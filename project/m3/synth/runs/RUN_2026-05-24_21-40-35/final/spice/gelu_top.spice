* NGSPICE file created from gelu_top.ext - technology: sky130A

* Black-box entry subcircuit for sky130_fd_sc_hd__decap_3 abstract view
.subckt sky130_fd_sc_hd__decap_3 VGND VNB VPB VPWR
.ends

* Black-box entry subcircuit for sky130_fd_sc_hd__and2b_1 abstract view
.subckt sky130_fd_sc_hd__and2b_1 A_N B VGND VNB VPB VPWR X
.ends

* Black-box entry subcircuit for sky130_fd_sc_hd__mux2_1 abstract view
.subckt sky130_fd_sc_hd__mux2_1 A0 A1 S VGND VNB VPB VPWR X
.ends

* Black-box entry subcircuit for sky130_fd_sc_hd__tapvpwrvgnd_1 abstract view
.subckt sky130_fd_sc_hd__tapvpwrvgnd_1 VGND VPWR
.ends

* Black-box entry subcircuit for sky130_fd_sc_hd__nand3_1 abstract view
.subckt sky130_fd_sc_hd__nand3_1 A B C VGND VNB VPB VPWR Y
.ends

* Black-box entry subcircuit for sky130_ef_sc_hd__decap_12 abstract view
.subckt sky130_ef_sc_hd__decap_12 VPWR VGND VPB VNB
.ends

* Black-box entry subcircuit for sky130_fd_sc_hd__fill_1 abstract view
.subckt sky130_fd_sc_hd__fill_1 VGND VNB VPB VPWR
.ends

* Black-box entry subcircuit for sky130_fd_sc_hd__xor2_1 abstract view
.subckt sky130_fd_sc_hd__xor2_1 A B VGND VNB VPB VPWR X
.ends

* Black-box entry subcircuit for sky130_fd_sc_hd__decap_4 abstract view
.subckt sky130_fd_sc_hd__decap_4 VGND VNB VPB VPWR
.ends

* Black-box entry subcircuit for sky130_fd_sc_hd__xnor2_1 abstract view
.subckt sky130_fd_sc_hd__xnor2_1 A B VGND VNB VPB VPWR Y
.ends

* Black-box entry subcircuit for sky130_fd_sc_hd__decap_6 abstract view
.subckt sky130_fd_sc_hd__decap_6 VGND VNB VPB VPWR
.ends

* Black-box entry subcircuit for sky130_fd_sc_hd__a21o_1 abstract view
.subckt sky130_fd_sc_hd__a21o_1 A1 A2 B1 VGND VNB VPB VPWR X
.ends

* Black-box entry subcircuit for sky130_fd_sc_hd__dlygate4sd3_1 abstract view
.subckt sky130_fd_sc_hd__dlygate4sd3_1 A VGND VNB VPB VPWR X
.ends

* Black-box entry subcircuit for sky130_fd_sc_hd__decap_8 abstract view
.subckt sky130_fd_sc_hd__decap_8 VGND VNB VPB VPWR
.ends

* Black-box entry subcircuit for sky130_fd_sc_hd__clkbuf_2 abstract view
.subckt sky130_fd_sc_hd__clkbuf_2 A VGND VNB VPB VPWR X
.ends

* Black-box entry subcircuit for sky130_fd_sc_hd__fill_2 abstract view
.subckt sky130_fd_sc_hd__fill_2 VGND VNB VPB VPWR
.ends

* Black-box entry subcircuit for sky130_fd_sc_hd__a211oi_2 abstract view
.subckt sky130_fd_sc_hd__a211oi_2 A1 A2 B1 C1 VGND VNB VPB VPWR Y
.ends

* Black-box entry subcircuit for sky130_fd_sc_hd__and2_1 abstract view
.subckt sky130_fd_sc_hd__and2_1 A B VGND VNB VPB VPWR X
.ends

* Black-box entry subcircuit for sky130_fd_sc_hd__a21bo_1 abstract view
.subckt sky130_fd_sc_hd__a21bo_1 A1 A2 B1_N VGND VNB VPB VPWR X
.ends

* Black-box entry subcircuit for sky130_fd_sc_hd__dfxtp_1 abstract view
.subckt sky130_fd_sc_hd__dfxtp_1 CLK D VGND VNB VPB VPWR Q
.ends

* Black-box entry subcircuit for sky130_fd_sc_hd__nor2_1 abstract view
.subckt sky130_fd_sc_hd__nor2_1 A B VGND VNB VPB VPWR Y
.ends

* Black-box entry subcircuit for sky130_fd_sc_hd__o211ai_1 abstract view
.subckt sky130_fd_sc_hd__o211ai_1 A1 A2 B1 C1 VGND VNB VPB VPWR Y
.ends

* Black-box entry subcircuit for sky130_fd_sc_hd__nand4_1 abstract view
.subckt sky130_fd_sc_hd__nand4_1 A B C D VGND VNB VPB VPWR Y
.ends

* Black-box entry subcircuit for sky130_fd_sc_hd__a21oi_1 abstract view
.subckt sky130_fd_sc_hd__a21oi_1 A1 A2 B1 VGND VNB VPB VPWR Y
.ends

* Black-box entry subcircuit for sky130_fd_sc_hd__xnor2_2 abstract view
.subckt sky130_fd_sc_hd__xnor2_2 A B VGND VNB VPB VPWR Y
.ends

* Black-box entry subcircuit for sky130_fd_sc_hd__a31o_1 abstract view
.subckt sky130_fd_sc_hd__a31o_1 A1 A2 A3 B1 VGND VNB VPB VPWR X
.ends

* Black-box entry subcircuit for sky130_fd_sc_hd__a221o_1 abstract view
.subckt sky130_fd_sc_hd__a221o_1 A1 A2 B1 B2 C1 VGND VNB VPB VPWR X
.ends

* Black-box entry subcircuit for sky130_fd_sc_hd__or2_1 abstract view
.subckt sky130_fd_sc_hd__or2_1 A B VGND VNB VPB VPWR X
.ends

* Black-box entry subcircuit for sky130_fd_sc_hd__mux4_1 abstract view
.subckt sky130_fd_sc_hd__mux4_1 A0 A1 A2 A3 S0 S1 VGND VNB VPB VPWR X
.ends

* Black-box entry subcircuit for sky130_fd_sc_hd__nand2_1 abstract view
.subckt sky130_fd_sc_hd__nand2_1 A B VGND VNB VPB VPWR Y
.ends

* Black-box entry subcircuit for sky130_fd_sc_hd__and3_1 abstract view
.subckt sky130_fd_sc_hd__and3_1 A B C VGND VNB VPB VPWR X
.ends

* Black-box entry subcircuit for sky130_fd_sc_hd__buf_2 abstract view
.subckt sky130_fd_sc_hd__buf_2 A VGND VNB VPB VPWR X
.ends

* Black-box entry subcircuit for sky130_fd_sc_hd__nand2b_1 abstract view
.subckt sky130_fd_sc_hd__nand2b_1 A_N B VGND VNB VPB VPWR Y
.ends

* Black-box entry subcircuit for sky130_fd_sc_hd__o211a_1 abstract view
.subckt sky130_fd_sc_hd__o211a_1 A1 A2 B1 C1 VGND VNB VPB VPWR X
.ends

* Black-box entry subcircuit for sky130_fd_sc_hd__xnor2_4 abstract view
.subckt sky130_fd_sc_hd__xnor2_4 A B VGND VNB VPB VPWR Y
.ends

* Black-box entry subcircuit for sky130_fd_sc_hd__o21a_1 abstract view
.subckt sky130_fd_sc_hd__o21a_1 A1 A2 B1 VGND VNB VPB VPWR X
.ends

* Black-box entry subcircuit for sky130_fd_sc_hd__o2bb2a_1 abstract view
.subckt sky130_fd_sc_hd__o2bb2a_1 A1_N A2_N B1 B2 VGND VNB VPB VPWR X
.ends

* Black-box entry subcircuit for sky130_fd_sc_hd__and4_1 abstract view
.subckt sky130_fd_sc_hd__and4_1 A B C D VGND VNB VPB VPWR X
.ends

* Black-box entry subcircuit for sky130_fd_sc_hd__o21ai_1 abstract view
.subckt sky130_fd_sc_hd__o21ai_1 A1 A2 B1 VGND VNB VPB VPWR Y
.ends

* Black-box entry subcircuit for sky130_fd_sc_hd__a211oi_1 abstract view
.subckt sky130_fd_sc_hd__a211oi_1 A1 A2 B1 C1 VGND VNB VPB VPWR Y
.ends

* Black-box entry subcircuit for sky130_fd_sc_hd__a22o_1 abstract view
.subckt sky130_fd_sc_hd__a22o_1 A1 A2 B1 B2 VGND VNB VPB VPWR X
.ends

* Black-box entry subcircuit for sky130_fd_sc_hd__dfxtp_2 abstract view
.subckt sky130_fd_sc_hd__dfxtp_2 CLK D VGND VNB VPB VPWR Q
.ends

* Black-box entry subcircuit for sky130_fd_sc_hd__or4_1 abstract view
.subckt sky130_fd_sc_hd__or4_1 A B C D VGND VNB VPB VPWR X
.ends

* Black-box entry subcircuit for sky130_fd_sc_hd__a31oi_1 abstract view
.subckt sky130_fd_sc_hd__a31oi_1 A1 A2 A3 B1 VGND VNB VPB VPWR Y
.ends

* Black-box entry subcircuit for sky130_fd_sc_hd__nor3b_1 abstract view
.subckt sky130_fd_sc_hd__nor3b_1 A B C_N VGND VNB VPB VPWR Y
.ends

* Black-box entry subcircuit for sky130_fd_sc_hd__or3_2 abstract view
.subckt sky130_fd_sc_hd__or3_2 A B C VGND VNB VPB VPWR X
.ends

* Black-box entry subcircuit for sky130_fd_sc_hd__nand3b_1 abstract view
.subckt sky130_fd_sc_hd__nand3b_1 A_N B C VGND VNB VPB VPWR Y
.ends

* Black-box entry subcircuit for sky130_fd_sc_hd__or3_1 abstract view
.subckt sky130_fd_sc_hd__or3_1 A B C VGND VNB VPB VPWR X
.ends

* Black-box entry subcircuit for sky130_fd_sc_hd__inv_2 abstract view
.subckt sky130_fd_sc_hd__inv_2 A VGND VNB VPB VPWR Y
.ends

* Black-box entry subcircuit for sky130_fd_sc_hd__diode_2 abstract view
.subckt sky130_fd_sc_hd__diode_2 DIODE VGND VNB VPB VPWR
.ends

* Black-box entry subcircuit for sky130_fd_sc_hd__a21oi_2 abstract view
.subckt sky130_fd_sc_hd__a21oi_2 A1 A2 B1 VGND VNB VPB VPWR Y
.ends

* Black-box entry subcircuit for sky130_fd_sc_hd__nand3b_2 abstract view
.subckt sky130_fd_sc_hd__nand3b_2 A_N B C VGND VNB VPB VPWR Y
.ends

* Black-box entry subcircuit for sky130_fd_sc_hd__o21ba_1 abstract view
.subckt sky130_fd_sc_hd__o21ba_1 A1 A2 B1_N VGND VNB VPB VPWR X
.ends

* Black-box entry subcircuit for sky130_fd_sc_hd__o211ai_2 abstract view
.subckt sky130_fd_sc_hd__o211ai_2 A1 A2 B1 C1 VGND VNB VPB VPWR Y
.ends

* Black-box entry subcircuit for sky130_fd_sc_hd__a211o_1 abstract view
.subckt sky130_fd_sc_hd__a211o_1 A1 A2 B1 C1 VGND VNB VPB VPWR X
.ends

* Black-box entry subcircuit for sky130_fd_sc_hd__clkbuf_16 abstract view
.subckt sky130_fd_sc_hd__clkbuf_16 A VGND VNB VPB VPWR X
.ends

* Black-box entry subcircuit for sky130_fd_sc_hd__o21bai_1 abstract view
.subckt sky130_fd_sc_hd__o21bai_1 A1 A2 B1_N VGND VNB VPB VPWR Y
.ends

* Black-box entry subcircuit for sky130_fd_sc_hd__nand3_4 abstract view
.subckt sky130_fd_sc_hd__nand3_4 A B C VGND VNB VPB VPWR Y
.ends

* Black-box entry subcircuit for sky130_fd_sc_hd__a21boi_1 abstract view
.subckt sky130_fd_sc_hd__a21boi_1 A1 A2 B1_N VGND VNB VPB VPWR Y
.ends

* Black-box entry subcircuit for sky130_fd_sc_hd__dlymetal6s2s_1 abstract view
.subckt sky130_fd_sc_hd__dlymetal6s2s_1 A VGND VNB VPB VPWR X
.ends

* Black-box entry subcircuit for sky130_fd_sc_hd__o22a_1 abstract view
.subckt sky130_fd_sc_hd__o22a_1 A1 A2 B1 B2 VGND VNB VPB VPWR X
.ends

* Black-box entry subcircuit for sky130_fd_sc_hd__and3b_1 abstract view
.subckt sky130_fd_sc_hd__and3b_1 A_N B C VGND VNB VPB VPWR X
.ends

* Black-box entry subcircuit for sky130_fd_sc_hd__a32o_1 abstract view
.subckt sky130_fd_sc_hd__a32o_1 A1 A2 A3 B1 B2 VGND VNB VPB VPWR X
.ends

* Black-box entry subcircuit for sky130_fd_sc_hd__nor3_2 abstract view
.subckt sky130_fd_sc_hd__nor3_2 A B C VGND VNB VPB VPWR Y
.ends

* Black-box entry subcircuit for sky130_fd_sc_hd__a2111o_1 abstract view
.subckt sky130_fd_sc_hd__a2111o_1 A1 A2 B1 C1 D1 VGND VNB VPB VPWR X
.ends

* Black-box entry subcircuit for sky130_fd_sc_hd__and2_2 abstract view
.subckt sky130_fd_sc_hd__and2_2 A B VGND VNB VPB VPWR X
.ends

* Black-box entry subcircuit for sky130_fd_sc_hd__clkbuf_8 abstract view
.subckt sky130_fd_sc_hd__clkbuf_8 A VGND VNB VPB VPWR X
.ends

* Black-box entry subcircuit for sky130_fd_sc_hd__clkinvlp_4 abstract view
.subckt sky130_fd_sc_hd__clkinvlp_4 A VGND VNB VPB VPWR Y
.ends

* Black-box entry subcircuit for sky130_fd_sc_hd__o41a_1 abstract view
.subckt sky130_fd_sc_hd__o41a_1 A1 A2 A3 A4 B1 VGND VNB VPB VPWR X
.ends

* Black-box entry subcircuit for sky130_fd_sc_hd__nand4_2 abstract view
.subckt sky130_fd_sc_hd__nand4_2 A B C D VGND VNB VPB VPWR Y
.ends

* Black-box entry subcircuit for sky130_fd_sc_hd__nor3_1 abstract view
.subckt sky130_fd_sc_hd__nor3_1 A B C VGND VNB VPB VPWR Y
.ends

* Black-box entry subcircuit for sky130_fd_sc_hd__a22oi_1 abstract view
.subckt sky130_fd_sc_hd__a22oi_1 A1 A2 B1 B2 VGND VNB VPB VPWR Y
.ends

* Black-box entry subcircuit for sky130_fd_sc_hd__nor2_2 abstract view
.subckt sky130_fd_sc_hd__nor2_2 A B VGND VNB VPB VPWR Y
.ends

* Black-box entry subcircuit for sky130_fd_sc_hd__nand3_2 abstract view
.subckt sky130_fd_sc_hd__nand3_2 A B C VGND VNB VPB VPWR Y
.ends

* Black-box entry subcircuit for sky130_fd_sc_hd__and4b_1 abstract view
.subckt sky130_fd_sc_hd__and4b_1 A_N B C D VGND VNB VPB VPWR X
.ends

* Black-box entry subcircuit for sky130_fd_sc_hd__clkbuf_4 abstract view
.subckt sky130_fd_sc_hd__clkbuf_4 A VGND VNB VPB VPWR X
.ends

* Black-box entry subcircuit for sky130_fd_sc_hd__o41ai_2 abstract view
.subckt sky130_fd_sc_hd__o41ai_2 A1 A2 A3 A4 B1 VGND VNB VPB VPWR Y
.ends

* Black-box entry subcircuit for sky130_fd_sc_hd__xor2_2 abstract view
.subckt sky130_fd_sc_hd__xor2_2 A B VGND VNB VPB VPWR X
.ends

* Black-box entry subcircuit for sky130_fd_sc_hd__nand4_4 abstract view
.subckt sky130_fd_sc_hd__nand4_4 A B C D VGND VNB VPB VPWR Y
.ends

* Black-box entry subcircuit for sky130_fd_sc_hd__nand2_2 abstract view
.subckt sky130_fd_sc_hd__nand2_2 A B VGND VNB VPB VPWR Y
.ends

* Black-box entry subcircuit for sky130_fd_sc_hd__and4bb_1 abstract view
.subckt sky130_fd_sc_hd__and4bb_1 A_N B_N C D VGND VNB VPB VPWR X
.ends

* Black-box entry subcircuit for sky130_fd_sc_hd__clkinv_8 abstract view
.subckt sky130_fd_sc_hd__clkinv_8 A VGND VNB VPB VPWR Y
.ends

* Black-box entry subcircuit for sky130_fd_sc_hd__o2111a_1 abstract view
.subckt sky130_fd_sc_hd__o2111a_1 A1 A2 B1 C1 D1 VGND VNB VPB VPWR X
.ends

* Black-box entry subcircuit for sky130_fd_sc_hd__or2_2 abstract view
.subckt sky130_fd_sc_hd__or2_2 A B VGND VNB VPB VPWR X
.ends

* Black-box entry subcircuit for sky130_fd_sc_hd__clkbuf_1 abstract view
.subckt sky130_fd_sc_hd__clkbuf_1 A VGND VNB VPB VPWR X
.ends

* Black-box entry subcircuit for sky130_fd_sc_hd__a22oi_2 abstract view
.subckt sky130_fd_sc_hd__a22oi_2 A1 A2 B1 B2 VGND VNB VPB VPWR Y
.ends

* Black-box entry subcircuit for sky130_fd_sc_hd__a31oi_2 abstract view
.subckt sky130_fd_sc_hd__a31oi_2 A1 A2 A3 B1 VGND VNB VPB VPWR Y
.ends

* Black-box entry subcircuit for sky130_fd_sc_hd__a2bb2o_1 abstract view
.subckt sky130_fd_sc_hd__a2bb2o_1 A1_N A2_N B1 B2 VGND VNB VPB VPWR X
.ends

* Black-box entry subcircuit for sky130_fd_sc_hd__inv_6 abstract view
.subckt sky130_fd_sc_hd__inv_6 A VGND VNB VPB VPWR Y
.ends

* Black-box entry subcircuit for sky130_fd_sc_hd__inv_8 abstract view
.subckt sky130_fd_sc_hd__inv_8 A VGND VNB VPB VPWR Y
.ends

* Black-box entry subcircuit for sky130_fd_sc_hd__o32a_1 abstract view
.subckt sky130_fd_sc_hd__o32a_1 A1 A2 A3 B1 B2 VGND VNB VPB VPWR X
.ends

* Black-box entry subcircuit for sky130_fd_sc_hd__or3b_1 abstract view
.subckt sky130_fd_sc_hd__or3b_1 A B C_N VGND VNB VPB VPWR X
.ends

* Black-box entry subcircuit for sky130_fd_sc_hd__nor4_1 abstract view
.subckt sky130_fd_sc_hd__nor4_1 A B C D VGND VNB VPB VPWR Y
.ends

* Black-box entry subcircuit for sky130_fd_sc_hd__buf_1 abstract view
.subckt sky130_fd_sc_hd__buf_1 A VGND VNB VPB VPWR X
.ends

* Black-box entry subcircuit for sky130_fd_sc_hd__inv_16 abstract view
.subckt sky130_fd_sc_hd__inv_16 A VGND VNB VPB VPWR Y
.ends

* Black-box entry subcircuit for sky130_fd_sc_hd__or4b_1 abstract view
.subckt sky130_fd_sc_hd__or4b_1 A B C D_N VGND VNB VPB VPWR X
.ends

* Black-box entry subcircuit for sky130_fd_sc_hd__o2bb2ai_1 abstract view
.subckt sky130_fd_sc_hd__o2bb2ai_1 A1_N A2_N B1 B2 VGND VNB VPB VPWR Y
.ends

* Black-box entry subcircuit for sky130_fd_sc_hd__or4_2 abstract view
.subckt sky130_fd_sc_hd__or4_2 A B C D VGND VNB VPB VPWR X
.ends

* Black-box entry subcircuit for sky130_fd_sc_hd__clkinv_4 abstract view
.subckt sky130_fd_sc_hd__clkinv_4 A VGND VNB VPB VPWR Y
.ends

* Black-box entry subcircuit for sky130_fd_sc_hd__clkinv_2 abstract view
.subckt sky130_fd_sc_hd__clkinv_2 A VGND VNB VPB VPWR Y
.ends

* Black-box entry subcircuit for sky130_fd_sc_hd__inv_12 abstract view
.subckt sky130_fd_sc_hd__inv_12 A VGND VNB VPB VPWR Y
.ends

* Black-box entry subcircuit for sky130_fd_sc_hd__buf_4 abstract view
.subckt sky130_fd_sc_hd__buf_4 A VGND VNB VPB VPWR X
.ends

* Black-box entry subcircuit for sky130_fd_sc_hd__a31oi_4 abstract view
.subckt sky130_fd_sc_hd__a31oi_4 A1 A2 A3 B1 VGND VNB VPB VPWR Y
.ends

* Black-box entry subcircuit for sky130_fd_sc_hd__or4bb_1 abstract view
.subckt sky130_fd_sc_hd__or4bb_1 A B C_N D_N VGND VNB VPB VPWR X
.ends

* Black-box entry subcircuit for sky130_fd_sc_hd__o21ai_2 abstract view
.subckt sky130_fd_sc_hd__o21ai_2 A1 A2 B1 VGND VNB VPB VPWR Y
.ends

* Black-box entry subcircuit for sky130_fd_sc_hd__and4_2 abstract view
.subckt sky130_fd_sc_hd__and4_2 A B C D VGND VNB VPB VPWR X
.ends

* Black-box entry subcircuit for sky130_fd_sc_hd__o21bai_2 abstract view
.subckt sky130_fd_sc_hd__o21bai_2 A1 A2 B1_N VGND VNB VPB VPWR Y
.ends

* Black-box entry subcircuit for sky130_fd_sc_hd__o31a_1 abstract view
.subckt sky130_fd_sc_hd__o31a_1 A1 A2 A3 B1 VGND VNB VPB VPWR X
.ends

* Black-box entry subcircuit for sky130_fd_sc_hd__a21boi_2 abstract view
.subckt sky130_fd_sc_hd__a21boi_2 A1 A2 B1_N VGND VNB VPB VPWR Y
.ends

* Black-box entry subcircuit for sky130_fd_sc_hd__nand2b_2 abstract view
.subckt sky130_fd_sc_hd__nand2b_2 A_N B VGND VNB VPB VPWR Y
.ends

* Black-box entry subcircuit for sky130_fd_sc_hd__nand2_4 abstract view
.subckt sky130_fd_sc_hd__nand2_4 A B VGND VNB VPB VPWR Y
.ends

* Black-box entry subcircuit for sky130_fd_sc_hd__bufinv_16 abstract view
.subckt sky130_fd_sc_hd__bufinv_16 A VGND VNB VPB VPWR Y
.ends

* Black-box entry subcircuit for sky130_fd_sc_hd__a32oi_4 abstract view
.subckt sky130_fd_sc_hd__a32oi_4 A1 A2 A3 B1 B2 VGND VNB VPB VPWR Y
.ends

* Black-box entry subcircuit for sky130_fd_sc_hd__o211ai_4 abstract view
.subckt sky130_fd_sc_hd__o211ai_4 A1 A2 B1 C1 VGND VNB VPB VPWR Y
.ends

* Black-box entry subcircuit for sky130_fd_sc_hd__o221a_1 abstract view
.subckt sky130_fd_sc_hd__o221a_1 A1 A2 B1 B2 C1 VGND VNB VPB VPWR X
.ends

* Black-box entry subcircuit for sky130_fd_sc_hd__a21o_2 abstract view
.subckt sky130_fd_sc_hd__a21o_2 A1 A2 B1 VGND VNB VPB VPWR X
.ends

* Black-box entry subcircuit for sky130_fd_sc_hd__o311a_1 abstract view
.subckt sky130_fd_sc_hd__o311a_1 A1 A2 A3 B1 C1 VGND VNB VPB VPWR X
.ends

* Black-box entry subcircuit for sky130_fd_sc_hd__o31ai_1 abstract view
.subckt sky130_fd_sc_hd__o31ai_1 A1 A2 A3 B1 VGND VNB VPB VPWR Y
.ends

* Black-box entry subcircuit for sky130_fd_sc_hd__nand4b_2 abstract view
.subckt sky130_fd_sc_hd__nand4b_2 A_N B C D VGND VNB VPB VPWR Y
.ends

* Black-box entry subcircuit for sky130_fd_sc_hd__or4_4 abstract view
.subckt sky130_fd_sc_hd__or4_4 A B C D VGND VNB VPB VPWR X
.ends

* Black-box entry subcircuit for sky130_fd_sc_hd__a211oi_4 abstract view
.subckt sky130_fd_sc_hd__a211oi_4 A1 A2 B1 C1 VGND VNB VPB VPWR Y
.ends

* Black-box entry subcircuit for sky130_fd_sc_hd__or3b_2 abstract view
.subckt sky130_fd_sc_hd__or3b_2 A B C_N VGND VNB VPB VPWR X
.ends

* Black-box entry subcircuit for sky130_fd_sc_hd__or4bb_4 abstract view
.subckt sky130_fd_sc_hd__or4bb_4 A B C_N D_N VGND VNB VPB VPWR X
.ends

* Black-box entry subcircuit for sky130_fd_sc_hd__a41o_1 abstract view
.subckt sky130_fd_sc_hd__a41o_1 A1 A2 A3 A4 B1 VGND VNB VPB VPWR X
.ends

* Black-box entry subcircuit for sky130_fd_sc_hd__and3_2 abstract view
.subckt sky130_fd_sc_hd__and3_2 A B C VGND VNB VPB VPWR X
.ends

* Black-box entry subcircuit for sky130_fd_sc_hd__and3_4 abstract view
.subckt sky130_fd_sc_hd__and3_4 A B C VGND VNB VPB VPWR X
.ends

* Black-box entry subcircuit for sky130_fd_sc_hd__a221oi_4 abstract view
.subckt sky130_fd_sc_hd__a221oi_4 A1 A2 B1 B2 C1 VGND VNB VPB VPWR Y
.ends

* Black-box entry subcircuit for sky130_fd_sc_hd__o21ai_4 abstract view
.subckt sky130_fd_sc_hd__o21ai_4 A1 A2 B1 VGND VNB VPB VPWR Y
.ends

* Black-box entry subcircuit for sky130_fd_sc_hd__nand4b_1 abstract view
.subckt sky130_fd_sc_hd__nand4b_1 A_N B C D VGND VNB VPB VPWR Y
.ends

* Black-box entry subcircuit for sky130_fd_sc_hd__conb_1 abstract view
.subckt sky130_fd_sc_hd__conb_1 VGND VNB VPB VPWR HI LO
.ends

* Black-box entry subcircuit for sky130_fd_sc_hd__a2bb2oi_1 abstract view
.subckt sky130_fd_sc_hd__a2bb2oi_1 A1_N A2_N B1 B2 VGND VNB VPB VPWR Y
.ends

* Black-box entry subcircuit for sky130_fd_sc_hd__or4b_4 abstract view
.subckt sky130_fd_sc_hd__or4b_4 A B C D_N VGND VNB VPB VPWR X
.ends

* Black-box entry subcircuit for sky130_fd_sc_hd__o2111ai_1 abstract view
.subckt sky130_fd_sc_hd__o2111ai_1 A1 A2 B1 C1 D1 VGND VNB VPB VPWR Y
.ends

* Black-box entry subcircuit for sky130_fd_sc_hd__o31ai_2 abstract view
.subckt sky130_fd_sc_hd__o31ai_2 A1 A2 A3 B1 VGND VNB VPB VPWR Y
.ends

* Black-box entry subcircuit for sky130_fd_sc_hd__a31o_2 abstract view
.subckt sky130_fd_sc_hd__a31o_2 A1 A2 A3 B1 VGND VNB VPB VPWR X
.ends

* Black-box entry subcircuit for sky130_fd_sc_hd__or4bb_2 abstract view
.subckt sky130_fd_sc_hd__or4bb_2 A B C_N D_N VGND VNB VPB VPWR X
.ends

* Black-box entry subcircuit for sky130_fd_sc_hd__or4b_2 abstract view
.subckt sky130_fd_sc_hd__or4b_2 A B C D_N VGND VNB VPB VPWR X
.ends

.subckt gelu_top VGND VPWR clk m_axis_tdata[0] m_axis_tdata[10] m_axis_tdata[11] m_axis_tdata[12]
+ m_axis_tdata[13] m_axis_tdata[14] m_axis_tdata[15] m_axis_tdata[16] m_axis_tdata[17]
+ m_axis_tdata[18] m_axis_tdata[19] m_axis_tdata[1] m_axis_tdata[20] m_axis_tdata[21]
+ m_axis_tdata[22] m_axis_tdata[23] m_axis_tdata[24] m_axis_tdata[25] m_axis_tdata[26]
+ m_axis_tdata[27] m_axis_tdata[28] m_axis_tdata[29] m_axis_tdata[2] m_axis_tdata[30]
+ m_axis_tdata[31] m_axis_tdata[3] m_axis_tdata[4] m_axis_tdata[5] m_axis_tdata[6]
+ m_axis_tdata[7] m_axis_tdata[8] m_axis_tdata[9] m_axis_tlast m_axis_tready m_axis_tuser
+ m_axis_tvalid rst s_axil_araddr[0] s_axil_araddr[10] s_axil_araddr[11] s_axil_araddr[12]
+ s_axil_araddr[13] s_axil_araddr[14] s_axil_araddr[15] s_axil_araddr[16] s_axil_araddr[17]
+ s_axil_araddr[18] s_axil_araddr[19] s_axil_araddr[1] s_axil_araddr[20] s_axil_araddr[21]
+ s_axil_araddr[22] s_axil_araddr[23] s_axil_araddr[24] s_axil_araddr[25] s_axil_araddr[26]
+ s_axil_araddr[27] s_axil_araddr[28] s_axil_araddr[29] s_axil_araddr[2] s_axil_araddr[30]
+ s_axil_araddr[31] s_axil_araddr[3] s_axil_araddr[4] s_axil_araddr[5] s_axil_araddr[6]
+ s_axil_araddr[7] s_axil_araddr[8] s_axil_araddr[9] s_axil_arready s_axil_arvalid
+ s_axil_awaddr[0] s_axil_awaddr[10] s_axil_awaddr[11] s_axil_awaddr[12] s_axil_awaddr[13]
+ s_axil_awaddr[14] s_axil_awaddr[15] s_axil_awaddr[16] s_axil_awaddr[17] s_axil_awaddr[18]
+ s_axil_awaddr[19] s_axil_awaddr[1] s_axil_awaddr[20] s_axil_awaddr[21] s_axil_awaddr[22]
+ s_axil_awaddr[23] s_axil_awaddr[24] s_axil_awaddr[25] s_axil_awaddr[26] s_axil_awaddr[27]
+ s_axil_awaddr[28] s_axil_awaddr[29] s_axil_awaddr[2] s_axil_awaddr[30] s_axil_awaddr[31]
+ s_axil_awaddr[3] s_axil_awaddr[4] s_axil_awaddr[5] s_axil_awaddr[6] s_axil_awaddr[7]
+ s_axil_awaddr[8] s_axil_awaddr[9] s_axil_awready s_axil_awvalid s_axil_bready s_axil_bresp[0]
+ s_axil_bresp[1] s_axil_bvalid s_axil_rdata[0] s_axil_rdata[10] s_axil_rdata[11]
+ s_axil_rdata[12] s_axil_rdata[13] s_axil_rdata[14] s_axil_rdata[15] s_axil_rdata[16]
+ s_axil_rdata[17] s_axil_rdata[18] s_axil_rdata[19] s_axil_rdata[1] s_axil_rdata[20]
+ s_axil_rdata[21] s_axil_rdata[22] s_axil_rdata[23] s_axil_rdata[24] s_axil_rdata[25]
+ s_axil_rdata[26] s_axil_rdata[27] s_axil_rdata[28] s_axil_rdata[29] s_axil_rdata[2]
+ s_axil_rdata[30] s_axil_rdata[31] s_axil_rdata[3] s_axil_rdata[4] s_axil_rdata[5]
+ s_axil_rdata[6] s_axil_rdata[7] s_axil_rdata[8] s_axil_rdata[9] s_axil_rready s_axil_rresp[0]
+ s_axil_rresp[1] s_axil_rvalid s_axil_wdata[0] s_axil_wdata[10] s_axil_wdata[11]
+ s_axil_wdata[12] s_axil_wdata[13] s_axil_wdata[14] s_axil_wdata[15] s_axil_wdata[16]
+ s_axil_wdata[17] s_axil_wdata[18] s_axil_wdata[19] s_axil_wdata[1] s_axil_wdata[20]
+ s_axil_wdata[21] s_axil_wdata[22] s_axil_wdata[23] s_axil_wdata[24] s_axil_wdata[25]
+ s_axil_wdata[26] s_axil_wdata[27] s_axil_wdata[28] s_axil_wdata[29] s_axil_wdata[2]
+ s_axil_wdata[30] s_axil_wdata[31] s_axil_wdata[3] s_axil_wdata[4] s_axil_wdata[5]
+ s_axil_wdata[6] s_axil_wdata[7] s_axil_wdata[8] s_axil_wdata[9] s_axil_wready s_axil_wstrb[0]
+ s_axil_wstrb[1] s_axil_wstrb[2] s_axil_wstrb[3] s_axil_wvalid s_axis_tdata[0] s_axis_tdata[10]
+ s_axis_tdata[11] s_axis_tdata[12] s_axis_tdata[13] s_axis_tdata[14] s_axis_tdata[15]
+ s_axis_tdata[16] s_axis_tdata[17] s_axis_tdata[18] s_axis_tdata[19] s_axis_tdata[1]
+ s_axis_tdata[20] s_axis_tdata[21] s_axis_tdata[22] s_axis_tdata[23] s_axis_tdata[24]
+ s_axis_tdata[25] s_axis_tdata[26] s_axis_tdata[27] s_axis_tdata[28] s_axis_tdata[29]
+ s_axis_tdata[2] s_axis_tdata[30] s_axis_tdata[31] s_axis_tdata[3] s_axis_tdata[4]
+ s_axis_tdata[5] s_axis_tdata[6] s_axis_tdata[7] s_axis_tdata[8] s_axis_tdata[9]
+ s_axis_tlast s_axis_tready s_axis_tuser s_axis_tvalid
XFILLER_39_233 VGND VGND VPWR VPWR sky130_fd_sc_hd__decap_3
X_09671_ _03424_ _03425_ VGND VGND VPWR VPWR _03426_ sky130_fd_sc_hd__and2b_1
X_06883_ _01425_ _01426_ net730 VGND VGND VPWR VPWR _01427_ sky130_fd_sc_hd__mux2_1
XTAP_TAPCELL_ROW_124_2322 VGND VPWR sky130_fd_sc_hd__tapvpwrvgnd_1
X_08622_ _02241_ net157 _02396_ VGND VGND VPWR VPWR _02397_ sky130_fd_sc_hd__nand3_1
XFILLER_54_214 VPWR VGND VPWR VGND sky130_ef_sc_hd__decap_12
XTAP_TAPCELL_ROW_38_946 VGND VPWR sky130_fd_sc_hd__tapvpwrvgnd_1
XFILLER_39_288 VPWR VGND VPWR VGND sky130_ef_sc_hd__decap_12
XFILLER_54_269 VGND VGND VPWR VPWR sky130_fd_sc_hd__fill_1
X_08553_ _02294_ _02330_ VGND VGND VPWR VPWR _02344_ sky130_fd_sc_hd__xor2_1
X_07504_ _01631_ _01635_ net309 VGND VGND VPWR VPWR _01636_ sky130_fd_sc_hd__mux2_1
XFILLER_82_589 VGND VGND VPWR VPWR sky130_fd_sc_hd__decap_4
XFILLER_23_612 VGND VGND VPWR VPWR sky130_fd_sc_hd__decap_4
X_08484_ net522 u_interface.u_gelu_fp32.u_synth_top.s3_mult\[45\] VGND VGND VPWR VPWR
+ _02275_ sky130_fd_sc_hd__xnor2_1
X_07435_ u_interface.u_gelu_fp32.u_fp32_to_q16.s2_norm_mag\[17\] u_interface.u_gelu_fp32.u_fp32_to_q16.s2_norm_mag\[18\]
+ net558 VGND VGND VPWR VPWR _01570_ sky130_fd_sc_hd__mux2_1
XFILLER_52_29 VGND VGND VPWR VPWR sky130_fd_sc_hd__fill_1
XFILLER_22_133 VGND VGND VPWR VPWR sky130_fd_sc_hd__decap_6
XTAP_TAPCELL_ROW_102_1974 VGND VPWR sky130_fd_sc_hd__tapvpwrvgnd_1
XTAP_TAPCELL_ROW_102_1963 VGND VPWR sky130_fd_sc_hd__tapvpwrvgnd_1
X_07366_ net562 net1499 net241 VGND VGND VPWR VPWR _00396_ sky130_fd_sc_hd__mux2_1
XFILLER_22_177 VGND VGND VPWR VPWR sky130_fd_sc_hd__fill_1
XFILLER_149_897 VGND VGND VPWR VPWR sky130_fd_sc_hd__decap_4
X_09105_ _02737_ _02750_ _02749_ VGND VGND VPWR VPWR _02864_ sky130_fd_sc_hd__a21o_1
X_07297_ net1286 net572 net248 VGND VGND VPWR VPWR _00327_ sky130_fd_sc_hd__mux2_1
X_09036_ _02791_ _02793_ _02794_ VGND VGND VPWR VPWR _02795_ sky130_fd_sc_hd__nand3_1
XFILLER_108_238 VGND VGND VPWR VPWR sky130_fd_sc_hd__decap_4
XTAP_TAPCELL_ROW_135_2495 VGND VPWR sky130_fd_sc_hd__tapvpwrvgnd_1
Xhold362 u_interface.fifo_data\[15\]\[22\] VGND VGND VPWR VPWR net1227 sky130_fd_sc_hd__dlygate4sd3_1
XFILLER_117_794 VGND VGND VPWR VPWR sky130_fd_sc_hd__decap_3
XFILLER_117_783 VGND VGND VPWR VPWR sky130_fd_sc_hd__fill_1
Xhold340 u_interface.fifo_data\[10\]\[1\] VGND VGND VPWR VPWR net1205 sky130_fd_sc_hd__dlygate4sd3_1
Xhold351 u_interface.fifo_data\[14\]\[27\] VGND VGND VPWR VPWR net1216 sky130_fd_sc_hd__dlygate4sd3_1
Xhold384 u_interface.fifo_data\[5\]\[1\] VGND VGND VPWR VPWR net1249 sky130_fd_sc_hd__dlygate4sd3_1
Xhold373 u_interface.fifo_data\[4\]\[4\] VGND VGND VPWR VPWR net1238 sky130_fd_sc_hd__dlygate4sd3_1
XFILLER_77_15 VGND VGND VPWR VPWR sky130_fd_sc_hd__decap_8
Xhold395 u_interface.fifo_data\[6\]\[8\] VGND VGND VPWR VPWR net1260 sky130_fd_sc_hd__dlygate4sd3_1
Xfanout820 net821 VGND VGND VPWR VPWR net820 sky130_fd_sc_hd__clkbuf_2
XFILLER_104_477 VGND VGND VPWR VPWR sky130_fd_sc_hd__decap_4
X_09938_ _03689_ _03690_ VGND VGND VPWR VPWR _03691_ sky130_fd_sc_hd__and2b_1
XFILLER_78_829 VGND VGND VPWR VPWR sky130_fd_sc_hd__decap_6
XFILLER_133_54 VGND VGND VPWR VPWR sky130_fd_sc_hd__fill_2
X_09869_ _03505_ _03508_ _03620_ _03621_ VGND VGND VPWR VPWR _03623_ sky130_fd_sc_hd__a211oi_2
XFILLER_92_309 VGND VGND VPWR VPWR sky130_fd_sc_hd__decap_8
XFILLER_85_350 VPWR VGND VPWR VGND sky130_ef_sc_hd__decap_12
XFILLER_46_704 VGND VGND VPWR VPWR sky130_fd_sc_hd__fill_1
X_12880_ net787 net1427 VGND VGND VPWR VPWR _01022_ sky130_fd_sc_hd__and2_1
XFILLER_133_87 VGND VGND VPWR VPWR sky130_fd_sc_hd__decap_6
XFILLER_73_545 VPWR VGND VPWR VGND sky130_ef_sc_hd__decap_12
XFILLER_45_225 VGND VGND VPWR VPWR sky130_fd_sc_hd__decap_4
X_11900_ _05633_ _05634_ VGND VGND VPWR VPWR _05635_ sky130_fd_sc_hd__xor2_1
XFILLER_45_258 VPWR VGND VPWR VGND sky130_ef_sc_hd__decap_12
XFILLER_26_41 VPWR VGND VPWR VGND sky130_ef_sc_hd__decap_12
X_11831_ net184 _05491_ _05490_ VGND VGND VPWR VPWR _05566_ sky130_fd_sc_hd__a21bo_1
XFILLER_61_729 VGND VGND VPWR VPWR sky130_fd_sc_hd__decap_3
XFILLER_14_601 VPWR VGND VPWR VGND sky130_ef_sc_hd__decap_12
X_13501_ clknet_leaf_4_clk _00511_ VGND VGND VPWR VPWR u_interface.u_gelu_fp32.u_synth_top.s2_m\[10\]
+ sky130_fd_sc_hd__dfxtp_1
XFILLER_13_111 VGND VGND VPWR VPWR sky130_fd_sc_hd__fill_1
XFILLER_14_645 VPWR VGND VPWR VGND sky130_ef_sc_hd__decap_12
XFILLER_26_85 VPWR VGND VPWR VGND sky130_ef_sc_hd__decap_12
X_11762_ net199 _05496_ VGND VGND VPWR VPWR _05498_ sky130_fd_sc_hd__nor2_1
XTAP_TAPCELL_ROW_155_2816 VGND VPWR sky130_fd_sc_hd__tapvpwrvgnd_1
X_10713_ _04456_ _04457_ _04335_ _04337_ VGND VGND VPWR VPWR _04459_ sky130_fd_sc_hd__o211ai_1
X_11693_ net685 net693 net415 net410 VGND VGND VPWR VPWR _05430_ sky130_fd_sc_hd__nand4_1
XFILLER_41_453 VPWR VGND VPWR VGND sky130_ef_sc_hd__decap_12
XTAP_TAPCELL_ROW_155_2838 VGND VPWR sky130_fd_sc_hd__tapvpwrvgnd_1
XTAP_TAPCELL_ROW_155_2827 VGND VPWR sky130_fd_sc_hd__tapvpwrvgnd_1
X_13432_ clknet_leaf_18_clk _00442_ VGND VGND VPWR VPWR u_interface.u_gelu_fp32.u_fp32_to_q16.s3_mag\[3\]
+ sky130_fd_sc_hd__dfxtp_1
X_10644_ _04389_ _04390_ _04373_ VGND VGND VPWR VPWR _04391_ sky130_fd_sc_hd__a21o_1
XFILLER_9_137 VPWR VGND VPWR VGND sky130_ef_sc_hd__decap_12
XFILLER_154_300 VGND VGND VPWR VPWR sky130_fd_sc_hd__decap_8
X_10575_ _04226_ _04235_ _04236_ VGND VGND VPWR VPWR _04322_ sky130_fd_sc_hd__a21o_1
X_13363_ clknet_leaf_70_clk _00373_ VGND VGND VPWR VPWR u_interface.fifo_data\[7\]\[8\]
+ sky130_fd_sc_hd__dfxtp_1
XFILLER_6_811 VGND VGND VPWR VPWR sky130_fd_sc_hd__fill_1
X_12314_ _05948_ _05979_ _05978_ VGND VGND VPWR VPWR _06043_ sky130_fd_sc_hd__a21oi_1
XFILLER_5_332 VGND VGND VPWR VPWR sky130_fd_sc_hd__fill_1
X_13294_ clknet_leaf_74_clk _00304_ VGND VGND VPWR VPWR u_interface.fifo_data\[8\]\[3\]
+ sky130_fd_sc_hd__dfxtp_1
XTAP_TAPCELL_ROW_75_1542 VGND VPWR sky130_fd_sc_hd__tapvpwrvgnd_1
XTAP_TAPCELL_ROW_75_1531 VGND VPWR sky130_fd_sc_hd__tapvpwrvgnd_1
X_12245_ _05972_ _05973_ VGND VGND VPWR VPWR _05975_ sky130_fd_sc_hd__xnor2_1
XFILLER_122_230 VGND VGND VPWR VPWR sky130_fd_sc_hd__decap_4
XFILLER_107_293 VPWR VGND VPWR VGND sky130_ef_sc_hd__decap_12
X_12176_ _05822_ _05840_ _05839_ VGND VGND VPWR VPWR _05907_ sky130_fd_sc_hd__a21oi_1
XFILLER_96_637 VGND VGND VPWR VPWR sky130_fd_sc_hd__decap_6
X_11127_ net586 net387 VGND VGND VPWR VPWR _04870_ sky130_fd_sc_hd__and2b_1
XFILLER_122_285 VGND VGND VPWR VPWR sky130_fd_sc_hd__fill_2
XFILLER_49_542 VGND VGND VPWR VPWR sky130_fd_sc_hd__decap_6
XFILLER_49_520 VGND VGND VPWR VPWR sky130_fd_sc_hd__fill_1
XFILLER_110_469 VGND VGND VPWR VPWR sky130_fd_sc_hd__fill_1
XFILLER_95_169 VGND VGND VPWR VPWR sky130_fd_sc_hd__fill_2
XFILLER_92_810 VGND VGND VPWR VPWR sky130_fd_sc_hd__fill_2
XFILLER_83_309 VGND VGND VPWR VPWR sky130_fd_sc_hd__fill_1
XFILLER_67_81 VPWR VGND VPWR VGND sky130_ef_sc_hd__decap_12
X_11058_ _04796_ _04800_ VGND VGND VPWR VPWR _04801_ sky130_fd_sc_hd__xnor2_2
XTAP_TAPCELL_ROW_106_2030 VGND VPWR sky130_fd_sc_hd__tapvpwrvgnd_1
X_10009_ net483 net698 _03690_ _03689_ VGND VGND VPWR VPWR _03761_ sky130_fd_sc_hd__a31o_1
XFILLER_36_214 VGND VGND VPWR VPWR sky130_fd_sc_hd__decap_8
XFILLER_92_887 VGND VGND VPWR VPWR sky130_fd_sc_hd__decap_3
XFILLER_92_865 VGND VGND VPWR VPWR sky130_fd_sc_hd__decap_3
XFILLER_36_258 VPWR VGND VPWR VGND sky130_ef_sc_hd__decap_12
XFILLER_92_898 VGND VGND VPWR VPWR sky130_fd_sc_hd__decap_4
XFILLER_83_80 VGND VGND VPWR VPWR sky130_fd_sc_hd__fill_2
XFILLER_51_206 VGND VGND VPWR VPWR sky130_fd_sc_hd__fill_2
XFILLER_17_483 VGND VGND VPWR VPWR sky130_fd_sc_hd__decap_3
XFILLER_32_442 VGND VGND VPWR VPWR sky130_fd_sc_hd__fill_1
XFILLER_32_475 VGND VGND VPWR VPWR sky130_fd_sc_hd__fill_1
X_07220_ net567 net1450 net260 VGND VGND VPWR VPWR _00260_ sky130_fd_sc_hd__mux2_1
XPHY_EDGE_ROW_17_Left_173 VGND VGND VPWR VPWR sky130_fd_sc_hd__decap_3
XFILLER_20_637 VGND VGND VPWR VPWR sky130_fd_sc_hd__decap_6
X_07151_ net1152 net577 net219 VGND VGND VPWR VPWR _00191_ sky130_fd_sc_hd__mux2_1
XFILLER_9_671 VGND VGND VPWR VPWR sky130_fd_sc_hd__fill_1
XFILLER_118_569 VGND VGND VPWR VPWR sky130_fd_sc_hd__decap_3
X_07082_ net1370 net382 net228 VGND VGND VPWR VPWR _00122_ sky130_fd_sc_hd__mux2_1
XFILLER_145_399 VGND VGND VPWR VPWR sky130_fd_sc_hd__decap_4
XFILLER_114_720 VGND VGND VPWR VPWR sky130_fd_sc_hd__decap_4
XFILLER_105_219 VGND VGND VPWR VPWR sky130_fd_sc_hd__decap_4
XFILLER_141_561 VGND VGND VPWR VPWR sky130_fd_sc_hd__fill_1
XFILLER_99_475 VPWR VGND VPWR VGND sky130_ef_sc_hd__decap_12
XPHY_EDGE_ROW_26_Left_182 VGND VGND VPWR VPWR sky130_fd_sc_hd__decap_3
X_07984_ net543 _01689_ net279 _01656_ net815 VGND VGND VPWR VPWR _01854_ sky130_fd_sc_hd__a221o_1
XFILLER_87_659 VPWR VGND VPWR VGND sky130_ef_sc_hd__decap_12
XFILLER_86_136 VGND VGND VPWR VPWR sky130_fd_sc_hd__decap_4
X_09723_ net216 _03477_ VGND VGND VPWR VPWR _03478_ sky130_fd_sc_hd__xnor2_1
XFILLER_86_158 VGND VGND VPWR VPWR sky130_fd_sc_hd__fill_2
X_06935_ _01465_ _01466_ VGND VGND VPWR VPWR _01469_ sky130_fd_sc_hd__or2_1
XFILLER_74_309 VGND VGND VPWR VPWR sky130_fd_sc_hd__decap_4
X_06866_ u_interface.fifo_data\[4\]\[29\] u_interface.fifo_data\[5\]\[29\] u_interface.fifo_data\[6\]\[29\]
+ u_interface.fifo_data\[7\]\[29\] net766 net749 VGND VGND VPWR VPWR _01412_ sky130_fd_sc_hd__mux4_1
X_09654_ _03266_ _03268_ _03407_ _03408_ VGND VGND VPWR VPWR _03410_ sky130_fd_sc_hd__a211oi_2
XFILLER_27_225 VGND VGND VPWR VPWR sky130_fd_sc_hd__fill_2
XFILLER_28_737 VPWR VGND VPWR VGND sky130_ef_sc_hd__decap_12
X_08605_ _02231_ _02384_ VGND VGND VPWR VPWR _02385_ sky130_fd_sc_hd__xnor2_1
XTAP_TAPCELL_ROW_2_368 VGND VPWR sky130_fd_sc_hd__tapvpwrvgnd_1
X_09585_ _03337_ _03338_ _03339_ VGND VGND VPWR VPWR _03341_ sky130_fd_sc_hd__a21o_1
XFILLER_70_515 VPWR VGND VPWR VGND sky130_ef_sc_hd__decap_12
X_06797_ u_interface.fifo_data\[8\]\[21\] u_interface.fifo_data\[9\]\[21\] u_interface.fifo_data\[10\]\[21\]
+ u_interface.fifo_data\[11\]\[21\] net755 net738 VGND VGND VPWR VPWR _01351_ sky130_fd_sc_hd__mux4_1
XFILLER_42_206 VGND VGND VPWR VPWR sky130_fd_sc_hd__fill_1
X_08536_ _02157_ _02159_ _02315_ _02311_ VGND VGND VPWR VPWR _02327_ sky130_fd_sc_hd__a31o_1
X_08467_ net526 u_interface.u_gelu_fp32.u_synth_top.s3_mult\[39\] VGND VGND VPWR VPWR
+ _02258_ sky130_fd_sc_hd__xnor2_1
XFILLER_11_615 VGND VGND VPWR VPWR sky130_fd_sc_hd__fill_1
XFILLER_23_453 VGND VGND VPWR VPWR sky130_fd_sc_hd__fill_1
XPHY_EDGE_ROW_35_Left_191 VGND VGND VPWR VPWR sky130_fd_sc_hd__decap_3
XTAP_TAPCELL_ROW_42_1007 VGND VPWR sky130_fd_sc_hd__tapvpwrvgnd_1
X_07418_ u_interface.u_gelu_fp32.u_fp32_to_q16.s2_norm_mag\[28\] u_interface.u_gelu_fp32.u_fp32_to_q16.s2_norm_mag\[29\]
+ net559 VGND VGND VPWR VPWR _01554_ sky130_fd_sc_hd__mux2_1
XTAP_TAPCELL_ROW_137_2535 VGND VPWR sky130_fd_sc_hd__tapvpwrvgnd_1
XTAP_TAPCELL_ROW_137_2524 VGND VPWR sky130_fd_sc_hd__tapvpwrvgnd_1
X_08398_ u_interface.u_gelu_fp32.u_synth_top.s3_mult\[26\] u_interface.u_gelu_fp32.u_synth_top.s3_b\[10\]
+ VGND VGND VPWR VPWR _02189_ sky130_fd_sc_hd__nand2_1
X_07349_ net356 net1498 net243 VGND VGND VPWR VPWR _00379_ sky130_fd_sc_hd__mux2_1
XFILLER_109_525 VGND VGND VPWR VPWR sky130_fd_sc_hd__decap_3
XTAP_TAPCELL_ROW_21_665 VGND VPWR sky130_fd_sc_hd__tapvpwrvgnd_1
XTAP_TAPCELL_ROW_21_676 VGND VPWR sky130_fd_sc_hd__tapvpwrvgnd_1
XTAP_TAPCELL_ROW_150_2735 VGND VPWR sky130_fd_sc_hd__tapvpwrvgnd_1
XFILLER_136_355 VGND VGND VPWR VPWR sky130_fd_sc_hd__decap_3
XFILLER_109_558 VGND VGND VPWR VPWR sky130_fd_sc_hd__fill_2
X_10360_ net474 net478 net724 VGND VGND VPWR VPWR _04109_ sky130_fd_sc_hd__and3_1
XFILLER_12_65 VPWR VGND VPWR VGND sky130_ef_sc_hd__decap_12
X_09019_ _02775_ _02776_ _02770_ VGND VGND VPWR VPWR _02778_ sky130_fd_sc_hd__a21o_1
XFILLER_136_377 VPWR VGND VPWR VGND sky130_ef_sc_hd__decap_12
XFILLER_88_36 VGND VGND VPWR VPWR sky130_fd_sc_hd__decap_8
X_10291_ _03924_ _04039_ VGND VGND VPWR VPWR _04041_ sky130_fd_sc_hd__nor2_1
XFILLER_104_230 VPWR VGND VPWR VGND sky130_ef_sc_hd__decap_12
XTAP_TAPCELL_ROW_57_1250 VGND VPWR sky130_fd_sc_hd__tapvpwrvgnd_1
XFILLER_2_357 VGND VGND VPWR VPWR sky130_fd_sc_hd__decap_6
X_12030_ _05761_ _05762_ VGND VGND VPWR VPWR _05763_ sky130_fd_sc_hd__and2_1
Xhold170 u_interface.fifo_data\[14\]\[6\] VGND VGND VPWR VPWR net1035 sky130_fd_sc_hd__dlygate4sd3_1
Xhold181 u_interface.fifo_data\[10\]\[10\] VGND VGND VPWR VPWR net1046 sky130_fd_sc_hd__dlygate4sd3_1
Xhold192 u_interface.fifo_data\[12\]\[27\] VGND VGND VPWR VPWR net1057 sky130_fd_sc_hd__dlygate4sd3_1
XFILLER_78_659 VPWR VGND VPWR VGND sky130_ef_sc_hd__decap_12
XFILLER_77_125 VPWR VGND VPWR VGND sky130_ef_sc_hd__decap_12
XTAP_TAPCELL_ROW_70_1450 VGND VPWR sky130_fd_sc_hd__tapvpwrvgnd_1
Xfanout650 u_interface.u_gelu_fp32.u_synth_top.s2_m\[9\] VGND VGND VPWR VPWR net650
+ sky130_fd_sc_hd__buf_2
XTAP_TAPCELL_ROW_148_2697 VGND VPWR sky130_fd_sc_hd__tapvpwrvgnd_1
Xfanout683 u_interface.u_gelu_fp32.u_synth_top.s2_m\[12\] VGND VGND VPWR VPWR net683
+ sky130_fd_sc_hd__buf_2
Xfanout672 net673 VGND VGND VPWR VPWR net672 sky130_fd_sc_hd__clkbuf_2
Xfanout661 u_interface.u_gelu_fp32.u_synth_top.s2_m\[10\] VGND VGND VPWR VPWR net661
+ sky130_fd_sc_hd__clkbuf_2
XFILLER_77_169 VGND VGND VPWR VPWR sky130_fd_sc_hd__decap_8
XTAP_TAPCELL_ROW_70_1461 VGND VPWR sky130_fd_sc_hd__tapvpwrvgnd_1
X_13981_ clknet_leaf_84_clk net1723 VGND VGND VPWR VPWR u_interface.u_gelu_fp32.u_q16_to_fp32.s2_mag\[26\]
+ sky130_fd_sc_hd__dfxtp_1
Xfanout694 net695 VGND VGND VPWR VPWR net694 sky130_fd_sc_hd__buf_2
X_12932_ _06441_ _06456_ VGND VGND VPWR VPWR _06457_ sky130_fd_sc_hd__nand2_1
XFILLER_46_523 VGND VGND VPWR VPWR sky130_fd_sc_hd__fill_1
XFILLER_37_84 VGND VGND VPWR VPWR sky130_fd_sc_hd__decap_8
X_12863_ net1383 u_interface.u_gelu_fp32.u_fp32_to_q16.s2_norm_mag\[18\] net820 VGND
+ VGND VPWR VPWR _01007_ sky130_fd_sc_hd__mux2_1
XFILLER_46_589 VGND VGND VPWR VPWR sky130_fd_sc_hd__fill_1
XFILLER_46_578 VGND VGND VPWR VPWR sky130_fd_sc_hd__decap_3
XTAP_TAPCELL_ROW_29_798 VGND VPWR sky130_fd_sc_hd__tapvpwrvgnd_1
X_12794_ _01787_ _06413_ VGND VGND VPWR VPWR _00957_ sky130_fd_sc_hd__nor2_1
XFILLER_61_548 VPWR VGND VPWR VGND sky130_ef_sc_hd__decap_12
XFILLER_26_280 VGND VGND VPWR VPWR sky130_fd_sc_hd__decap_4
X_11814_ _05548_ _05549_ VGND VGND VPWR VPWR _05550_ sky130_fd_sc_hd__or2_1
XFILLER_42_740 VGND VGND VPWR VPWR sky130_fd_sc_hd__decap_6
X_11745_ _05314_ _05396_ _05481_ VGND VGND VPWR VPWR _05482_ sky130_fd_sc_hd__a21o_1
XFILLER_14_475 VGND VGND VPWR VPWR sky130_fd_sc_hd__fill_1
X_13415_ clknet_leaf_39_clk _00425_ VGND VGND VPWR VPWR u_interface.fifo_data\[6\]\[28\]
+ sky130_fd_sc_hd__dfxtp_1
X_11676_ _05337_ _05340_ VGND VGND VPWR VPWR _05413_ sky130_fd_sc_hd__nand2b_1
X_10627_ net669 net449 VGND VGND VPWR VPWR _04374_ sky130_fd_sc_hd__nand2_1
XFILLER_10_681 VPWR VGND VPWR VGND sky130_ef_sc_hd__decap_12
XTAP_TAPCELL_ROW_40_974 VGND VPWR sky130_fd_sc_hd__tapvpwrvgnd_1
XFILLER_155_664 VGND VGND VPWR VPWR sky130_fd_sc_hd__decap_4
XFILLER_154_141 VGND VGND VPWR VPWR sky130_fd_sc_hd__fill_1
X_13346_ clknet_leaf_52_clk _00356_ VGND VGND VPWR VPWR u_interface.fifo_data\[10\]\[23\]
+ sky130_fd_sc_hd__dfxtp_1
X_10558_ _04180_ _04182_ _04303_ _04304_ VGND VGND VPWR VPWR _04306_ sky130_fd_sc_hd__o211a_1
XFILLER_143_826 VGND VGND VPWR VPWR sky130_fd_sc_hd__decap_6
XFILLER_142_303 VGND VGND VPWR VPWR sky130_fd_sc_hd__decap_4
X_13277_ clknet_leaf_42_clk _00287_ VGND VGND VPWR VPWR u_interface.fifo_data\[0\]\[19\]
+ sky130_fd_sc_hd__dfxtp_1
XFILLER_127_377 VPWR VGND VPWR VGND sky130_ef_sc_hd__decap_12
X_10489_ _04234_ _04236_ VGND VGND VPWR VPWR _04237_ sky130_fd_sc_hd__nor2_1
X_12228_ _05826_ _05957_ VGND VGND VPWR VPWR _05958_ sky130_fd_sc_hd__xnor2_4
XFILLER_69_615 VGND VGND VPWR VPWR sky130_fd_sc_hd__fill_1
XFILLER_111_745 VPWR VGND VPWR VGND sky130_ef_sc_hd__decap_12
XFILLER_68_125 VGND VGND VPWR VPWR sky130_fd_sc_hd__fill_1
X_12159_ net717 net401 net397 VGND VGND VPWR VPWR _05890_ sky130_fd_sc_hd__and3_1
XFILLER_111_767 VGND VGND VPWR VPWR sky130_fd_sc_hd__decap_8
XFILLER_56_309 VPWR VGND VPWR VGND sky130_ef_sc_hd__decap_12
XFILLER_110_299 VGND VGND VPWR VPWR sky130_fd_sc_hd__fill_1
X_06720_ net733 _01281_ net728 VGND VGND VPWR VPWR _01284_ sky130_fd_sc_hd__o21a_1
XTAP_TAPCELL_ROW_88_1744 VGND VPWR sky130_fd_sc_hd__tapvpwrvgnd_1
XFILLER_37_501 VGND VGND VPWR VPWR sky130_fd_sc_hd__decap_3
XFILLER_37_534 VGND VGND VPWR VPWR sky130_fd_sc_hd__decap_4
X_06651_ _01222_ _01223_ net729 VGND VGND VPWR VPWR _01224_ sky130_fd_sc_hd__mux2_1
XFILLER_80_835 VGND VGND VPWR VPWR sky130_fd_sc_hd__fill_1
XFILLER_18_781 VPWR VGND VPWR VGND sky130_ef_sc_hd__decap_12
XFILLER_25_729 VPWR VGND VPWR VGND sky130_ef_sc_hd__decap_12
X_09370_ _03009_ _03042_ _03124_ _03125_ VGND VGND VPWR VPWR _03129_ sky130_fd_sc_hd__o2bb2a_1
X_06582_ net536 u_interface.u_gelu_fp32.s1_data\[30\] u_interface.u_gelu_fp32.s1_data\[29\]
+ u_interface.u_gelu_fp32.s1_data\[28\] VGND VGND VPWR VPWR _01170_ sky130_fd_sc_hd__and4_1
X_08321_ net530 net1655 _02122_ net796 VGND VGND VPWR VPWR _02124_ sky130_fd_sc_hd__a31o_1
XFILLER_32_250 VGND VGND VPWR VPWR sky130_fd_sc_hd__fill_2
X_08252_ net1618 _02072_ net782 VGND VGND VPWR VPWR _02073_ sky130_fd_sc_hd__o21ai_1
XFILLER_32_272 VGND VGND VPWR VPWR sky130_fd_sc_hd__decap_6
XFILLER_119_801 VGND VGND VPWR VPWR sky130_fd_sc_hd__fill_2
XTAP_TAPCELL_ROW_119_2243 VGND VPWR sky130_fd_sc_hd__tapvpwrvgnd_1
XTAP_TAPCELL_ROW_119_2232 VGND VPWR sky130_fd_sc_hd__tapvpwrvgnd_1
X_07203_ net363 net1309 net259 VGND VGND VPWR VPWR _00243_ sky130_fd_sc_hd__mux2_1
XFILLER_118_322 VGND VGND VPWR VPWR sky130_fd_sc_hd__decap_3
X_08183_ u_interface.u_gelu_fp32.u_fp32_to_q16.s3_mag\[21\] u_interface.u_gelu_fp32.u_fp32_to_q16.s3_mag\[20\]
+ _01886_ u_interface.u_gelu_fp32.u_fp32_to_q16.s3_mag\[22\] VGND VGND VPWR VPWR _02018_
+ sky130_fd_sc_hd__a31o_1
XFILLER_119_889 VGND VGND VPWR VPWR sky130_fd_sc_hd__decap_6
X_07134_ net1095 net372 net217 VGND VGND VPWR VPWR _00174_ sky130_fd_sc_hd__mux2_1
X_07065_ net994 net352 net209 VGND VGND VPWR VPWR _00105_ sky130_fd_sc_hd__mux2_1
XFILLER_134_837 VGND VGND VPWR VPWR sky130_fd_sc_hd__fill_1
XTAP_TAPCELL_ROW_132_2454 VGND VPWR sky130_fd_sc_hd__tapvpwrvgnd_1
XFILLER_133_314 VPWR VGND VPWR VGND sky130_ef_sc_hd__decap_12
XTAP_TAPCELL_ROW_132_2443 VGND VPWR sky130_fd_sc_hd__tapvpwrvgnd_1
XFILLER_118_399 VGND VGND VPWR VPWR sky130_fd_sc_hd__fill_1
XFILLER_118_377 VPWR VGND VPWR VGND sky130_ef_sc_hd__decap_12
XFILLER_99_261 VPWR VGND VPWR VGND sky130_ef_sc_hd__decap_12
XFILLER_59_103 VGND VGND VPWR VPWR sky130_fd_sc_hd__decap_8
XTAP_TAPCELL_ROW_7_449 VGND VPWR sky130_fd_sc_hd__tapvpwrvgnd_1
X_07967_ net1565 _01845_ net774 VGND VGND VPWR VPWR _00688_ sky130_fd_sc_hd__mux2_1
XFILLER_59_169 VGND VGND VPWR VPWR sky130_fd_sc_hd__decap_6
X_09706_ _03355_ _03358_ _03459_ _03460_ VGND VGND VPWR VPWR _03461_ sky130_fd_sc_hd__a211oi_1
XFILLER_101_288 VGND VGND VPWR VPWR sky130_fd_sc_hd__decap_8
X_06918_ _01452_ _01453_ _01454_ VGND VGND VPWR VPWR _01456_ sky130_fd_sc_hd__and3_1
XFILLER_74_117 VPWR VGND VPWR VGND sky130_ef_sc_hd__decap_12
XFILLER_56_810 VGND VGND VPWR VPWR sky130_fd_sc_hd__fill_2
XFILLER_28_501 VGND VGND VPWR VPWR sky130_fd_sc_hd__fill_1
XFILLER_28_523 VGND VGND VPWR VPWR sky130_fd_sc_hd__decap_8
X_07898_ net788 net940 VGND VGND VPWR VPWR _00659_ sky130_fd_sc_hd__and2_1
XFILLER_74_27 VGND VGND VPWR VPWR sky130_fd_sc_hd__fill_1
XFILLER_56_865 VGND VGND VPWR VPWR sky130_fd_sc_hd__decap_3
X_09637_ _03381_ _03390_ _03391_ VGND VGND VPWR VPWR _03393_ sky130_fd_sc_hd__and3_1
XFILLER_83_684 VGND VGND VPWR VPWR sky130_fd_sc_hd__fill_2
XFILLER_83_673 VGND VGND VPWR VPWR sky130_fd_sc_hd__decap_6
X_06849_ u_interface.fifo_data\[0\]\[27\] u_interface.fifo_data\[1\]\[27\] u_interface.fifo_data\[2\]\[27\]
+ u_interface.fifo_data\[3\]\[27\] net760 net743 VGND VGND VPWR VPWR _01397_ sky130_fd_sc_hd__mux4_1
XFILLER_43_526 VGND VGND VPWR VPWR sky130_fd_sc_hd__decap_6
XFILLER_28_589 VPWR VGND VPWR VGND sky130_ef_sc_hd__decap_12
X_09568_ net601 net450 VGND VGND VPWR VPWR _03324_ sky130_fd_sc_hd__nand2_1
XFILLER_43_548 VGND VGND VPWR VPWR sky130_fd_sc_hd__decap_4
XTAP_TAPCELL_ROW_26_746 VGND VPWR sky130_fd_sc_hd__tapvpwrvgnd_1
XFILLER_90_15 VPWR VGND VPWR VGND sky130_ef_sc_hd__decap_12
X_08519_ _02297_ _02304_ _02308_ _02309_ VGND VGND VPWR VPWR _02310_ sky130_fd_sc_hd__and4_1
XTAP_TAPCELL_ROW_26_757 VGND VPWR sky130_fd_sc_hd__tapvpwrvgnd_1
XFILLER_30_209 VGND VGND VPWR VPWR sky130_fd_sc_hd__decap_3
X_09499_ _03244_ _03253_ _03254_ VGND VGND VPWR VPWR _03256_ sky130_fd_sc_hd__and3_1
XFILLER_51_581 VGND VGND VPWR VPWR sky130_fd_sc_hd__fill_1
XFILLER_11_423 VGND VGND VPWR VPWR sky130_fd_sc_hd__fill_1
X_11530_ _05267_ _05268_ VGND VGND VPWR VPWR _05269_ sky130_fd_sc_hd__nor2_1
XFILLER_135_3 VGND VGND VPWR VPWR sky130_fd_sc_hd__decap_8
XFILLER_11_456 VGND VGND VPWR VPWR sky130_fd_sc_hd__fill_1
XFILLER_8_917 VGND VGND VPWR VPWR sky130_fd_sc_hd__decap_4
XFILLER_7_405 VGND VGND VPWR VPWR sky130_fd_sc_hd__fill_2
XPHY_EDGE_ROW_137_Right_137 VGND VGND VPWR VPWR sky130_fd_sc_hd__decap_3
X_11461_ _05200_ _05199_ VGND VGND VPWR VPWR _05201_ sky130_fd_sc_hd__nand2b_1
XFILLER_7_427 VGND VGND VPWR VPWR sky130_fd_sc_hd__decap_3
XFILLER_152_601 VGND VGND VPWR VPWR sky130_fd_sc_hd__decap_4
X_13200_ clknet_leaf_38_clk _00210_ VGND VGND VPWR VPWR u_interface.fifo_data\[12\]\[10\]
+ sky130_fd_sc_hd__dfxtp_1
X_10412_ net619 net432 net427 net609 VGND VGND VPWR VPWR _04161_ sky130_fd_sc_hd__a22o_1
X_11392_ _04934_ _05131_ VGND VGND VPWR VPWR _05132_ sky130_fd_sc_hd__nand2_1
XFILLER_136_163 VPWR VGND VPWR VGND sky130_ef_sc_hd__decap_12
XFILLER_99_57 VGND VGND VPWR VPWR sky130_fd_sc_hd__decap_4
X_10343_ _04090_ _04091_ _03979_ VGND VGND VPWR VPWR _04092_ sky130_fd_sc_hd__a21o_1
X_13131_ clknet_leaf_70_clk _00141_ VGND VGND VPWR VPWR u_interface.fifo_data\[2\]\[20\]
+ sky130_fd_sc_hd__dfxtp_1
XTAP_TAPCELL_ROW_55_1209 VGND VPWR sky130_fd_sc_hd__tapvpwrvgnd_1
XFILLER_2_121 VPWR VGND VPWR VGND sky130_ef_sc_hd__decap_12
XFILLER_155_85 VGND VGND VPWR VPWR sky130_fd_sc_hd__fill_1
XFILLER_151_177 VGND VGND VPWR VPWR sky130_fd_sc_hd__decap_3
XFILLER_151_155 VGND VGND VPWR VPWR sky130_fd_sc_hd__decap_4
XFILLER_112_509 VPWR VGND VPWR VGND sky130_ef_sc_hd__decap_12
X_13062_ clknet_leaf_65_clk _00072_ VGND VGND VPWR VPWR u_interface.fifo_data\[14\]\[15\]
+ sky130_fd_sc_hd__dfxtp_1
X_10274_ _04022_ _04023_ _04016_ VGND VGND VPWR VPWR _04024_ sky130_fd_sc_hd__a21o_1
XFILLER_2_165 VPWR VGND VPWR VGND sky130_ef_sc_hd__decap_12
XFILLER_78_445 VPWR VGND VPWR VGND sky130_ef_sc_hd__decap_12
X_12013_ _05741_ _05745_ VGND VGND VPWR VPWR _05746_ sky130_fd_sc_hd__nand2_1
XFILLER_38_309 VGND VGND VPWR VPWR sky130_fd_sc_hd__fill_2
Xfanout480 net481 VGND VGND VPWR VPWR net480 sky130_fd_sc_hd__buf_2
Xfanout491 net495 VGND VGND VPWR VPWR net491 sky130_fd_sc_hd__buf_2
XFILLER_93_437 VGND VGND VPWR VPWR sky130_fd_sc_hd__fill_1
X_13964_ clknet_leaf_59_clk net1685 VGND VGND VPWR VPWR u_interface.u_gelu_fp32.u_q16_to_fp32.s2_mag\[9\]
+ sky130_fd_sc_hd__dfxtp_1
X_12915_ net1750 _06441_ _06442_ VGND VGND VPWR VPWR _01053_ sky130_fd_sc_hd__o21a_1
X_13895_ clknet_leaf_90_clk _00031_ VGND VGND VPWR VPWR u_interface.u_gelu_fp32.u_synth_top.s2_dx\[31\]
+ sky130_fd_sc_hd__dfxtp_2
XFILLER_62_813 VGND VGND VPWR VPWR sky130_fd_sc_hd__fill_2
XFILLER_0_57 VPWR VGND VPWR VGND sky130_ef_sc_hd__decap_12
X_12846_ net46 net45 net49 net48 VGND VGND VPWR VPWR _06428_ sky130_fd_sc_hd__or4_1
XFILLER_64_71 VPWR VGND VPWR VGND sky130_ef_sc_hd__decap_12
XTAP_TAPCELL_ROW_83_1663 VGND VPWR sky130_fd_sc_hd__tapvpwrvgnd_1
X_12777_ u_interface.u_gelu_fp32.u_q16_to_fp32.s3_norm_mag\[17\] _01781_ net296 VGND
+ VGND VPWR VPWR _06405_ sky130_fd_sc_hd__o21ai_1
XFILLER_14_261 VGND VGND VPWR VPWR sky130_fd_sc_hd__decap_6
XFILLER_9_55 VGND VGND VPWR VPWR sky130_fd_sc_hd__fill_1
X_11728_ _05328_ _05383_ _05382_ VGND VGND VPWR VPWR _05465_ sky130_fd_sc_hd__o21ai_1
XPHY_EDGE_ROW_104_Right_104 VGND VGND VPWR VPWR sky130_fd_sc_hd__decap_3
X_11659_ _05314_ _05396_ VGND VGND VPWR VPWR _05397_ sky130_fd_sc_hd__xor2_1
XFILLER_155_461 VGND VGND VPWR VPWR sky130_fd_sc_hd__decap_4
XFILLER_143_623 VPWR VGND VPWR VGND sky130_ef_sc_hd__decap_12
XFILLER_143_612 VGND VGND VPWR VPWR sky130_fd_sc_hd__decap_4
Xhold917 u_interface.u_gelu_fp32.u_fp32_to_q16.s3_frac\[10\] VGND VGND VPWR VPWR net1782
+ sky130_fd_sc_hd__dlygate4sd3_1
XFILLER_115_314 VGND VGND VPWR VPWR sky130_fd_sc_hd__fill_1
Xhold906 u_interface.u_gelu_fp32.u_synth_top.s1_hits\[9\] VGND VGND VPWR VPWR net1771
+ sky130_fd_sc_hd__dlygate4sd3_1
X_13329_ clknet_leaf_75_clk _00339_ VGND VGND VPWR VPWR u_interface.fifo_data\[10\]\[6\]
+ sky130_fd_sc_hd__dfxtp_1
XTAP_TAPCELL_ROW_114_2162 VGND VPWR sky130_fd_sc_hd__tapvpwrvgnd_1
XFILLER_50_3 VPWR VGND VPWR VGND sky130_ef_sc_hd__decap_12
X_08870_ _02599_ _02627_ _02628_ VGND VGND VPWR VPWR _02629_ sky130_fd_sc_hd__and3_1
XFILLER_69_423 VGND VGND VPWR VPWR sky130_fd_sc_hd__decap_3
X_07821_ net1564 net346 net231 VGND VGND VPWR VPWR _00582_ sky130_fd_sc_hd__mux2_1
XFILLER_56_128 VPWR VGND VPWR VGND sky130_ef_sc_hd__decap_12
X_07752_ u_interface.u_gelu_fp32.u_q16_to_fp32.s3_exp\[1\] _01791_ net294 VGND VGND
+ VPWR VPWR _01795_ sky130_fd_sc_hd__o21ai_1
X_07683_ _01428_ _01757_ VGND VGND VPWR VPWR _00495_ sky130_fd_sc_hd__or2_1
XFILLER_64_161 VPWR VGND VPWR VGND sky130_ef_sc_hd__decap_12
X_06703_ u_interface.fifo_data\[12\]\[9\] u_interface.fifo_data\[13\]\[9\] u_interface.fifo_data\[14\]\[9\]
+ u_interface.fifo_data\[15\]\[9\] net756 net739 VGND VGND VPWR VPWR _01269_ sky130_fd_sc_hd__mux4_1
X_09422_ net510 net697 _02666_ _02665_ VGND VGND VPWR VPWR _03180_ sky130_fd_sc_hd__a31oi_1
XFILLER_80_643 VGND VGND VPWR VPWR sky130_fd_sc_hd__fill_1
XFILLER_80_621 VGND VGND VPWR VPWR sky130_fd_sc_hd__decap_6
X_06634_ u_interface.fifo_data\[4\]\[0\] u_interface.fifo_data\[5\]\[0\] u_interface.fifo_data\[6\]\[0\]
+ u_interface.fifo_data\[7\]\[0\] net756 net739 VGND VGND VPWR VPWR _01209_ sky130_fd_sc_hd__mux4_1
XFILLER_52_334 VPWR VGND VPWR VGND sky130_ef_sc_hd__decap_12
XFILLER_25_559 VGND VGND VPWR VPWR sky130_fd_sc_hd__fill_1
X_09353_ _03039_ _03041_ VGND VGND VPWR VPWR _03112_ sky130_fd_sc_hd__xnor2_1
XFILLER_80_687 VPWR VGND VPWR VGND sky130_ef_sc_hd__decap_12
XFILLER_12_209 VGND VGND VPWR VPWR sky130_fd_sc_hd__fill_2
XTAP_TAPCELL_ROW_23_705 VGND VPWR sky130_fd_sc_hd__tapvpwrvgnd_1
X_06565_ net535 _01150_ VGND VGND VPWR VPWR _01159_ sky130_fd_sc_hd__nor2_1
X_08304_ net530 _02110_ net1582 VGND VGND VPWR VPWR _02111_ sky130_fd_sc_hd__a21oi_1
XFILLER_21_721 VGND VGND VPWR VPWR sky130_fd_sc_hd__decap_6
X_09284_ net615 net623 net513 net517 VGND VGND VPWR VPWR _03043_ sky130_fd_sc_hd__and4_1
XFILLER_138_417 VGND VGND VPWR VPWR sky130_fd_sc_hd__decap_3
XFILLER_20_242 VGND VGND VPWR VPWR sky130_fd_sc_hd__decap_8
XFILLER_21_765 VPWR VGND VPWR VGND sky130_ef_sc_hd__decap_12
X_08235_ u_interface.u_gelu_fp32.u_fp32_to_q16.s3_mag\[30\] _01893_ VGND VGND VPWR
+ VPWR _02062_ sky130_fd_sc_hd__xnor2_1
XFILLER_60_29 VGND VGND VPWR VPWR sky130_fd_sc_hd__fill_2
XFILLER_119_653 VGND VGND VPWR VPWR sky130_fd_sc_hd__fill_1
XFILLER_118_141 VGND VGND VPWR VPWR sky130_fd_sc_hd__decap_4
X_08166_ _01993_ _01994_ _01998_ VGND VGND VPWR VPWR _02004_ sky130_fd_sc_hd__nor3b_1
XFILLER_5_909 VPWR VGND VPWR VGND sky130_ef_sc_hd__decap_12
X_07117_ net971 net324 net255 VGND VGND VPWR VPWR _00157_ sky130_fd_sc_hd__mux2_1
XFILLER_109_34 VPWR VGND VPWR VGND sky130_ef_sc_hd__decap_12
XFILLER_4_419 VGND VGND VPWR VPWR sky130_fd_sc_hd__fill_1
XFILLER_133_111 VGND VGND VPWR VPWR sky130_fd_sc_hd__fill_1
X_08097_ net292 _01946_ VGND VGND VPWR VPWR _00717_ sky130_fd_sc_hd__nor2_1
XFILLER_69_27 VGND VGND VPWR VPWR sky130_fd_sc_hd__decap_8
X_07048_ net1038 net561 net269 VGND VGND VPWR VPWR _00088_ sky130_fd_sc_hd__mux2_1
XTAP_TAPCELL_ROW_50_1128 VGND VPWR sky130_fd_sc_hd__tapvpwrvgnd_1
XFILLER_0_669 VGND VGND VPWR VPWR sky130_fd_sc_hd__decap_3
X_08999_ _02629_ _02756_ _02757_ VGND VGND VPWR VPWR _02758_ sky130_fd_sc_hd__or3_2
XFILLER_102_586 VGND VGND VPWR VPWR sky130_fd_sc_hd__fill_2
XTAP_TAPCELL_ROW_50_1139 VGND VPWR sky130_fd_sc_hd__tapvpwrvgnd_1
XFILLER_29_821 VPWR VGND VPWR VGND sky130_ef_sc_hd__decap_12
XTAP_TAPCELL_ROW_145_2656 VGND VPWR sky130_fd_sc_hd__tapvpwrvgnd_1
XFILLER_56_640 VGND VGND VPWR VPWR sky130_fd_sc_hd__decap_4
XFILLER_18_53 VPWR VGND VPWR VGND sky130_ef_sc_hd__decap_12
XFILLER_29_865 VPWR VGND VPWR VGND sky130_ef_sc_hd__decap_12
XFILLER_56_684 VGND VGND VPWR VPWR sky130_fd_sc_hd__decap_4
X_10961_ _04701_ _04702_ _04703_ VGND VGND VPWR VPWR _04705_ sky130_fd_sc_hd__nand3b_1
X_13680_ clknet_leaf_9_clk _00690_ VGND VGND VPWR VPWR u_interface.u_gelu_fp32.u_fp32_to_q16.s3_frac\[16\]
+ sky130_fd_sc_hd__dfxtp_1
X_12700_ _01740_ net280 _06357_ _01696_ VGND VGND VPWR VPWR _06358_ sky130_fd_sc_hd__a22o_1
XFILLER_44_846 VGND VGND VPWR VPWR sky130_fd_sc_hd__decap_4
XFILLER_16_548 VGND VGND VPWR VPWR sky130_fd_sc_hd__fill_1
XFILLER_18_97 VPWR VGND VPWR VGND sky130_ef_sc_hd__decap_12
X_12631_ _06317_ _06330_ VGND VGND VPWR VPWR _06332_ sky130_fd_sc_hd__nor2_1
XFILLER_70_153 VGND VGND VPWR VPWR sky130_fd_sc_hd__decap_4
X_10892_ _04632_ _04636_ VGND VGND VPWR VPWR _04637_ sky130_fd_sc_hd__or2_1
XTAP_TAPCELL_ROW_65_1382 VGND VPWR sky130_fd_sc_hd__tapvpwrvgnd_1
XTAP_TAPCELL_ROW_65_1371 VGND VPWR sky130_fd_sc_hd__tapvpwrvgnd_1
XFILLER_34_41 VPWR VGND VPWR VGND sky130_ef_sc_hd__decap_12
X_12562_ net784 net1682 VGND VGND VPWR VPWR _00860_ sky130_fd_sc_hd__and2_1
XFILLER_70_197 VPWR VGND VPWR VGND sky130_ef_sc_hd__decap_12
XFILLER_24_592 VPWR VGND VPWR VGND sky130_ef_sc_hd__decap_12
XFILLER_34_85 VGND VGND VPWR VPWR sky130_fd_sc_hd__fill_1
XFILLER_8_725 VPWR VGND VPWR VGND sky130_ef_sc_hd__decap_12
X_12493_ _06172_ _06178_ _06170_ VGND VGND VPWR VPWR _06219_ sky130_fd_sc_hd__o21a_1
X_11513_ _05236_ _05251_ VGND VGND VPWR VPWR _05252_ sky130_fd_sc_hd__nor2_1
XFILLER_144_409 VGND VGND VPWR VPWR sky130_fd_sc_hd__fill_2
XFILLER_8_769 VPWR VGND VPWR VGND sky130_ef_sc_hd__decap_12
XFILLER_7_257 VGND VGND VPWR VPWR sky130_fd_sc_hd__decap_3
X_11444_ _05182_ _05183_ VGND VGND VPWR VPWR _05184_ sky130_fd_sc_hd__nand2_1
XFILLER_50_62 VGND VGND VPWR VPWR sky130_fd_sc_hd__decap_6
X_14163_ clknet_leaf_43_clk _01089_ VGND VGND VPWR VPWR u_interface.fifo_data\[1\]\[23\]
+ sky130_fd_sc_hd__dfxtp_1
XFILLER_109_185 VGND VGND VPWR VPWR sky130_fd_sc_hd__fill_1
X_11375_ _05114_ _05115_ VGND VGND VPWR VPWR _05116_ sky130_fd_sc_hd__xnor2_1
X_14094_ clknet_leaf_29_clk _01020_ VGND VGND VPWR VPWR net144 sky130_fd_sc_hd__dfxtp_1
X_10326_ net197 _04073_ _04074_ VGND VGND VPWR VPWR _04076_ sky130_fd_sc_hd__or3_1
X_13114_ clknet_leaf_73_clk _00124_ VGND VGND VPWR VPWR u_interface.fifo_data\[2\]\[3\]
+ sky130_fd_sc_hd__dfxtp_1
XFILLER_3_441 VGND VGND VPWR VPWR sky130_fd_sc_hd__decap_6
X_13045_ clknet_leaf_37_clk _00055_ VGND VGND VPWR VPWR u_interface.fifo_tuser\[15\]
+ sky130_fd_sc_hd__dfxtp_1
XFILLER_112_328 VGND VGND VPWR VPWR sky130_fd_sc_hd__decap_4
X_10257_ net464 net682 net688 net468 VGND VGND VPWR VPWR _04007_ sky130_fd_sc_hd__a22o_1
XFILLER_3_485 VPWR VGND VPWR VGND sky130_ef_sc_hd__decap_12
XFILLER_78_253 VPWR VGND VPWR VGND sky130_ef_sc_hd__decap_12
XFILLER_78_231 VPWR VGND VPWR VGND sky130_ef_sc_hd__decap_12
XFILLER_39_607 VGND VGND VPWR VPWR sky130_fd_sc_hd__decap_8
XFILLER_93_212 VPWR VGND VPWR VGND sky130_ef_sc_hd__decap_12
X_10188_ _03930_ _03938_ VGND VGND VPWR VPWR _03939_ sky130_fd_sc_hd__nand2_1
XFILLER_66_404 VGND VGND VPWR VPWR sky130_fd_sc_hd__decap_8
XFILLER_39_629 VPWR VGND VPWR VGND sky130_ef_sc_hd__decap_12
X_13947_ clknet_leaf_29_clk _00873_ VGND VGND VPWR VPWR net147 sky130_fd_sc_hd__dfxtp_1
XTAP_TAPCELL_ROW_85_1703 VGND VPWR sky130_fd_sc_hd__tapvpwrvgnd_1
XFILLER_53_109 VGND VGND VPWR VPWR sky130_fd_sc_hd__decap_3
XFILLER_46_194 VGND VGND VPWR VPWR sky130_fd_sc_hd__fill_2
XFILLER_46_172 VGND VGND VPWR VPWR sky130_fd_sc_hd__decap_8
XFILLER_46_161 VGND VGND VPWR VPWR sky130_fd_sc_hd__fill_1
X_13878_ clknet_leaf_3_clk _00023_ VGND VGND VPWR VPWR u_interface.u_gelu_fp32.u_synth_top.s2_dx\[14\]
+ sky130_fd_sc_hd__dfxtp_1
XFILLER_62_654 VGND VGND VPWR VPWR sky130_fd_sc_hd__decap_8
XFILLER_98_3 VGND VGND VPWR VPWR sky130_fd_sc_hd__decap_6
X_12829_ net338 _06328_ net781 VGND VGND VPWR VPWR _00987_ sky130_fd_sc_hd__mux2_1
XFILLER_22_518 VPWR VGND VPWR VGND sky130_ef_sc_hd__decap_12
XFILLER_34_389 VGND VGND VPWR VPWR sky130_fd_sc_hd__decap_8
XFILLER_147_225 VGND VGND VPWR VPWR sky130_fd_sc_hd__decap_3
X_08020_ u_interface.u_gelu_fp32.u_fp32_to_q16.s3_mag\[7\] u_interface.u_gelu_fp32.u_fp32_to_q16.s3_mag\[6\]
+ _01876_ VGND VGND VPWR VPWR _01877_ sky130_fd_sc_hd__and3_1
XFILLER_30_584 VGND VGND VPWR VPWR sky130_fd_sc_hd__decap_4
Xhold703 u_interface.fifo_data\[7\]\[29\] VGND VGND VPWR VPWR net1568 sky130_fd_sc_hd__dlygate4sd3_1
XFILLER_116_601 VPWR VGND VPWR VGND sky130_ef_sc_hd__decap_12
XFILLER_116_645 VGND VGND VPWR VPWR sky130_fd_sc_hd__decap_6
Xhold736 u_interface.fifo_data\[7\]\[25\] VGND VGND VPWR VPWR net1601 sky130_fd_sc_hd__dlygate4sd3_1
Xhold714 u_interface.u_gelu_fp32.u_q16_to_fp32.s2_exp\[3\] VGND VGND VPWR VPWR net1579
+ sky130_fd_sc_hd__dlygate4sd3_1
XTAP_TAPCELL_ROW_96_1876 VGND VPWR sky130_fd_sc_hd__tapvpwrvgnd_1
XTAP_TAPCELL_ROW_96_1865 VGND VPWR sky130_fd_sc_hd__tapvpwrvgnd_1
Xhold725 u_interface.fifo_data\[7\]\[3\] VGND VGND VPWR VPWR net1590 sky130_fd_sc_hd__dlygate4sd3_1
Xhold758 u_interface.u_gelu_fp32.u_fp32_to_q16.s1_mant\[15\] VGND VGND VPWR VPWR net1623
+ sky130_fd_sc_hd__dlygate4sd3_1
X_09971_ _03721_ _03722_ _03686_ VGND VGND VPWR VPWR _03724_ sky130_fd_sc_hd__o21ai_1
Xhold747 u_interface.u_gelu_fp32.u_q16_to_fp32.s1_mag\[11\] VGND VGND VPWR VPWR net1612
+ sky130_fd_sc_hd__dlygate4sd3_1
Xhold769 u_interface.u_gelu_fp32.s2_data\[21\] VGND VGND VPWR VPWR net1634 sky130_fd_sc_hd__dlygate4sd3_1
X_08922_ net489 net654 net494 net664 VGND VGND VPWR VPWR _02681_ sky130_fd_sc_hd__a22o_1
XFILLER_115_177 VGND VGND VPWR VPWR sky130_fd_sc_hd__fill_1
XFILLER_69_231 VGND VGND VPWR VPWR sky130_fd_sc_hd__fill_2
X_08853_ _02608_ _02609_ _02610_ VGND VGND VPWR VPWR _02612_ sky130_fd_sc_hd__nand3_1
XFILLER_85_724 VGND VGND VPWR VPWR sky130_fd_sc_hd__decap_4
XFILLER_69_275 VGND VGND VPWR VPWR sky130_fd_sc_hd__fill_1
XTAP_TAPCELL_ROW_127_2364 VGND VPWR sky130_fd_sc_hd__tapvpwrvgnd_1
X_08784_ _02541_ _02542_ _02535_ VGND VGND VPWR VPWR _02543_ sky130_fd_sc_hd__a21o_1
XFILLER_85_779 VGND VGND VPWR VPWR sky130_fd_sc_hd__decap_4
XFILLER_57_459 VGND VGND VPWR VPWR sky130_fd_sc_hd__fill_1
X_07804_ net1209 net380 net229 VGND VGND VPWR VPWR _00565_ sky130_fd_sc_hd__mux2_1
XTAP_TAPCELL_ROW_127_2375 VGND VPWR sky130_fd_sc_hd__tapvpwrvgnd_1
X_07735_ u_interface.u_gelu_fp32.u_q16_to_fp32.s3_norm_mag\[13\] u_interface.u_gelu_fp32.u_q16_to_fp32.s3_norm_mag\[12\]
+ _01777_ VGND VGND VPWR VPWR _01779_ sky130_fd_sc_hd__and3_1
XFILLER_72_429 VGND VGND VPWR VPWR sky130_fd_sc_hd__fill_2
XFILLER_44_109 VPWR VGND VPWR VGND sky130_ef_sc_hd__decap_12
XFILLER_26_813 VPWR VGND VPWR VGND sky130_ef_sc_hd__decap_12
XFILLER_25_312 VPWR VGND VPWR VGND sky130_ef_sc_hd__decap_12
XFILLER_25_334 VGND VGND VPWR VPWR sky130_fd_sc_hd__fill_2
XTAP_TAPCELL_ROW_140_2575 VGND VPWR sky130_fd_sc_hd__tapvpwrvgnd_1
X_09405_ _02653_ _03162_ VGND VGND VPWR VPWR _03163_ sky130_fd_sc_hd__or2_1
X_07666_ net807 net1765 net299 _01747_ VGND VGND VPWR VPWR _00484_ sky130_fd_sc_hd__a22o_1
XPHY_EDGE_ROW_9_Left_165 VGND VGND VPWR VPWR sky130_fd_sc_hd__decap_3
X_06617_ u_interface.fifo_tuser\[0\] u_interface.fifo_tuser\[1\] u_interface.fifo_tuser\[2\]
+ u_interface.fifo_tuser\[3\] net770 net753 VGND VGND VPWR VPWR _01194_ sky130_fd_sc_hd__mux4_1
X_07597_ u_interface.u_gelu_fp32.u_fp32_to_q16.s2_shift\[4\] _01677_ VGND VGND VPWR
+ VPWR _01694_ sky130_fd_sc_hd__nor2_1
XFILLER_111_57 VPWR VGND VPWR VGND sky130_ef_sc_hd__decap_12
XFILLER_80_495 VGND VGND VPWR VPWR sky130_fd_sc_hd__fill_2
XFILLER_52_186 VGND VGND VPWR VPWR sky130_fd_sc_hd__decap_8
XFILLER_13_529 VPWR VGND VPWR VGND sky130_ef_sc_hd__decap_12
XFILLER_25_378 VPWR VGND VPWR VGND sky130_ef_sc_hd__decap_12
XFILLER_40_326 VGND VGND VPWR VPWR sky130_fd_sc_hd__decap_3
X_09336_ _03093_ _03094_ VGND VGND VPWR VPWR _03095_ sky130_fd_sc_hd__nand2b_1
X_06548_ u_interface.u_gelu_fp32.s1_data\[3\] u_interface.u_gelu_fp32.s1_data\[2\]
+ u_interface.u_gelu_fp32.s1_data\[1\] u_interface.u_gelu_fp32.s1_data\[0\] VGND VGND
+ VPWR VPWR _01144_ sky130_fd_sc_hd__or4_1
XFILLER_52_197 VGND VGND VPWR VPWR sky130_fd_sc_hd__decap_4
XTAP_TAPCELL_ROW_47_1090 VGND VPWR sky130_fd_sc_hd__tapvpwrvgnd_1
X_09267_ _02977_ _03012_ _03024_ VGND VGND VPWR VPWR _03026_ sky130_fd_sc_hd__nand3_1
X_08218_ u_interface.u_gelu_fp32.u_fp32_to_q16.s3_mag\[27\] _01891_ VGND VGND VPWR
+ VPWR _02048_ sky130_fd_sc_hd__xnor2_1
X_09198_ _02911_ _02916_ _02954_ VGND VGND VPWR VPWR _02957_ sky130_fd_sc_hd__a21o_1
XTAP_TAPCELL_ROW_60_1290 VGND VPWR sky130_fd_sc_hd__tapvpwrvgnd_1
X_08149_ net315 _01988_ _01987_ VGND VGND VPWR VPWR _01990_ sky130_fd_sc_hd__o21ai_1
X_11160_ net195 _04786_ _04785_ VGND VGND VPWR VPWR _04903_ sky130_fd_sc_hd__a21oi_1
XFILLER_20_65 VPWR VGND VPWR VGND sky130_ef_sc_hd__decap_12
X_10111_ _03778_ _03780_ VGND VGND VPWR VPWR _03862_ sky130_fd_sc_hd__nand2b_1
X_11091_ _04832_ _04833_ VGND VGND VPWR VPWR _04834_ sky130_fd_sc_hd__and2b_1
X_10042_ _03792_ _03793_ VGND VGND VPWR VPWR _03794_ sky130_fd_sc_hd__nor2_1
XFILLER_0_433 VPWR VGND VPWR VGND sky130_ef_sc_hd__decap_12
Xhold41 u_interface.u_gelu_fp32.u_synth_top.v_pipe\[1\] VGND VGND VPWR VPWR net906
+ sky130_fd_sc_hd__dlygate4sd3_1
XFILLER_102_372 VPWR VGND VPWR VGND sky130_ef_sc_hd__decap_12
XFILLER_102_350 VGND VGND VPWR VPWR sky130_fd_sc_hd__fill_1
Xhold30 u_interface.u_gelu_fp32.s1_data\[28\] VGND VGND VPWR VPWR net895 sky130_fd_sc_hd__dlygate4sd3_1
XFILLER_0_477 VPWR VGND VPWR VGND sky130_ef_sc_hd__decap_12
Xhold74 u_interface.meta_tlast_pipe\[0\] VGND VGND VPWR VPWR net939 sky130_fd_sc_hd__dlygate4sd3_1
XFILLER_152_53 VPWR VGND VPWR VGND sky130_ef_sc_hd__decap_12
Xhold63 u_interface.u_gelu_fp32.u_q16_to_fp32.s1_valid VGND VGND VPWR VPWR net928
+ sky130_fd_sc_hd__dlygate4sd3_1
Xhold52 u_interface.meta_tuser_pipe\[9\] VGND VGND VPWR VPWR net917 sky130_fd_sc_hd__dlygate4sd3_1
XFILLER_76_757 VGND VGND VPWR VPWR sky130_fd_sc_hd__fill_2
XFILLER_75_223 VGND VGND VPWR VPWR sky130_fd_sc_hd__fill_1
X_13801_ clknet_leaf_25_clk _00811_ VGND VGND VPWR VPWR u_interface.u_gelu_fp32.u_synth_top.s3_mult\[19\]
+ sky130_fd_sc_hd__dfxtp_1
XFILLER_91_727 VGND VGND VPWR VPWR sky130_fd_sc_hd__fill_1
XFILLER_75_278 VGND VGND VPWR VPWR sky130_fd_sc_hd__fill_2
Xhold96 _00895_ VGND VGND VPWR VPWR net961 sky130_fd_sc_hd__dlygate4sd3_1
Xhold85 u_interface.u_gelu_fp32.u_q16_to_fp32.s3_norm_mag\[5\] VGND VGND VPWR VPWR
+ net950 sky130_fd_sc_hd__dlygate4sd3_1
XTAP_TAPCELL_ROW_67_1400 VGND VPWR sky130_fd_sc_hd__tapvpwrvgnd_1
XFILLER_29_673 VPWR VGND VPWR VGND sky130_ef_sc_hd__decap_12
X_13732_ clknet_leaf_28_clk _00742_ VGND VGND VPWR VPWR u_interface.u_gelu_fp32.s1_valid
+ sky130_fd_sc_hd__dfxtp_1
XTAP_TAPCELL_ROW_67_1411 VGND VPWR sky130_fd_sc_hd__tapvpwrvgnd_1
X_11993_ _05656_ _05659_ net178 VGND VGND VPWR VPWR _05726_ sky130_fd_sc_hd__o21a_1
X_10944_ _03979_ _04324_ VGND VGND VPWR VPWR _04688_ sky130_fd_sc_hd__or2_1
XFILLER_45_51 VGND VGND VPWR VPWR sky130_fd_sc_hd__decap_4
XFILLER_32_805 VGND VGND VPWR VPWR sky130_fd_sc_hd__decap_6
X_13663_ clknet_leaf_14_clk _00673_ VGND VGND VPWR VPWR u_interface.u_gelu_fp32.u_fp32_to_q16.s2_shift\[0\]
+ sky130_fd_sc_hd__dfxtp_1
XTAP_TAPCELL_ROW_80_1611 VGND VPWR sky130_fd_sc_hd__tapvpwrvgnd_1
X_10875_ net618 net626 net418 net413 VGND VGND VPWR VPWR _04620_ sky130_fd_sc_hd__and4_1
XFILLER_32_849 VPWR VGND VPWR VGND sky130_ef_sc_hd__decap_12
X_12614_ _06316_ VGND VGND VPWR VPWR _06317_ sky130_fd_sc_hd__inv_2
XTAP_TAPCELL_ROW_80_1622 VGND VPWR sky130_fd_sc_hd__tapvpwrvgnd_1
X_13594_ clknet_leaf_83_clk _00604_ VGND VGND VPWR VPWR u_interface.fifo_data\[3\]\[9\]
+ sky130_fd_sc_hd__dfxtp_1
XFILLER_129_225 VGND VGND VPWR VPWR sky130_fd_sc_hd__decap_3
X_12545_ _06222_ _06261_ VGND VGND VPWR VPWR _06269_ sky130_fd_sc_hd__xnor2_1
XTAP_TAPCELL_ROW_14_557 VGND VPWR sky130_fd_sc_hd__tapvpwrvgnd_1
XFILLER_8_533 VPWR VGND VPWR VGND sky130_ef_sc_hd__decap_12
X_12476_ _06199_ _06200_ VGND VGND VPWR VPWR _06202_ sky130_fd_sc_hd__xor2_1
XANTENNA_5 _01819_ VGND VGND VPWR VPWR sky130_fd_sc_hd__diode_2
X_11427_ net676 net421 _05164_ _05165_ VGND VGND VPWR VPWR _05167_ sky130_fd_sc_hd__nand4_1
XTAP_TAPCELL_ROW_111_2110 VGND VPWR sky130_fd_sc_hd__tapvpwrvgnd_1
XTAP_TAPCELL_ROW_78_1584 VGND VPWR sky130_fd_sc_hd__tapvpwrvgnd_1
X_11358_ _04965_ _04999_ _04998_ VGND VGND VPWR VPWR _05099_ sky130_fd_sc_hd__a21oi_2
X_14146_ clknet_leaf_71_clk _01072_ VGND VGND VPWR VPWR u_interface.fifo_data\[1\]\[6\]
+ sky130_fd_sc_hd__dfxtp_1
XFILLER_98_337 VGND VGND VPWR VPWR sky130_fd_sc_hd__fill_2
X_10309_ _04042_ _04057_ _04058_ VGND VGND VPWR VPWR _04059_ sky130_fd_sc_hd__nand3b_2
X_14077_ clknet_leaf_17_clk net1073 VGND VGND VPWR VPWR u_interface.u_gelu_fp32.u_fp32_to_q16.s2_norm_mag\[14\]
+ sky130_fd_sc_hd__dfxtp_1
XFILLER_140_445 VGND VGND VPWR VPWR sky130_fd_sc_hd__fill_2
XTAP_TAPCELL_ROW_91_1784 VGND VPWR sky130_fd_sc_hd__tapvpwrvgnd_1
X_11289_ _04946_ _04962_ _04963_ VGND VGND VPWR VPWR _05030_ sky130_fd_sc_hd__o21ba_1
XFILLER_3_293 VPWR VGND VPWR VGND sky130_ef_sc_hd__decap_12
X_13028_ _01530_ _01531_ VGND VGND VPWR VPWR _01046_ sky130_fd_sc_hd__nor2_1
XFILLER_112_169 VGND VGND VPWR VPWR sky130_fd_sc_hd__fill_1
XTAP_TAPCELL_ROW_91_1795 VGND VPWR sky130_fd_sc_hd__tapvpwrvgnd_1
XFILLER_13_3 VPWR VGND VPWR VGND sky130_ef_sc_hd__decap_12
XTAP_TAPCELL_ROW_109_2083 VGND VPWR sky130_fd_sc_hd__tapvpwrvgnd_1
XTAP_TAPCELL_ROW_109_2072 VGND VPWR sky130_fd_sc_hd__tapvpwrvgnd_1
XFILLER_66_256 VPWR VGND VPWR VGND sky130_ef_sc_hd__decap_12
XFILLER_26_109 VGND VGND VPWR VPWR sky130_fd_sc_hd__decap_8
X_07520_ net547 _01648_ _01649_ VGND VGND VPWR VPWR _01650_ sky130_fd_sc_hd__o21ba_1
XFILLER_35_665 VGND VGND VPWR VPWR sky130_fd_sc_hd__decap_6
X_07451_ _01577_ _01585_ net549 VGND VGND VPWR VPWR _01586_ sky130_fd_sc_hd__mux2_1
XTAP_TAPCELL_ROW_122_2294 VGND VPWR sky130_fd_sc_hd__tapvpwrvgnd_1
XTAP_TAPCELL_ROW_122_2283 VGND VPWR sky130_fd_sc_hd__tapvpwrvgnd_1
XFILLER_90_793 VGND VGND VPWR VPWR sky130_fd_sc_hd__decap_3
X_07382_ net1404 net354 net238 VGND VGND VPWR VPWR _00412_ sky130_fd_sc_hd__mux2_1
XFILLER_34_197 VGND VGND VPWR VPWR sky130_fd_sc_hd__decap_8
X_09121_ _02825_ _02878_ _02879_ VGND VGND VPWR VPWR _02880_ sky130_fd_sc_hd__and3_1
XTAP_TAPCELL_ROW_98_1905 VGND VPWR sky130_fd_sc_hd__tapvpwrvgnd_1
XTAP_TAPCELL_ROW_33_866 VGND VPWR sky130_fd_sc_hd__tapvpwrvgnd_1
XFILLER_148_589 VGND VGND VPWR VPWR sky130_fd_sc_hd__decap_4
X_09052_ _02760_ _02809_ _02808_ _02806_ VGND VGND VPWR VPWR _02811_ sky130_fd_sc_hd__a211oi_1
X_08003_ net311 _01675_ _01866_ VGND VGND VPWR VPWR _01867_ sky130_fd_sc_hd__o21a_1
Xhold500 u_interface.fifo_data\[10\]\[24\] VGND VGND VPWR VPWR net1365 sky130_fd_sc_hd__dlygate4sd3_1
Xhold511 u_interface.fifo_data\[4\]\[25\] VGND VGND VPWR VPWR net1376 sky130_fd_sc_hd__dlygate4sd3_1
XFILLER_144_751 VGND VGND VPWR VPWR sky130_fd_sc_hd__fill_1
Xhold522 u_interface.fifo_data\[2\]\[29\] VGND VGND VPWR VPWR net1387 sky130_fd_sc_hd__dlygate4sd3_1
Xhold533 u_interface.u_gelu_fp32.u_synth_top.s1_hits\[15\] VGND VGND VPWR VPWR net1398
+ sky130_fd_sc_hd__dlygate4sd3_1
Xhold544 u_interface.fifo_data\[0\]\[25\] VGND VGND VPWR VPWR net1409 sky130_fd_sc_hd__dlygate4sd3_1
XFILLER_89_304 VPWR VGND VPWR VGND sky130_ef_sc_hd__decap_12
Xhold555 u_interface.u_gelu_fp32.u_fp32_to_q16.s1_mant\[17\] VGND VGND VPWR VPWR net1420
+ sky130_fd_sc_hd__dlygate4sd3_1
Xhold566 u_interface.u_gelu_fp32.u_fp32_to_q16.s1_sign VGND VGND VPWR VPWR net1431
+ sky130_fd_sc_hd__dlygate4sd3_1
XFILLER_143_261 VGND VGND VPWR VPWR sky130_fd_sc_hd__decap_4
XFILLER_89_337 VGND VGND VPWR VPWR sky130_fd_sc_hd__fill_2
Xhold588 u_interface.fifo_data\[12\]\[5\] VGND VGND VPWR VPWR net1453 sky130_fd_sc_hd__dlygate4sd3_1
Xhold577 u_interface.fifo_data\[5\]\[3\] VGND VGND VPWR VPWR net1442 sky130_fd_sc_hd__dlygate4sd3_1
XFILLER_143_294 VGND VGND VPWR VPWR sky130_fd_sc_hd__fill_1
Xhold599 u_interface.fifo_data\[13\]\[13\] VGND VGND VPWR VPWR net1464 sky130_fd_sc_hd__dlygate4sd3_1
XTAP_TAPCELL_ROW_129_2404 VGND VPWR sky130_fd_sc_hd__tapvpwrvgnd_1
X_09954_ net455 net631 net641 net459 VGND VGND VPWR VPWR _03707_ sky130_fd_sc_hd__a22o_1
X_08905_ net510 net697 VGND VGND VPWR VPWR _02664_ sky130_fd_sc_hd__nand2_1
XFILLER_103_169 VGND VGND VPWR VPWR sky130_fd_sc_hd__decap_8
X_09885_ net486 net705 net713 net491 VGND VGND VPWR VPWR _03638_ sky130_fd_sc_hd__a22o_1
XFILLER_58_735 VGND VGND VPWR VPWR sky130_fd_sc_hd__fill_1
X_08836_ _02580_ _02594_ VGND VGND VPWR VPWR _02595_ sky130_fd_sc_hd__nand2_1
XFILLER_58_757 VGND VGND VPWR VPWR sky130_fd_sc_hd__decap_3
XFILLER_57_223 VGND VGND VPWR VPWR sky130_fd_sc_hd__fill_1
XTAP_TAPCELL_ROW_142_2615 VGND VPWR sky130_fd_sc_hd__tapvpwrvgnd_1
XTAP_TAPCELL_ROW_142_2604 VGND VPWR sky130_fd_sc_hd__tapvpwrvgnd_1
XFILLER_73_727 VGND VGND VPWR VPWR sky130_fd_sc_hd__fill_1
XFILLER_72_204 VGND VGND VPWR VPWR sky130_fd_sc_hd__fill_2
XFILLER_45_407 VPWR VGND VPWR VGND sky130_ef_sc_hd__decap_12
X_08767_ _02523_ _02524_ _02525_ VGND VGND VPWR VPWR _02526_ sky130_fd_sc_hd__and3_1
XFILLER_73_749 VGND VGND VPWR VPWR sky130_fd_sc_hd__decap_3
X_08698_ net670 net511 VGND VGND VPWR VPWR _02457_ sky130_fd_sc_hd__nand2_1
X_07718_ u_interface.u_gelu_fp32.u_synth_top.s1_hits\[11\] net386 u_interface.u_gelu_fp32.u_synth_top.s1_hits\[1\]
+ VGND VGND VPWR VPWR _01770_ sky130_fd_sc_hd__or3_1
XFILLER_82_27 VGND VGND VPWR VPWR sky130_fd_sc_hd__fill_1
XFILLER_14_805 VGND VGND VPWR VPWR sky130_fd_sc_hd__decap_6
XFILLER_26_643 VGND VGND VPWR VPWR sky130_fd_sc_hd__fill_1
X_07649_ net803 net1703 net298 _01734_ VGND VGND VPWR VPWR _00480_ sky130_fd_sc_hd__a22o_1
XFILLER_13_304 VPWR VGND VPWR VGND sky130_ef_sc_hd__decap_12
XFILLER_14_849 VPWR VGND VPWR VGND sky130_ef_sc_hd__decap_12
XFILLER_25_164 VGND VGND VPWR VPWR sky130_fd_sc_hd__decap_4
X_10660_ _04397_ _04405_ _04406_ VGND VGND VPWR VPWR _04407_ sky130_fd_sc_hd__and3_1
XTAP_TAPCELL_ROW_62_1330 VGND VPWR sky130_fd_sc_hd__tapvpwrvgnd_1
XTAP_TAPCELL_ROW_45_1049 VGND VPWR sky130_fd_sc_hd__tapvpwrvgnd_1
XFILLER_13_337 VGND VGND VPWR VPWR sky130_fd_sc_hd__fill_2
X_09319_ _03049_ _03076_ _03077_ VGND VGND VPWR VPWR _03078_ sky130_fd_sc_hd__and3_1
XTAP_TAPCELL_ROW_11_505 VGND VPWR sky130_fd_sc_hd__tapvpwrvgnd_1
X_10591_ _04336_ _04337_ _04320_ VGND VGND VPWR VPWR _04338_ sky130_fd_sc_hd__a21o_1
XTAP_TAPCELL_ROW_11_516 VGND VPWR sky130_fd_sc_hd__tapvpwrvgnd_1
XFILLER_22_893 VPWR VGND VPWR VGND sky130_ef_sc_hd__decap_12
XFILLER_127_718 VGND VGND VPWR VPWR sky130_fd_sc_hd__fill_1
XFILLER_126_217 VGND VGND VPWR VPWR sky130_fd_sc_hd__fill_1
XFILLER_5_503 VGND VGND VPWR VPWR sky130_fd_sc_hd__fill_1
X_12330_ _06056_ _06057_ VGND VGND VPWR VPWR _06059_ sky130_fd_sc_hd__and2_1
XTAP_TAPCELL_ROW_153_2788 VGND VPWR sky130_fd_sc_hd__tapvpwrvgnd_1
XTAP_TAPCELL_ROW_153_2777 VGND VPWR sky130_fd_sc_hd__tapvpwrvgnd_1
X_12261_ _05988_ _05989_ VGND VGND VPWR VPWR _05991_ sky130_fd_sc_hd__xnor2_1
XFILLER_107_453 VGND VGND VPWR VPWR sky130_fd_sc_hd__decap_3
X_14000_ clknet_leaf_50_clk _00926_ VGND VGND VPWR VPWR u_interface.u_gelu_fp32.u_q16_to_fp32.s3_norm_mag\[27\]
+ sky130_fd_sc_hd__dfxtp_1
X_11212_ net677 net430 net425 net668 VGND VGND VPWR VPWR _04954_ sky130_fd_sc_hd__a22o_1
XFILLER_107_475 VPWR VGND VPWR VGND sky130_ef_sc_hd__decap_12
X_12192_ _05800_ _05856_ _05855_ VGND VGND VPWR VPWR _05923_ sky130_fd_sc_hd__a21o_1
X_11143_ _04740_ _04770_ _04769_ VGND VGND VPWR VPWR _04886_ sky130_fd_sc_hd__a21oi_1
XFILLER_1_753 VPWR VGND VPWR VGND sky130_ef_sc_hd__decap_12
XFILLER_122_489 VGND VGND VPWR VPWR sky130_fd_sc_hd__decap_4
XFILLER_89_893 VGND VGND VPWR VPWR sky130_fd_sc_hd__decap_3
X_11074_ net452 net456 net712 net719 VGND VGND VPWR VPWR _04817_ sky130_fd_sc_hd__nand4_1
XFILLER_103_692 VGND VGND VPWR VPWR sky130_fd_sc_hd__decap_3
X_10025_ _03774_ _03775_ _03648_ _03651_ VGND VGND VPWR VPWR _03777_ sky130_fd_sc_hd__o211a_1
XFILLER_76_543 VGND VGND VPWR VPWR sky130_fd_sc_hd__fill_1
XFILLER_1_797 VPWR VGND VPWR VGND sky130_ef_sc_hd__decap_12
XFILLER_37_919 VGND VGND VPWR VPWR sky130_fd_sc_hd__fill_2
XFILLER_91_535 VGND VGND VPWR VPWR sky130_fd_sc_hd__decap_8
XTAP_TAPCELL_ROW_19_638 VGND VPWR sky130_fd_sc_hd__tapvpwrvgnd_1
XFILLER_17_665 VGND VGND VPWR VPWR sky130_fd_sc_hd__decap_6
X_11976_ _05654_ _05709_ VGND VGND VPWR VPWR _05710_ sky130_fd_sc_hd__xor2_1
X_13715_ clknet_leaf_10_clk _00725_ VGND VGND VPWR VPWR u_interface.u_gelu_fp32.s1_data\[15\]
+ sky130_fd_sc_hd__dfxtp_1
X_10927_ _04667_ _04670_ VGND VGND VPWR VPWR _04672_ sky130_fd_sc_hd__nand2_1
XFILLER_16_153 VGND VGND VPWR VPWR sky130_fd_sc_hd__decap_6
XFILLER_32_613 VPWR VGND VPWR VGND sky130_ef_sc_hd__decap_12
X_13646_ clknet_leaf_45_clk _00656_ VGND VGND VPWR VPWR u_interface.fifo_data\[13\]\[29\]
+ sky130_fd_sc_hd__dfxtp_1
XFILLER_71_281 VGND VGND VPWR VPWR sky130_fd_sc_hd__decap_4
XFILLER_16_197 VGND VGND VPWR VPWR sky130_fd_sc_hd__decap_6
XFILLER_32_657 VPWR VGND VPWR VGND sky130_ef_sc_hd__decap_12
XFILLER_72_82 VGND VGND VPWR VPWR sky130_fd_sc_hd__fill_2
X_10858_ _04601_ _04602_ VGND VGND VPWR VPWR _04603_ sky130_fd_sc_hd__nor2_1
XTAP_TAPCELL_ROW_30_814 VGND VPWR sky130_fd_sc_hd__tapvpwrvgnd_1
XFILLER_31_145 VPWR VGND VPWR VGND sky130_ef_sc_hd__decap_12
X_13577_ clknet_leaf_46_clk _00587_ VGND VGND VPWR VPWR u_interface.fifo_data\[4\]\[24\]
+ sky130_fd_sc_hd__dfxtp_1
X_10789_ _04533_ _04534_ _04410_ _04413_ VGND VGND VPWR VPWR _04535_ sky130_fd_sc_hd__o211ai_2
XFILLER_9_853 VPWR VGND VPWR VGND sky130_ef_sc_hd__decap_12
XFILLER_31_178 VGND VGND VPWR VPWR sky130_fd_sc_hd__fill_1
XFILLER_9_897 VPWR VGND VPWR VGND sky130_ef_sc_hd__decap_12
X_12528_ _06135_ _06223_ VGND VGND VPWR VPWR _06252_ sky130_fd_sc_hd__and2_1
X_12459_ _06184_ VGND VGND VPWR VPWR _06185_ sky130_fd_sc_hd__inv_2
XTAP_TAPCELL_ROW_93_1824 VGND VPWR sky130_fd_sc_hd__tapvpwrvgnd_1
XFILLER_113_412 VPWR VGND VPWR VGND sky130_ef_sc_hd__decap_12
X_14129_ clknet_leaf_28_clk _01055_ VGND VGND VPWR VPWR u_interface.in_flight_count\[2\]
+ sky130_fd_sc_hd__dfxtp_1
Xfanout309 net312 VGND VGND VPWR VPWR net309 sky130_fd_sc_hd__clkbuf_2
XFILLER_113_434 VPWR VGND VPWR VGND sky130_ef_sc_hd__decap_12
XFILLER_99_657 VGND VGND VPWR VPWR sky130_fd_sc_hd__decap_4
XFILLER_98_123 VGND VGND VPWR VPWR sky130_fd_sc_hd__fill_1
XFILLER_113_489 VGND VGND VPWR VPWR sky130_fd_sc_hd__fill_1
XFILLER_98_189 VGND VGND VPWR VPWR sky130_fd_sc_hd__decap_6
XFILLER_97_90 VGND VGND VPWR VPWR sky130_fd_sc_hd__decap_8
X_06951_ _01480_ _01481_ VGND VGND VPWR VPWR _00027_ sky130_fd_sc_hd__xnor2_1
X_09670_ net601 net447 net441 net589 VGND VGND VPWR VPWR _03425_ sky130_fd_sc_hd__a22o_1
XTAP_TAPCELL_ROW_124_2312 VGND VPWR sky130_fd_sc_hd__tapvpwrvgnd_1
X_08621_ _02176_ _02238_ _02240_ VGND VGND VPWR VPWR _02396_ sky130_fd_sc_hd__nand3_1
X_06882_ u_interface.fifo_data\[4\]\[31\] u_interface.fifo_data\[5\]\[31\] u_interface.fifo_data\[6\]\[31\]
+ u_interface.fifo_data\[7\]\[31\] net756 net739 VGND VGND VPWR VPWR _01426_ sky130_fd_sc_hd__mux4_1
XTAP_TAPCELL_ROW_124_2323 VGND VPWR sky130_fd_sc_hd__tapvpwrvgnd_1
XFILLER_54_226 VGND VGND VPWR VPWR sky130_fd_sc_hd__decap_3
XTAP_TAPCELL_ROW_38_936 VGND VPWR sky130_fd_sc_hd__tapvpwrvgnd_1
XTAP_TAPCELL_ROW_38_947 VGND VPWR sky130_fd_sc_hd__tapvpwrvgnd_1
X_08552_ _02168_ _02342_ VGND VGND VPWR VPWR _02343_ sky130_fd_sc_hd__xnor2_1
X_07503_ _01634_ _01632_ net547 VGND VGND VPWR VPWR _01635_ sky130_fd_sc_hd__mux2_1
X_08483_ _02267_ _02269_ _02270_ _02273_ VGND VGND VPWR VPWR _02274_ sky130_fd_sc_hd__or4_1
X_07434_ net815 net1581 net301 _01569_ VGND VGND VPWR VPWR _00430_ sky130_fd_sc_hd__a22o_1
XTAP_TAPCELL_ROW_102_1975 VGND VPWR sky130_fd_sc_hd__tapvpwrvgnd_1
XTAP_TAPCELL_ROW_102_1964 VGND VPWR sky130_fd_sc_hd__tapvpwrvgnd_1
XFILLER_50_454 VPWR VGND VPWR VGND sky130_ef_sc_hd__decap_12
XFILLER_10_307 VGND VGND VPWR VPWR sky130_fd_sc_hd__fill_1
XFILLER_148_342 VPWR VGND VPWR VGND sky130_ef_sc_hd__decap_12
XPHY_EDGE_ROW_99_Left_255 VGND VGND VPWR VPWR sky130_fd_sc_hd__decap_3
X_07365_ net563 net1474 net241 VGND VGND VPWR VPWR _00395_ sky130_fd_sc_hd__mux2_1
X_09104_ _02859_ _02862_ _02808_ _02819_ VGND VGND VPWR VPWR _02863_ sky130_fd_sc_hd__a211o_1
XFILLER_109_729 VGND VGND VPWR VPWR sky130_fd_sc_hd__decap_4
XFILLER_109_718 VGND VGND VPWR VPWR sky130_fd_sc_hd__fill_1
X_07296_ net1292 net574 net246 VGND VGND VPWR VPWR _00326_ sky130_fd_sc_hd__mux2_1
X_09035_ _02742_ _02790_ _02789_ VGND VGND VPWR VPWR _02794_ sky130_fd_sc_hd__a21o_1
XFILLER_151_518 VGND VGND VPWR VPWR sky130_fd_sc_hd__decap_8
XTAP_TAPCELL_ROW_135_2496 VGND VPWR sky130_fd_sc_hd__tapvpwrvgnd_1
XFILLER_123_209 VPWR VGND VPWR VGND sky130_ef_sc_hd__decap_12
Xhold352 u_interface.u_gelu_fp32.u_fp32_to_q16.s3_is_zero VGND VGND VPWR VPWR net1217
+ sky130_fd_sc_hd__dlygate4sd3_1
Xhold341 u_interface.fifo_data\[12\]\[19\] VGND VGND VPWR VPWR net1206 sky130_fd_sc_hd__dlygate4sd3_1
XFILLER_117_34 VGND VGND VPWR VPWR sky130_fd_sc_hd__decap_6
Xhold330 u_interface.fifo_data\[15\]\[30\] VGND VGND VPWR VPWR net1195 sky130_fd_sc_hd__dlygate4sd3_1
Xhold385 u_interface.fifo_tuser\[10\] VGND VGND VPWR VPWR net1250 sky130_fd_sc_hd__dlygate4sd3_1
Xhold396 u_interface.fifo_data\[13\]\[19\] VGND VGND VPWR VPWR net1261 sky130_fd_sc_hd__dlygate4sd3_1
XFILLER_132_754 VGND VGND VPWR VPWR sky130_fd_sc_hd__fill_2
Xhold363 u_interface.fifo_data\[5\]\[23\] VGND VGND VPWR VPWR net1228 sky130_fd_sc_hd__dlygate4sd3_1
Xhold374 u_interface.fifo_data\[0\]\[15\] VGND VGND VPWR VPWR net1239 sky130_fd_sc_hd__dlygate4sd3_1
Xfanout821 net822 VGND VGND VPWR VPWR net821 sky130_fd_sc_hd__clkbuf_2
XFILLER_132_787 VGND VGND VPWR VPWR sky130_fd_sc_hd__fill_1
Xfanout810 net812 VGND VGND VPWR VPWR net810 sky130_fd_sc_hd__buf_2
X_09937_ net475 net681 net691 net479 VGND VGND VPWR VPWR _03690_ sky130_fd_sc_hd__a22o_1
XFILLER_89_167 VGND VGND VPWR VPWR sky130_fd_sc_hd__fill_1
XFILLER_77_329 VGND VGND VPWR VPWR sky130_fd_sc_hd__fill_1
XFILLER_77_38 VPWR VGND VPWR VGND sky130_ef_sc_hd__decap_12
X_09868_ _03620_ _03621_ _03505_ _03508_ VGND VGND VPWR VPWR _03622_ sky130_fd_sc_hd__o211a_1
XFILLER_85_362 VPWR VGND VPWR VGND sky130_ef_sc_hd__decap_12
XFILLER_73_502 VGND VGND VPWR VPWR sky130_fd_sc_hd__fill_2
X_08819_ _02559_ _02576_ _02577_ _02518_ VGND VGND VPWR VPWR _02578_ sky130_fd_sc_hd__a211oi_2
XFILLER_100_673 VGND VGND VPWR VPWR sky130_fd_sc_hd__decap_6
X_09799_ _03541_ _03550_ _03551_ VGND VGND VPWR VPWR _03553_ sky130_fd_sc_hd__and3_1
XFILLER_73_557 VGND VGND VPWR VPWR sky130_fd_sc_hd__decap_3
X_11830_ _05563_ _05564_ _05565_ VGND VGND VPWR VPWR _00831_ sky130_fd_sc_hd__o21ba_1
Xclkbuf_3_6__f_clk clknet_0_clk VGND VGND VPWR VPWR clknet_3_6__leaf_clk sky130_fd_sc_hd__clkbuf_16
XFILLER_54_782 VGND VGND VPWR VPWR sky130_fd_sc_hd__decap_3
XFILLER_14_613 VPWR VGND VPWR VGND sky130_ef_sc_hd__decap_12
XFILLER_26_53 VPWR VGND VPWR VGND sky130_ef_sc_hd__decap_12
X_11761_ net199 _05496_ VGND VGND VPWR VPWR _05497_ sky130_fd_sc_hd__and2_1
X_13500_ clknet_leaf_3_clk _00510_ VGND VGND VPWR VPWR u_interface.u_gelu_fp32.u_synth_top.s2_m\[11\]
+ sky130_fd_sc_hd__dfxtp_1
XFILLER_81_590 VPWR VGND VPWR VGND sky130_ef_sc_hd__decap_12
X_10712_ _04444_ _04454_ _04455_ VGND VGND VPWR VPWR _04458_ sky130_fd_sc_hd__nand3_1
XFILLER_53_281 VPWR VGND VPWR VGND sky130_ef_sc_hd__decap_12
XFILLER_14_657 VPWR VGND VPWR VGND sky130_ef_sc_hd__decap_12
XFILLER_26_97 VPWR VGND VPWR VGND sky130_ef_sc_hd__decap_12
XTAP_TAPCELL_ROW_155_2817 VGND VPWR sky130_fd_sc_hd__tapvpwrvgnd_1
XFILLER_9_105 VGND VGND VPWR VPWR sky130_fd_sc_hd__decap_6
XFILLER_13_167 VGND VGND VPWR VPWR sky130_fd_sc_hd__fill_1
X_11692_ _05358_ _05360_ _05359_ VGND VGND VPWR VPWR _05429_ sky130_fd_sc_hd__o21bai_1
XFILLER_41_465 VPWR VGND VPWR VGND sky130_ef_sc_hd__decap_12
XTAP_TAPCELL_ROW_155_2839 VGND VPWR sky130_fd_sc_hd__tapvpwrvgnd_1
XTAP_TAPCELL_ROW_155_2828 VGND VPWR sky130_fd_sc_hd__tapvpwrvgnd_1
X_13431_ clknet_leaf_18_clk _00441_ VGND VGND VPWR VPWR u_interface.u_gelu_fp32.u_fp32_to_q16.s3_mag\[2\]
+ sky130_fd_sc_hd__dfxtp_1
X_10643_ _04288_ _04387_ _04388_ VGND VGND VPWR VPWR _04390_ sky130_fd_sc_hd__nand3_4
XFILLER_9_149 VPWR VGND VPWR VGND sky130_ef_sc_hd__decap_12
XFILLER_155_813 VGND VGND VPWR VPWR sky130_fd_sc_hd__fill_2
X_13362_ clknet_leaf_41_clk _00372_ VGND VGND VPWR VPWR u_interface.fifo_data\[7\]\[7\]
+ sky130_fd_sc_hd__dfxtp_1
X_10574_ _04208_ _04210_ VGND VGND VPWR VPWR _04321_ sky130_fd_sc_hd__nand2_1
XFILLER_42_85 VGND VGND VPWR VPWR sky130_fd_sc_hd__fill_2
XFILLER_155_846 VGND VGND VPWR VPWR sky130_fd_sc_hd__decap_4
X_12313_ _06010_ _06041_ VGND VGND VPWR VPWR _06042_ sky130_fd_sc_hd__xnor2_1
XFILLER_142_507 VPWR VGND VPWR VGND sky130_ef_sc_hd__decap_12
XFILLER_6_867 VGND VGND VPWR VPWR sky130_fd_sc_hd__fill_1
XFILLER_5_344 VPWR VGND VPWR VGND sky130_ef_sc_hd__decap_12
X_13293_ clknet_leaf_74_clk _00303_ VGND VGND VPWR VPWR u_interface.fifo_data\[8\]\[2\]
+ sky130_fd_sc_hd__dfxtp_1
XTAP_TAPCELL_ROW_75_1543 VGND VPWR sky130_fd_sc_hd__tapvpwrvgnd_1
XTAP_TAPCELL_ROW_75_1532 VGND VPWR sky130_fd_sc_hd__tapvpwrvgnd_1
X_12244_ _05973_ _05972_ VGND VGND VPWR VPWR _05974_ sky130_fd_sc_hd__nand2b_1
X_12175_ _05888_ _05905_ VGND VGND VPWR VPWR _05906_ sky130_fd_sc_hd__xor2_1
X_11126_ net602 net396 VGND VGND VPWR VPWR _04869_ sky130_fd_sc_hd__nand2_1
XFILLER_1_561 VPWR VGND VPWR VGND sky130_ef_sc_hd__decap_12
XFILLER_110_448 VGND VGND VPWR VPWR sky130_fd_sc_hd__fill_2
XFILLER_110_426 VPWR VGND VPWR VGND sky130_ef_sc_hd__decap_12
XFILLER_77_841 VGND VGND VPWR VPWR sky130_fd_sc_hd__fill_2
XFILLER_77_830 VGND VGND VPWR VPWR sky130_fd_sc_hd__fill_1
XFILLER_3_57 VPWR VGND VPWR VGND sky130_ef_sc_hd__decap_12
X_11057_ _04798_ _04799_ VGND VGND VPWR VPWR _04800_ sky130_fd_sc_hd__nand2_1
XFILLER_67_93 VPWR VGND VPWR VGND sky130_ef_sc_hd__decap_12
XFILLER_49_554 VGND VGND VPWR VPWR sky130_fd_sc_hd__decap_6
XTAP_TAPCELL_ROW_106_2031 VGND VPWR sky130_fd_sc_hd__tapvpwrvgnd_1
X_10008_ _03639_ _03641_ VGND VGND VPWR VPWR _03760_ sky130_fd_sc_hd__nand2_1
XFILLER_37_749 VGND VGND VPWR VPWR sky130_fd_sc_hd__fill_1
XFILLER_64_546 VGND VGND VPWR VPWR sky130_fd_sc_hd__decap_8
X_11959_ _05604_ _05613_ _05612_ VGND VGND VPWR VPWR _05693_ sky130_fd_sc_hd__a21boi_1
XFILLER_80_3 VPWR VGND VPWR VGND sky130_ef_sc_hd__decap_12
X_13629_ clknet_leaf_66_clk _00639_ VGND VGND VPWR VPWR u_interface.fifo_data\[13\]\[12\]
+ sky130_fd_sc_hd__dfxtp_1
X_07150_ net1026 net340 net220 VGND VGND VPWR VPWR _00190_ sky130_fd_sc_hd__mux2_1
X_07081_ net1514 net384 net225 VGND VGND VPWR VPWR _00121_ sky130_fd_sc_hd__mux2_1
XFILLER_145_367 VGND VGND VPWR VPWR sky130_fd_sc_hd__fill_1
XFILLER_8_193 VGND VGND VPWR VPWR sky130_fd_sc_hd__decap_3
XFILLER_126_592 VGND VGND VPWR VPWR sky130_fd_sc_hd__fill_2
XFILLER_99_487 VGND VGND VPWR VPWR sky130_fd_sc_hd__decap_8
XFILLER_59_307 VPWR VGND VPWR VGND sky130_ef_sc_hd__decap_12
X_07983_ net308 net301 _01650_ _01853_ VGND VGND VPWR VPWR _00696_ sky130_fd_sc_hd__a31o_1
X_09722_ _03471_ _03475_ VGND VGND VPWR VPWR _03477_ sky130_fd_sc_hd__xnor2_1
XFILLER_87_638 VGND VGND VPWR VPWR sky130_fd_sc_hd__decap_8
X_06934_ u_interface.u_gelu_fp32.u_synth_top.s1_x\[24\] net275 VGND VGND VPWR VPWR
+ _01468_ sky130_fd_sc_hd__xnor2_1
X_09653_ _03407_ _03408_ _03266_ _03268_ VGND VGND VPWR VPWR _03409_ sky130_fd_sc_hd__o211a_1
X_06865_ u_interface.fifo_data\[0\]\[29\] u_interface.fifo_data\[1\]\[29\] u_interface.fifo_data\[2\]\[29\]
+ u_interface.fifo_data\[3\]\[29\] net766 net749 VGND VGND VPWR VPWR _01411_ sky130_fd_sc_hd__mux4_1
XFILLER_67_373 VGND VGND VPWR VPWR sky130_fd_sc_hd__decap_8
XFILLER_28_749 VGND VGND VPWR VPWR sky130_fd_sc_hd__decap_6
X_09584_ _03337_ _03338_ _03339_ VGND VGND VPWR VPWR _03340_ sky130_fd_sc_hd__a21oi_1
XFILLER_82_354 VGND VGND VPWR VPWR sky130_fd_sc_hd__fill_1
X_08604_ _02187_ _02188_ VGND VGND VPWR VPWR _02384_ sky130_fd_sc_hd__and2b_1
XFILLER_55_557 VGND VGND VPWR VPWR sky130_fd_sc_hd__decap_3
XTAP_TAPCELL_ROW_2_369 VGND VPWR sky130_fd_sc_hd__tapvpwrvgnd_1
XPHY_EDGE_ROW_118_Right_118 VGND VGND VPWR VPWR sky130_fd_sc_hd__decap_3
XFILLER_82_365 VGND VGND VPWR VPWR sky130_fd_sc_hd__fill_1
X_06796_ _01346_ _01347_ _01350_ net316 VGND VGND VPWR VPWR net121 sky130_fd_sc_hd__a22o_1
X_08535_ _02162_ _02316_ VGND VGND VPWR VPWR _02326_ sky130_fd_sc_hd__xor2_1
XFILLER_35_281 VGND VGND VPWR VPWR sky130_fd_sc_hd__decap_3
X_08466_ _02170_ _02256_ VGND VGND VPWR VPWR _02257_ sky130_fd_sc_hd__nand2_1
XTAP_TAPCELL_ROW_42_1008 VGND VPWR sky130_fd_sc_hd__tapvpwrvgnd_1
XTAP_TAPCELL_ROW_137_2525 VGND VPWR sky130_fd_sc_hd__tapvpwrvgnd_1
X_07417_ _01552_ VGND VGND VPWR VPWR _01553_ sky130_fd_sc_hd__inv_2
X_08397_ u_interface.u_gelu_fp32.u_synth_top.s3_mult\[27\] u_interface.u_gelu_fp32.u_synth_top.s3_b\[11\]
+ VGND VGND VPWR VPWR _02188_ sky130_fd_sc_hd__nand2_1
X_07348_ net358 net1459 net243 VGND VGND VPWR VPWR _00378_ sky130_fd_sc_hd__mux2_1
XFILLER_7_609 VGND VGND VPWR VPWR sky130_fd_sc_hd__decap_6
XFILLER_148_161 VGND VGND VPWR VPWR sky130_fd_sc_hd__fill_1
XTAP_TAPCELL_ROW_21_666 VGND VPWR sky130_fd_sc_hd__tapvpwrvgnd_1
XTAP_TAPCELL_ROW_21_677 VGND VPWR sky130_fd_sc_hd__tapvpwrvgnd_1
XTAP_TAPCELL_ROW_150_2736 VGND VPWR sky130_fd_sc_hd__tapvpwrvgnd_1
XFILLER_12_77 VGND VGND VPWR VPWR sky130_fd_sc_hd__decap_6
X_07279_ net1320 net368 net245 VGND VGND VPWR VPWR _00309_ sky130_fd_sc_hd__mux2_1
X_09018_ _02770_ _02776_ VGND VGND VPWR VPWR _02777_ sky130_fd_sc_hd__nand2b_1
XFILLER_136_389 VGND VGND VPWR VPWR sky130_fd_sc_hd__decap_8
X_10290_ _03924_ _04039_ VGND VGND VPWR VPWR _04040_ sky130_fd_sc_hd__and2_1
Xhold171 u_interface.fifo_data\[8\]\[28\] VGND VGND VPWR VPWR net1036 sky130_fd_sc_hd__dlygate4sd3_1
XFILLER_151_337 VPWR VGND VPWR VGND sky130_ef_sc_hd__decap_12
Xhold160 u_interface.fifo_data\[5\]\[27\] VGND VGND VPWR VPWR net1025 sky130_fd_sc_hd__dlygate4sd3_1
XTAP_TAPCELL_ROW_57_1251 VGND VPWR sky130_fd_sc_hd__tapvpwrvgnd_1
XTAP_TAPCELL_ROW_57_1240 VGND VPWR sky130_fd_sc_hd__tapvpwrvgnd_1
XFILLER_104_253 VGND VGND VPWR VPWR sky130_fd_sc_hd__decap_6
Xhold193 u_interface.fifo_data\[13\]\[25\] VGND VGND VPWR VPWR net1058 sky130_fd_sc_hd__dlygate4sd3_1
Xhold182 u_interface.u_gelu_fp32.u_q16_to_fp32.s1_mag\[16\] VGND VGND VPWR VPWR net1047
+ sky130_fd_sc_hd__dlygate4sd3_1
Xfanout640 net641 VGND VGND VPWR VPWR net640 sky130_fd_sc_hd__clkbuf_2
XFILLER_77_137 VPWR VGND VPWR VGND sky130_ef_sc_hd__decap_12
XTAP_TAPCELL_ROW_70_1451 VGND VPWR sky130_fd_sc_hd__tapvpwrvgnd_1
Xfanout651 u_interface.u_gelu_fp32.u_synth_top.s2_m\[9\] VGND VGND VPWR VPWR net651
+ sky130_fd_sc_hd__dlymetal6s2s_1
XTAP_TAPCELL_ROW_148_2698 VGND VPWR sky130_fd_sc_hd__tapvpwrvgnd_1
Xfanout662 net665 VGND VGND VPWR VPWR net662 sky130_fd_sc_hd__buf_2
Xfanout673 net674 VGND VGND VPWR VPWR net673 sky130_fd_sc_hd__buf_2
XTAP_TAPCELL_ROW_70_1462 VGND VPWR sky130_fd_sc_hd__tapvpwrvgnd_1
XFILLER_59_874 VGND VGND VPWR VPWR sky130_fd_sc_hd__decap_6
X_13980_ clknet_leaf_84_clk net1691 VGND VGND VPWR VPWR u_interface.u_gelu_fp32.u_q16_to_fp32.s2_mag\[25\]
+ sky130_fd_sc_hd__dfxtp_1
Xfanout684 u_interface.u_gelu_fp32.u_synth_top.s2_m\[13\] VGND VGND VPWR VPWR net684
+ sky130_fd_sc_hd__buf_2
X_12931_ _06454_ _06455_ VGND VGND VPWR VPWR _06456_ sky130_fd_sc_hd__xnor2_1
XFILLER_100_470 VGND VGND VPWR VPWR sky130_fd_sc_hd__decap_6
XFILLER_74_822 VGND VGND VPWR VPWR sky130_fd_sc_hd__fill_1
XFILLER_74_811 VGND VGND VPWR VPWR sky130_fd_sc_hd__fill_1
Xfanout695 net700 VGND VGND VPWR VPWR net695 sky130_fd_sc_hd__buf_2
XFILLER_19_727 VGND VGND VPWR VPWR sky130_fd_sc_hd__fill_1
X_12862_ net1614 u_interface.u_gelu_fp32.u_fp32_to_q16.s2_norm_mag\[17\] net819 VGND
+ VGND VPWR VPWR _01006_ sky130_fd_sc_hd__mux2_1
XFILLER_74_877 VGND VGND VPWR VPWR sky130_fd_sc_hd__fill_1
XFILLER_73_354 VPWR VGND VPWR VGND sky130_ef_sc_hd__decap_12
X_11813_ _05412_ _05463_ _05462_ VGND VGND VPWR VPWR _05549_ sky130_fd_sc_hd__a21oi_1
X_12793_ u_interface.u_gelu_fp32.u_q16_to_fp32.s3_norm_mag\[25\] _01786_ net295 VGND
+ VGND VPWR VPWR _06413_ sky130_fd_sc_hd__o21ai_1
XFILLER_14_421 VPWR VGND VPWR VGND sky130_ef_sc_hd__decap_12
XFILLER_26_270 VGND VGND VPWR VPWR sky130_fd_sc_hd__decap_4
XTAP_TAPCELL_ROW_29_799 VGND VPWR sky130_fd_sc_hd__tapvpwrvgnd_1
XFILLER_53_51 VGND VGND VPWR VPWR sky130_fd_sc_hd__decap_4
X_11744_ _05304_ _05305_ _05314_ _05396_ VGND VGND VPWR VPWR _05481_ sky130_fd_sc_hd__o22a_1
XFILLER_41_240 VGND VGND VPWR VPWR sky130_fd_sc_hd__fill_2
X_11675_ _05406_ _05411_ VGND VGND VPWR VPWR _05412_ sky130_fd_sc_hd__xnor2_1
X_13414_ clknet_leaf_66_clk _00424_ VGND VGND VPWR VPWR u_interface.fifo_data\[6\]\[27\]
+ sky130_fd_sc_hd__dfxtp_1
X_10626_ _04271_ _04273_ VGND VGND VPWR VPWR _04373_ sky130_fd_sc_hd__nand2_1
XFILLER_128_824 VGND VGND VPWR VPWR sky130_fd_sc_hd__decap_3
XTAP_TAPCELL_ROW_40_975 VGND VPWR sky130_fd_sc_hd__tapvpwrvgnd_1
XFILLER_155_643 VGND VGND VPWR VPWR sky130_fd_sc_hd__fill_1
X_13345_ clknet_leaf_36_clk _00355_ VGND VGND VPWR VPWR u_interface.fifo_data\[10\]\[22\]
+ sky130_fd_sc_hd__dfxtp_1
XFILLER_127_334 VGND VGND VPWR VPWR sky130_fd_sc_hd__fill_2
X_10557_ _04303_ _04304_ _04180_ _04182_ VGND VGND VPWR VPWR _04305_ sky130_fd_sc_hd__a211oi_1
XFILLER_10_693 VGND VGND VPWR VPWR sky130_fd_sc_hd__decap_6
XFILLER_127_389 VGND VGND VPWR VPWR sky130_fd_sc_hd__decap_3
XFILLER_115_529 VPWR VGND VPWR VGND sky130_ef_sc_hd__decap_12
X_13276_ clknet_leaf_49_clk _00286_ VGND VGND VPWR VPWR u_interface.fifo_data\[0\]\[18\]
+ sky130_fd_sc_hd__dfxtp_1
X_10488_ _04231_ _04232_ _04233_ VGND VGND VPWR VPWR _04236_ sky130_fd_sc_hd__and3_1
XFILLER_154_197 VGND VGND VPWR VPWR sky130_fd_sc_hd__fill_1
X_12227_ _05890_ _05956_ net717 VGND VGND VPWR VPWR _05957_ sky130_fd_sc_hd__and3b_1
XFILLER_150_381 VPWR VGND VPWR VGND sky130_ef_sc_hd__decap_12
X_12158_ net717 net401 net397 net709 VGND VGND VPWR VPWR _05889_ sky130_fd_sc_hd__a22o_1
XTAP_TAPCELL_ROW_9_480 VGND VPWR sky130_fd_sc_hd__tapvpwrvgnd_1
XFILLER_2_881 VPWR VGND VPWR VGND sky130_ef_sc_hd__decap_12
XFILLER_111_757 VGND VGND VPWR VPWR sky130_fd_sc_hd__fill_2
XFILLER_84_619 VGND VGND VPWR VPWR sky130_fd_sc_hd__fill_2
X_11109_ net617 net408 _04755_ _04753_ VGND VGND VPWR VPWR _04852_ sky130_fd_sc_hd__a31o_1
XFILLER_1_391 VGND VGND VPWR VPWR sky130_fd_sc_hd__fill_1
X_12089_ _05815_ _05820_ VGND VGND VPWR VPWR _05821_ sky130_fd_sc_hd__xnor2_1
XTAP_TAPCELL_ROW_88_1745 VGND VPWR sky130_fd_sc_hd__tapvpwrvgnd_1
XFILLER_76_181 VGND VGND VPWR VPWR sky130_fd_sc_hd__decap_4
X_06650_ u_interface.fifo_data\[4\]\[2\] u_interface.fifo_data\[5\]\[2\] u_interface.fifo_data\[6\]\[2\]
+ u_interface.fifo_data\[7\]\[2\] net758 net741 VGND VGND VPWR VPWR _01223_ sky130_fd_sc_hd__mux4_1
XFILLER_65_888 VGND VGND VPWR VPWR sky130_fd_sc_hd__decap_8
XFILLER_64_365 VPWR VGND VPWR VGND sky130_ef_sc_hd__decap_12
X_06581_ u_interface.u_gelu_fp32.s1_data\[27\] u_interface.u_gelu_fp32.s1_data\[26\]
+ u_interface.u_gelu_fp32.s1_data\[25\] VGND VGND VPWR VPWR _01169_ sky130_fd_sc_hd__and3_1
XFILLER_92_696 VGND VGND VPWR VPWR sky130_fd_sc_hd__decap_4
XFILLER_80_869 VGND VGND VPWR VPWR sky130_fd_sc_hd__decap_6
XFILLER_18_793 VPWR VGND VPWR VGND sky130_ef_sc_hd__decap_12
X_08320_ net530 _02122_ net1655 VGND VGND VPWR VPWR _02123_ sky130_fd_sc_hd__a21oi_1
XFILLER_33_741 VPWR VGND VPWR VGND sky130_ef_sc_hd__decap_12
X_08251_ u_interface.u_gelu_fp32.s2_data\[1\] u_interface.u_gelu_fp32.s2_data\[0\]
+ net533 VGND VGND VPWR VPWR _02072_ sky130_fd_sc_hd__o21a_1
XFILLER_33_785 VPWR VGND VPWR VGND sky130_ef_sc_hd__decap_12
X_07202_ net364 net1497 net260 VGND VGND VPWR VPWR _00242_ sky130_fd_sc_hd__mux2_1
XTAP_TAPCELL_ROW_119_2244 VGND VPWR sky130_fd_sc_hd__tapvpwrvgnd_1
XTAP_TAPCELL_ROW_119_2233 VGND VPWR sky130_fd_sc_hd__tapvpwrvgnd_1
X_08182_ net290 _02017_ VGND VGND VPWR VPWR _00731_ sky130_fd_sc_hd__nor2_1
XFILLER_20_468 VGND VGND VPWR VPWR sky130_fd_sc_hd__fill_1
XFILLER_106_507 VGND VGND VPWR VPWR sky130_fd_sc_hd__fill_2
X_07133_ net1127 net375 net218 VGND VGND VPWR VPWR _00173_ sky130_fd_sc_hd__mux2_1
XTAP_TAPCELL_ROW_132_2455 VGND VPWR sky130_fd_sc_hd__tapvpwrvgnd_1
XFILLER_133_326 VGND VGND VPWR VPWR sky130_fd_sc_hd__decap_3
XTAP_TAPCELL_ROW_132_2444 VGND VPWR sky130_fd_sc_hd__tapvpwrvgnd_1
XFILLER_118_389 VGND VGND VPWR VPWR sky130_fd_sc_hd__decap_3
X_07064_ net1443 net355 net208 VGND VGND VPWR VPWR _00104_ sky130_fd_sc_hd__mux2_1
XPHY_EDGE_ROW_12_Right_12 VGND VGND VPWR VPWR sky130_fd_sc_hd__decap_3
XFILLER_99_295 VGND VGND VPWR VPWR sky130_fd_sc_hd__decap_3
XFILLER_99_273 VGND VGND VPWR VPWR sky130_fd_sc_hd__decap_6
X_07966_ net546 _01645_ _01838_ _01680_ net542 VGND VGND VPWR VPWR _01845_ sky130_fd_sc_hd__a32o_1
X_09705_ _03445_ _03457_ _03458_ VGND VGND VPWR VPWR _03460_ sky130_fd_sc_hd__nor3_2
XFILLER_101_278 VGND VGND VPWR VPWR sky130_fd_sc_hd__fill_2
X_06917_ _01453_ _01454_ _01452_ VGND VGND VPWR VPWR _01455_ sky130_fd_sc_hd__a21oi_1
XFILLER_74_129 VGND VGND VPWR VPWR sky130_fd_sc_hd__decap_3
XTAP_TAPCELL_ROW_52_1170 VGND VPWR sky130_fd_sc_hd__tapvpwrvgnd_1
X_09636_ _03390_ _03391_ _03381_ VGND VGND VPWR VPWR _03392_ sky130_fd_sc_hd__a21oi_1
XFILLER_95_490 VGND VGND VPWR VPWR sky130_fd_sc_hd__decap_4
XFILLER_28_557 VPWR VGND VPWR VGND sky130_ef_sc_hd__decap_12
X_07897_ net1283 net561 net265 VGND VGND VPWR VPWR _00658_ sky130_fd_sc_hd__mux2_1
X_06848_ net321 _01395_ net726 VGND VGND VPWR VPWR _01396_ sky130_fd_sc_hd__o21a_1
XFILLER_55_354 VGND VGND VPWR VPWR sky130_fd_sc_hd__fill_2
XPHY_EDGE_ROW_21_Right_21 VGND VGND VPWR VPWR sky130_fd_sc_hd__decap_3
X_09567_ _03320_ _03322_ _03323_ VGND VGND VPWR VPWR _00810_ sky130_fd_sc_hd__o21a_1
X_06779_ _01334_ _01335_ net731 VGND VGND VPWR VPWR _01336_ sky130_fd_sc_hd__mux2_1
XTAP_TAPCELL_ROW_26_747 VGND VPWR sky130_fd_sc_hd__tapvpwrvgnd_1
X_09498_ _03253_ _03254_ _03244_ VGND VGND VPWR VPWR _03255_ sky130_fd_sc_hd__a21oi_1
XFILLER_90_27 VGND VGND VPWR VPWR sky130_fd_sc_hd__fill_1
XFILLER_70_357 VGND VGND VPWR VPWR sky130_fd_sc_hd__fill_1
X_08518_ u_interface.u_gelu_fp32.u_synth_top.s3_mult\[55\] u_interface.u_gelu_fp32.u_synth_top.s3_mult\[54\]
+ net524 VGND VGND VPWR VPWR _02309_ sky130_fd_sc_hd__o21ai_1
XTAP_TAPCELL_ROW_26_758 VGND VPWR sky130_fd_sc_hd__tapvpwrvgnd_1
X_08449_ _02183_ _02234_ _02239_ _02182_ _02181_ VGND VGND VPWR VPWR _02240_ sky130_fd_sc_hd__a2111o_1
XFILLER_139_54 VGND VGND VPWR VPWR sky130_fd_sc_hd__fill_2
XFILLER_139_32 VGND VGND VPWR VPWR sky130_fd_sc_hd__fill_1
XFILLER_128_3 VGND VGND VPWR VPWR sky130_fd_sc_hd__decap_3
X_11460_ _05044_ _05101_ _05100_ VGND VGND VPWR VPWR _05200_ sky130_fd_sc_hd__a21oi_1
XFILLER_11_468 VGND VGND VPWR VPWR sky130_fd_sc_hd__fill_1
XFILLER_136_131 VGND VGND VPWR VPWR sky130_fd_sc_hd__decap_4
X_10411_ net609 net618 net432 net427 VGND VGND VPWR VPWR _04160_ sky130_fd_sc_hd__nand4_1
X_11391_ _05046_ _05048_ _05047_ VGND VGND VPWR VPWR _05131_ sky130_fd_sc_hd__o21ba_1
XPHY_EDGE_ROW_30_Right_30 VGND VGND VPWR VPWR sky130_fd_sc_hd__decap_3
XFILLER_136_175 VGND VGND VPWR VPWR sky130_fd_sc_hd__decap_4
X_13130_ clknet_leaf_43_clk _00140_ VGND VGND VPWR VPWR u_interface.fifo_data\[2\]\[19\]
+ sky130_fd_sc_hd__dfxtp_1
X_10342_ net277 _03869_ _04089_ VGND VGND VPWR VPWR _04091_ sky130_fd_sc_hd__nand3_1
XFILLER_136_197 VGND VGND VPWR VPWR sky130_fd_sc_hd__decap_4
XFILLER_136_186 VGND VGND VPWR VPWR sky130_fd_sc_hd__fill_2
X_13061_ clknet_leaf_42_clk _00071_ VGND VGND VPWR VPWR u_interface.fifo_data\[14\]\[14\]
+ sky130_fd_sc_hd__dfxtp_1
X_10273_ _04017_ _04020_ _04021_ VGND VGND VPWR VPWR _04023_ sky130_fd_sc_hd__nand3_1
XFILLER_2_133 VGND VGND VPWR VPWR sky130_fd_sc_hd__decap_6
X_12012_ _05743_ _05744_ VGND VGND VPWR VPWR _05745_ sky130_fd_sc_hd__and2_2
XFILLER_155_97 VGND VGND VPWR VPWR sky130_fd_sc_hd__fill_2
XFILLER_2_177 VPWR VGND VPWR VGND sky130_ef_sc_hd__decap_12
XFILLER_78_457 VGND VGND VPWR VPWR sky130_fd_sc_hd__fill_1
Xfanout492 net494 VGND VGND VPWR VPWR net492 sky130_fd_sc_hd__buf_2
Xfanout481 u_interface.u_gelu_fp32.u_synth_top.s2_dx\[9\] VGND VGND VPWR VPWR net481
+ sky130_fd_sc_hd__buf_2
Xfanout470 net471 VGND VGND VPWR VPWR net470 sky130_fd_sc_hd__buf_2
XFILLER_59_682 VGND VGND VPWR VPWR sky130_fd_sc_hd__decap_4
X_13963_ clknet_leaf_59_clk net1198 VGND VGND VPWR VPWR u_interface.u_gelu_fp32.u_q16_to_fp32.s2_mag\[8\]
+ sky130_fd_sc_hd__dfxtp_1
XFILLER_74_652 VGND VGND VPWR VPWR sky130_fd_sc_hd__decap_6
Xclkbuf_leaf_85_clk clknet_3_4__leaf_clk VGND VGND VPWR VPWR clknet_leaf_85_clk sky130_fd_sc_hd__clkbuf_8
X_12914_ u_interface.in_flight_count\[0\] _06441_ net828 VGND VGND VPWR VPWR _06442_
+ sky130_fd_sc_hd__a21oi_1
XFILLER_73_140 VPWR VGND VPWR VGND sky130_ef_sc_hd__decap_12
X_13894_ clknet_leaf_90_clk _00030_ VGND VGND VPWR VPWR u_interface.u_gelu_fp32.u_synth_top.s2_dx\[30\]
+ sky130_fd_sc_hd__dfxtp_1
XFILLER_46_365 VPWR VGND VPWR VGND sky130_ef_sc_hd__decap_12
XFILLER_0_69 VPWR VGND VPWR VGND sky130_ef_sc_hd__decap_12
X_12845_ net42 net41 net44 net43 VGND VGND VPWR VPWR _06427_ sky130_fd_sc_hd__or4_1
XFILLER_74_696 VGND VGND VPWR VPWR sky130_fd_sc_hd__decap_4
XFILLER_46_387 VGND VGND VPWR VPWR sky130_fd_sc_hd__fill_1
XTAP_TAPCELL_ROW_83_1664 VGND VPWR sky130_fd_sc_hd__tapvpwrvgnd_1
X_12776_ _01781_ _06404_ VGND VGND VPWR VPWR _00948_ sky130_fd_sc_hd__nor2_1
XFILLER_64_83 VGND VGND VPWR VPWR sky130_fd_sc_hd__fill_1
XFILLER_15_741 VPWR VGND VPWR VGND sky130_ef_sc_hd__decap_12
XFILLER_61_379 VGND VGND VPWR VPWR sky130_fd_sc_hd__fill_1
XFILLER_15_785 VPWR VGND VPWR VGND sky130_ef_sc_hd__decap_12
X_11727_ _05412_ _05463_ VGND VGND VPWR VPWR _05464_ sky130_fd_sc_hd__xor2_1
XFILLER_30_755 VGND VGND VPWR VPWR sky130_fd_sc_hd__fill_1
XFILLER_80_93 VGND VGND VPWR VPWR sky130_fd_sc_hd__fill_2
X_11658_ net193 _05395_ VGND VGND VPWR VPWR _05396_ sky130_fd_sc_hd__xnor2_1
XFILLER_155_440 VGND VGND VPWR VPWR sky130_fd_sc_hd__decap_4
X_10609_ net460 net695 _04354_ _04355_ VGND VGND VPWR VPWR _04356_ sky130_fd_sc_hd__a22o_1
X_11589_ _05321_ _05325_ VGND VGND VPWR VPWR _05327_ sky130_fd_sc_hd__xnor2_1
Xhold907 u_interface.u_gelu_fp32.u_synth_top.s2_b\[12\] VGND VGND VPWR VPWR net1772
+ sky130_fd_sc_hd__dlygate4sd3_1
Xhold918 u_interface.u_gelu_fp32.u_q16_to_fp32.s3_norm_mag\[8\] VGND VGND VPWR VPWR
+ net1783 sky130_fd_sc_hd__dlygate4sd3_1
X_13328_ clknet_leaf_70_clk _00338_ VGND VGND VPWR VPWR u_interface.fifo_data\[10\]\[5\]
+ sky130_fd_sc_hd__dfxtp_1
XFILLER_6_450 VGND VGND VPWR VPWR sky130_fd_sc_hd__fill_2
XFILLER_143_635 VGND VGND VPWR VPWR sky130_fd_sc_hd__fill_1
XTAP_TAPCELL_ROW_114_2163 VGND VPWR sky130_fd_sc_hd__tapvpwrvgnd_1
XTAP_TAPCELL_ROW_114_2152 VGND VPWR sky130_fd_sc_hd__tapvpwrvgnd_1
XFILLER_130_307 VGND VGND VPWR VPWR sky130_fd_sc_hd__fill_1
X_13259_ clknet_leaf_54_clk _00269_ VGND VGND VPWR VPWR u_interface.fifo_data\[0\]\[1\]
+ sky130_fd_sc_hd__dfxtp_1
XFILLER_43_3 VPWR VGND VPWR VGND sky130_ef_sc_hd__decap_12
XFILLER_142_178 VGND VGND VPWR VPWR sky130_fd_sc_hd__decap_6
XFILLER_123_381 VGND VGND VPWR VPWR sky130_fd_sc_hd__decap_6
XFILLER_97_733 VGND VGND VPWR VPWR sky130_fd_sc_hd__fill_1
XFILLER_96_221 VGND VGND VPWR VPWR sky130_fd_sc_hd__decap_6
X_07820_ net1348 net348 net232 VGND VGND VPWR VPWR _00581_ sky130_fd_sc_hd__mux2_1
X_07751_ u_interface.u_gelu_fp32.u_q16_to_fp32.s3_exp\[0\] u_interface.u_gelu_fp32.u_q16_to_fp32.s3_exp\[1\]
+ _01790_ VGND VGND VPWR VPWR _01794_ sky130_fd_sc_hd__and3_1
XFILLER_96_276 VGND VGND VPWR VPWR sky130_fd_sc_hd__decap_4
XFILLER_38_811 VGND VGND VPWR VPWR sky130_fd_sc_hd__fill_1
X_06702_ net730 _01267_ VGND VGND VPWR VPWR _01268_ sky130_fd_sc_hd__or2_1
Xclkbuf_leaf_76_clk clknet_3_4__leaf_clk VGND VGND VPWR VPWR clknet_leaf_76_clk sky130_fd_sc_hd__clkbuf_8
XFILLER_38_833 VGND VGND VPWR VPWR sky130_fd_sc_hd__fill_1
X_07682_ u_interface.u_gelu_fp32.u_synth_top.s1_hits\[13\] _01756_ VGND VGND VPWR
+ VPWR _01757_ sky130_fd_sc_hd__or2_1
XFILLER_37_376 VGND VGND VPWR VPWR sky130_fd_sc_hd__decap_4
X_09421_ _03177_ _03178_ VGND VGND VPWR VPWR _03179_ sky130_fd_sc_hd__nor2_1
XFILLER_92_493 VPWR VGND VPWR VGND sky130_ef_sc_hd__decap_12
XFILLER_92_482 VGND VGND VPWR VPWR sky130_fd_sc_hd__decap_6
XFILLER_64_173 VGND VGND VPWR VPWR sky130_fd_sc_hd__fill_2
X_06633_ u_interface.fifo_data\[0\]\[0\] u_interface.fifo_data\[1\]\[0\] u_interface.fifo_data\[2\]\[0\]
+ u_interface.fifo_data\[3\]\[0\] net756 net739 VGND VGND VPWR VPWR _01208_ sky130_fd_sc_hd__mux4_1
X_09352_ _03026_ _03027_ VGND VGND VPWR VPWR _03111_ sky130_fd_sc_hd__and2_1
X_06564_ u_interface.u_gelu_fp32.s1_data\[14\] _01155_ u_interface.u_gelu_fp32.s1_data\[17\]
+ net537 _01137_ VGND VGND VPWR VPWR _01158_ sky130_fd_sc_hd__a2111o_1
XFILLER_52_346 VPWR VGND VPWR VGND sky130_ef_sc_hd__decap_12
XFILLER_80_699 VGND VGND VPWR VPWR sky130_fd_sc_hd__fill_1
X_08303_ u_interface.u_gelu_fp32.s2_data\[15\] _02107_ VGND VGND VPWR VPWR _02110_
+ sky130_fd_sc_hd__or2_1
XTAP_TAPCELL_ROW_23_706 VGND VPWR sky130_fd_sc_hd__tapvpwrvgnd_1
X_09283_ _03039_ _03040_ _03038_ VGND VGND VPWR VPWR _03042_ sky130_fd_sc_hd__a21oi_1
X_08234_ _02058_ _02060_ _02061_ VGND VGND VPWR VPWR _00739_ sky130_fd_sc_hd__a21boi_1
XFILLER_21_777 VGND VGND VPWR VPWR sky130_fd_sc_hd__decap_6
X_08165_ _01886_ _02002_ VGND VGND VPWR VPWR _02003_ sky130_fd_sc_hd__nand2b_1
XFILLER_109_13 VGND VGND VPWR VPWR sky130_fd_sc_hd__fill_2
X_07116_ net324 net1349 net260 VGND VGND VPWR VPWR _00156_ sky130_fd_sc_hd__mux2_1
XFILLER_134_624 VGND VGND VPWR VPWR sky130_fd_sc_hd__decap_4
XFILLER_114_9 VGND VGND VPWR VPWR sky130_fd_sc_hd__fill_1
XFILLER_109_46 VGND VGND VPWR VPWR sky130_fd_sc_hd__fill_1
XFILLER_134_635 VGND VGND VPWR VPWR sky130_fd_sc_hd__decap_8
Xclkload80 clknet_leaf_45_clk VGND VGND VPWR VPWR clkload80/Y sky130_fd_sc_hd__clkinvlp_4
X_08096_ net168 _01944_ _01945_ net164 VGND VGND VPWR VPWR _01946_ sky130_fd_sc_hd__a31oi_1
XFILLER_109_57 VPWR VGND VPWR VGND sky130_ef_sc_hd__decap_12
X_07047_ net1119 net564 net270 VGND VGND VPWR VPWR _00087_ sky130_fd_sc_hd__mux2_1
XFILLER_130_830 VGND VGND VPWR VPWR sky130_fd_sc_hd__decap_8
X_08998_ _02599_ _02628_ _02627_ VGND VGND VPWR VPWR _02757_ sky130_fd_sc_hd__a21oi_1
XTAP_TAPCELL_ROW_50_1129 VGND VPWR sky130_fd_sc_hd__tapvpwrvgnd_1
XTAP_TAPCELL_ROW_145_2657 VGND VPWR sky130_fd_sc_hd__tapvpwrvgnd_1
X_07949_ net774 _01825_ _01837_ _01835_ VGND VGND VPWR VPWR _00678_ sky130_fd_sc_hd__a31o_1
XFILLER_91_909 VGND VGND VPWR VPWR sky130_fd_sc_hd__decap_4
Xclkbuf_leaf_67_clk clknet_3_7__leaf_clk VGND VGND VPWR VPWR clknet_leaf_67_clk sky130_fd_sc_hd__clkbuf_8
XFILLER_29_833 VGND VGND VPWR VPWR sky130_fd_sc_hd__decap_6
XFILLER_141_55 VGND VGND VPWR VPWR sky130_fd_sc_hd__fill_1
XFILLER_90_408 VGND VGND VPWR VPWR sky130_fd_sc_hd__decap_3
X_10960_ _04702_ _04703_ _04701_ VGND VGND VPWR VPWR _04704_ sky130_fd_sc_hd__a21bo_1
XFILLER_18_65 VPWR VGND VPWR VGND sky130_ef_sc_hd__decap_12
XFILLER_29_877 VPWR VGND VPWR VGND sky130_ef_sc_hd__decap_12
X_09619_ _03373_ _03374_ VGND VGND VPWR VPWR _03375_ sky130_fd_sc_hd__and2_1
X_10891_ _04510_ _04634_ _04633_ VGND VGND VPWR VPWR _04636_ sky130_fd_sc_hd__o21ai_1
XFILLER_28_376 VGND VGND VPWR VPWR sky130_fd_sc_hd__decap_4
XFILLER_43_313 VGND VGND VPWR VPWR sky130_fd_sc_hd__decap_6
X_12630_ net823 net1540 _06329_ _06331_ VGND VGND VPWR VPWR _00875_ sky130_fd_sc_hd__a22o_1
XFILLER_70_121 VPWR VGND VPWR VGND sky130_ef_sc_hd__decap_12
XFILLER_43_357 VGND VGND VPWR VPWR sky130_fd_sc_hd__fill_2
XFILLER_70_176 VGND VGND VPWR VPWR sky130_fd_sc_hd__decap_8
XFILLER_70_165 VGND VGND VPWR VPWR sky130_fd_sc_hd__fill_1
XTAP_TAPCELL_ROW_65_1383 VGND VPWR sky130_fd_sc_hd__tapvpwrvgnd_1
XTAP_TAPCELL_ROW_65_1372 VGND VPWR sky130_fd_sc_hd__tapvpwrvgnd_1
XFILLER_34_53 VGND VGND VPWR VPWR sky130_fd_sc_hd__decap_4
X_12561_ net782 net1743 VGND VGND VPWR VPWR _00859_ sky130_fd_sc_hd__and2_1
XFILLER_12_755 VGND VGND VPWR VPWR sky130_fd_sc_hd__fill_1
XFILLER_11_254 VPWR VGND VPWR VGND sky130_ef_sc_hd__decap_12
XFILLER_8_737 VPWR VGND VPWR VGND sky130_ef_sc_hd__decap_12
X_12492_ _06214_ _06217_ VGND VGND VPWR VPWR _06218_ sky130_fd_sc_hd__nand2_1
X_11512_ _05237_ _05250_ VGND VGND VPWR VPWR _05251_ sky130_fd_sc_hd__xor2_1
XFILLER_7_225 VPWR VGND VPWR VGND sky130_ef_sc_hd__decap_12
X_11443_ net617 u_interface.u_gelu_fp32.u_synth_top.s2_dx\[29\] _05086_ _05085_ VGND
+ VGND VPWR VPWR _05183_ sky130_fd_sc_hd__a31o_1
X_14162_ clknet_leaf_35_clk _01088_ VGND VGND VPWR VPWR u_interface.fifo_data\[1\]\[22\]
+ sky130_fd_sc_hd__dfxtp_1
XFILLER_50_85 VGND VGND VPWR VPWR sky130_fd_sc_hd__decap_3
XFILLER_152_421 VGND VGND VPWR VPWR sky130_fd_sc_hd__fill_1
XFILLER_125_657 VGND VGND VPWR VPWR sky130_fd_sc_hd__fill_1
X_11374_ _04915_ _05016_ _05015_ VGND VGND VPWR VPWR _05115_ sky130_fd_sc_hd__a21oi_1
X_13113_ clknet_leaf_72_clk _00123_ VGND VGND VPWR VPWR u_interface.fifo_data\[2\]\[2\]
+ sky130_fd_sc_hd__dfxtp_1
X_14093_ clknet_leaf_20_clk net1620 VGND VGND VPWR VPWR u_interface.u_gelu_fp32.u_fp32_to_q16.s2_norm_mag\[30\]
+ sky130_fd_sc_hd__dfxtp_1
XFILLER_140_616 VPWR VGND VPWR VGND sky130_ef_sc_hd__decap_12
X_10325_ _04073_ _04074_ net196 VGND VGND VPWR VPWR _04075_ sky130_fd_sc_hd__o21ai_1
X_13044_ clknet_leaf_42_clk _00054_ VGND VGND VPWR VPWR u_interface.fifo_tuser\[1\]
+ sky130_fd_sc_hd__dfxtp_1
XFILLER_133_690 VGND VGND VPWR VPWR sky130_fd_sc_hd__fill_2
X_10256_ net464 net468 net682 net688 VGND VGND VPWR VPWR _04006_ sky130_fd_sc_hd__nand4_1
XFILLER_3_497 VGND VGND VPWR VPWR sky130_fd_sc_hd__decap_6
XFILLER_78_243 VGND VGND VPWR VPWR sky130_fd_sc_hd__decap_8
X_10187_ _03935_ _03936_ VGND VGND VPWR VPWR _03938_ sky130_fd_sc_hd__xnor2_1
XFILLER_78_276 VPWR VGND VPWR VGND sky130_ef_sc_hd__decap_12
XFILLER_78_265 VGND VGND VPWR VPWR sky130_fd_sc_hd__decap_3
Xclkbuf_leaf_58_clk clknet_3_0__leaf_clk VGND VGND VPWR VPWR clknet_leaf_58_clk sky130_fd_sc_hd__clkbuf_8
XPHY_EDGE_ROW_53_Left_209 VGND VGND VPWR VPWR sky130_fd_sc_hd__decap_3
XFILLER_19_310 VPWR VGND VPWR VGND sky130_ef_sc_hd__decap_12
X_13946_ clknet_leaf_5_clk _00013_ VGND VGND VPWR VPWR u_interface.u_gelu_fp32.u_synth_top.s1_hits\[18\]
+ sky130_fd_sc_hd__dfxtp_1
XFILLER_62_633 VGND VGND VPWR VPWR sky130_fd_sc_hd__fill_2
XFILLER_61_110 VGND VGND VPWR VPWR sky130_fd_sc_hd__fill_2
X_13877_ clknet_leaf_2_clk net875 VGND VGND VPWR VPWR u_interface.u_gelu_fp32.u_synth_top.s2_dx\[13\]
+ sky130_fd_sc_hd__dfxtp_1
X_12828_ net779 net88 VGND VGND VPWR VPWR _00986_ sky130_fd_sc_hd__and2_1
XFILLER_50_828 VGND VGND VPWR VPWR sky130_fd_sc_hd__decap_3
XFILLER_91_81 VPWR VGND VPWR VGND sky130_ef_sc_hd__decap_12
X_12759_ u_interface.u_gelu_fp32.u_q16_to_fp32.s3_norm_mag\[5\] u_interface.u_gelu_fp32.u_q16_to_fp32.s3_norm_mag\[4\]
+ u_interface.u_gelu_fp32.u_q16_to_fp32.s3_norm_mag\[6\] _06395_ u_interface.u_gelu_fp32.u_q16_to_fp32.s3_norm_mag\[7\]
+ VGND VGND VPWR VPWR _06396_ sky130_fd_sc_hd__o41a_1
XPHY_EDGE_ROW_62_Left_218 VGND VGND VPWR VPWR sky130_fd_sc_hd__decap_3
XFILLER_30_563 VGND VGND VPWR VPWR sky130_fd_sc_hd__fill_1
XFILLER_147_259 VGND VGND VPWR VPWR sky130_fd_sc_hd__fill_2
XFILLER_128_473 VGND VGND VPWR VPWR sky130_fd_sc_hd__decap_3
XFILLER_116_613 VPWR VGND VPWR VGND sky130_ef_sc_hd__decap_12
XFILLER_155_281 VGND VGND VPWR VPWR sky130_fd_sc_hd__fill_2
Xhold737 net147 VGND VGND VPWR VPWR net1602 sky130_fd_sc_hd__dlygate4sd3_1
XFILLER_143_410 VGND VGND VPWR VPWR sky130_fd_sc_hd__decap_8
Xhold726 u_interface.fifo_data\[11\]\[7\] VGND VGND VPWR VPWR net1591 sky130_fd_sc_hd__dlygate4sd3_1
Xhold715 _00933_ VGND VGND VPWR VPWR net1580 sky130_fd_sc_hd__dlygate4sd3_1
XTAP_TAPCELL_ROW_96_1877 VGND VPWR sky130_fd_sc_hd__tapvpwrvgnd_1
XTAP_TAPCELL_ROW_96_1866 VGND VPWR sky130_fd_sc_hd__tapvpwrvgnd_1
Xhold704 u_interface.fifo_data\[11\]\[2\] VGND VGND VPWR VPWR net1569 sky130_fd_sc_hd__dlygate4sd3_1
Xhold759 _01012_ VGND VGND VPWR VPWR net1624 sky130_fd_sc_hd__dlygate4sd3_1
XFILLER_116_679 VGND VGND VPWR VPWR sky130_fd_sc_hd__decap_3
X_09970_ _03686_ _03721_ _03722_ VGND VGND VPWR VPWR _03723_ sky130_fd_sc_hd__or3_2
Xhold748 _00892_ VGND VGND VPWR VPWR net1613 sky130_fd_sc_hd__dlygate4sd3_1
XFILLER_131_649 VGND VGND VPWR VPWR sky130_fd_sc_hd__fill_1
XFILLER_130_104 VGND VGND VPWR VPWR sky130_fd_sc_hd__decap_8
X_08921_ net489 net654 net494 net664 VGND VGND VPWR VPWR _02680_ sky130_fd_sc_hd__nand4_2
XFILLER_130_137 VGND VGND VPWR VPWR sky130_fd_sc_hd__decap_3
X_08852_ _02609_ _02610_ _02608_ VGND VGND VPWR VPWR _02611_ sky130_fd_sc_hd__a21o_1
XPHY_EDGE_ROW_71_Left_227 VGND VGND VPWR VPWR sky130_fd_sc_hd__decap_3
X_07803_ net1289 net382 net232 VGND VGND VPWR VPWR _00564_ sky130_fd_sc_hd__mux2_1
XFILLER_85_703 VGND VGND VPWR VPWR sky130_fd_sc_hd__fill_1
XTAP_TAPCELL_ROW_127_2365 VGND VPWR sky130_fd_sc_hd__tapvpwrvgnd_1
X_08783_ _02536_ _02539_ _02540_ VGND VGND VPWR VPWR _02542_ sky130_fd_sc_hd__nand3_1
Xclkbuf_leaf_49_clk clknet_3_7__leaf_clk VGND VGND VPWR VPWR clknet_leaf_49_clk sky130_fd_sc_hd__clkbuf_8
XFILLER_84_268 VGND VGND VPWR VPWR sky130_fd_sc_hd__fill_2
XFILLER_84_257 VGND VGND VPWR VPWR sky130_fd_sc_hd__fill_2
X_07734_ u_interface.u_gelu_fp32.u_q16_to_fp32.s3_norm_mag\[12\] _01777_ VGND VGND
+ VPWR VPWR _01778_ sky130_fd_sc_hd__and2_1
XFILLER_72_419 VGND VGND VPWR VPWR sky130_fd_sc_hd__fill_1
X_07665_ _01723_ _01746_ net307 VGND VGND VPWR VPWR _01747_ sky130_fd_sc_hd__mux2_1
XFILLER_25_324 VGND VGND VPWR VPWR sky130_fd_sc_hd__decap_3
XFILLER_26_825 VPWR VGND VPWR VGND sky130_ef_sc_hd__decap_12
XFILLER_38_696 VGND VGND VPWR VPWR sky130_fd_sc_hd__decap_4
X_06616_ net323 _01192_ net727 VGND VGND VPWR VPWR _01193_ sky130_fd_sc_hd__o21a_1
XTAP_TAPCELL_ROW_140_2576 VGND VPWR sky130_fd_sc_hd__tapvpwrvgnd_1
X_09404_ _03150_ _03160_ VGND VGND VPWR VPWR _03162_ sky130_fd_sc_hd__xnor2_1
XFILLER_111_47 VGND VGND VPWR VPWR sky130_fd_sc_hd__decap_8
XFILLER_26_869 VPWR VGND VPWR VGND sky130_ef_sc_hd__decap_12
X_07596_ net813 net1707 _01536_ _01693_ VGND VGND VPWR VPWR _00468_ sky130_fd_sc_hd__a22o_1
XFILLER_111_69 VPWR VGND VPWR VGND sky130_ef_sc_hd__decap_12
XFILLER_53_688 VGND VGND VPWR VPWR sky130_fd_sc_hd__fill_1
X_09335_ net600 net513 net517 net606 VGND VGND VPWR VPWR _03094_ sky130_fd_sc_hd__a22o_1
X_06547_ u_interface.u_gelu_fp32.s1_data\[13\] u_interface.u_gelu_fp32.s1_data\[12\]
+ _01142_ VGND VGND VPWR VPWR _01143_ sky130_fd_sc_hd__nor3_1
XPHY_EDGE_ROW_80_Left_236 VGND VGND VPWR VPWR sky130_fd_sc_hd__decap_3
XTAP_TAPCELL_ROW_47_1091 VGND VPWR sky130_fd_sc_hd__tapvpwrvgnd_1
XTAP_TAPCELL_ROW_47_1080 VGND VPWR sky130_fd_sc_hd__tapvpwrvgnd_1
XFILLER_33_390 VGND VGND VPWR VPWR sky130_fd_sc_hd__fill_2
XFILLER_40_349 VPWR VGND VPWR VGND sky130_ef_sc_hd__decap_12
X_09266_ _02977_ _03012_ _03024_ VGND VGND VPWR VPWR _03025_ sky130_fd_sc_hd__a21o_1
XFILLER_139_727 VGND VGND VPWR VPWR sky130_fd_sc_hd__fill_1
XFILLER_138_226 VGND VGND VPWR VPWR sky130_fd_sc_hd__decap_3
XFILLER_119_440 VGND VGND VPWR VPWR sky130_fd_sc_hd__decap_8
X_08217_ u_interface.u_gelu_fp32.u_fp32_to_q16.s3_overflow _02046_ net539 VGND VGND
+ VPWR VPWR _02047_ sky130_fd_sc_hd__o21a_1
XFILLER_147_782 VGND VGND VPWR VPWR sky130_fd_sc_hd__fill_2
X_09197_ _02795_ _02834_ _02846_ _02849_ VGND VGND VPWR VPWR _02956_ sky130_fd_sc_hd__a31o_1
XFILLER_119_462 VPWR VGND VPWR VGND sky130_ef_sc_hd__decap_12
XTAP_TAPCELL_ROW_60_1291 VGND VPWR sky130_fd_sc_hd__tapvpwrvgnd_1
XFILLER_5_729 VPWR VGND VPWR VGND sky130_ef_sc_hd__decap_12
XFILLER_153_229 VGND VGND VPWR VPWR sky130_fd_sc_hd__fill_1
XFILLER_134_421 VGND VGND VPWR VPWR sky130_fd_sc_hd__decap_8
X_08148_ net315 _01987_ _01988_ VGND VGND VPWR VPWR _01989_ sky130_fd_sc_hd__or3_1
X_08079_ u_interface.u_gelu_fp32.u_fp32_to_q16.s3_mag\[5\] _01875_ VGND VGND VPWR
+ VPWR _01931_ sky130_fd_sc_hd__nor2_1
XFILLER_107_668 VGND VGND VPWR VPWR sky130_fd_sc_hd__decap_4
XFILLER_20_77 VGND VGND VPWR VPWR sky130_fd_sc_hd__decap_6
XFILLER_134_498 VGND VGND VPWR VPWR sky130_fd_sc_hd__fill_1
XFILLER_106_189 VGND VGND VPWR VPWR sky130_fd_sc_hd__decap_6
X_10110_ net784 _03860_ _03861_ VGND VGND VPWR VPWR _00815_ sky130_fd_sc_hd__and3_1
X_11090_ net694 net443 net438 net686 VGND VGND VPWR VPWR _04833_ sky130_fd_sc_hd__a22o_1
XFILLER_103_841 VGND VGND VPWR VPWR sky130_fd_sc_hd__decap_6
X_10041_ net596 net432 net428 net588 VGND VGND VPWR VPWR _03793_ sky130_fd_sc_hd__a22oi_1
XFILLER_0_445 VGND VGND VPWR VPWR sky130_fd_sc_hd__decap_3
XFILLER_130_671 VGND VGND VPWR VPWR sky130_fd_sc_hd__fill_1
Xhold20 u_interface.u_gelu_fp32.s1_data\[3\] VGND VGND VPWR VPWR net885 sky130_fd_sc_hd__dlygate4sd3_1
Xhold31 u_interface.u_gelu_fp32.s1_data\[18\] VGND VGND VPWR VPWR net896 sky130_fd_sc_hd__dlygate4sd3_1
XFILLER_0_489 VPWR VGND VPWR VGND sky130_ef_sc_hd__decap_12
Xhold53 u_interface.meta_tuser_pipe\[3\] VGND VGND VPWR VPWR net918 sky130_fd_sc_hd__dlygate4sd3_1
Xhold64 u_interface.meta_tlast_pipe\[3\] VGND VGND VPWR VPWR net929 sky130_fd_sc_hd__dlygate4sd3_1
Xhold42 u_interface.meta_tlast_pipe\[8\] VGND VGND VPWR VPWR net907 sky130_fd_sc_hd__dlygate4sd3_1
XFILLER_102_384 VGND VGND VPWR VPWR sky130_fd_sc_hd__decap_4
XFILLER_76_747 VGND VGND VPWR VPWR sky130_fd_sc_hd__decap_8
XFILLER_152_65 VPWR VGND VPWR VGND sky130_ef_sc_hd__decap_12
Xhold97 u_interface.fifo_data\[9\]\[16\] VGND VGND VPWR VPWR net962 sky130_fd_sc_hd__dlygate4sd3_1
Xhold75 u_interface.u_gelu_fp32.s1_valid VGND VGND VPWR VPWR net940 sky130_fd_sc_hd__dlygate4sd3_1
Xhold86 u_interface.u_gelu_fp32.s2_valid VGND VGND VPWR VPWR net951 sky130_fd_sc_hd__dlygate4sd3_1
X_13800_ clknet_leaf_25_clk _00810_ VGND VGND VPWR VPWR u_interface.u_gelu_fp32.u_synth_top.s3_mult\[18\]
+ sky130_fd_sc_hd__dfxtp_1
XTAP_TAPCELL_ROW_67_1401 VGND VPWR sky130_fd_sc_hd__tapvpwrvgnd_1
XFILLER_29_641 VPWR VGND VPWR VGND sky130_ef_sc_hd__decap_12
X_11992_ net178 _05656_ _05659_ VGND VGND VPWR VPWR _05725_ sky130_fd_sc_hd__nor3_1
X_13731_ clknet_leaf_8_clk _00741_ VGND VGND VPWR VPWR u_interface.u_gelu_fp32.s1_data\[31\]
+ sky130_fd_sc_hd__dfxtp_1
XFILLER_84_780 VGND VGND VPWR VPWR sky130_fd_sc_hd__decap_8
XFILLER_72_920 VGND VGND VPWR VPWR sky130_fd_sc_hd__fill_1
XTAP_TAPCELL_ROW_67_1412 VGND VPWR sky130_fd_sc_hd__tapvpwrvgnd_1
X_10943_ _04328_ _04445_ VGND VGND VPWR VPWR _04687_ sky130_fd_sc_hd__and2_1
XFILLER_28_173 VGND VGND VPWR VPWR sky130_fd_sc_hd__fill_2
XFILLER_29_685 VPWR VGND VPWR VGND sky130_ef_sc_hd__decap_12
XPHY_EDGE_ROW_119_Left_275 VGND VGND VPWR VPWR sky130_fd_sc_hd__decap_3
X_13662_ clknet_leaf_29_clk _00672_ VGND VGND VPWR VPWR u_interface.u_gelu_fp32.u_fp32_to_q16.s1_valid
+ sky130_fd_sc_hd__dfxtp_1
XTAP_TAPCELL_ROW_80_1612 VGND VPWR sky130_fd_sc_hd__tapvpwrvgnd_1
X_10874_ net635 net422 VGND VGND VPWR VPWR _04619_ sky130_fd_sc_hd__nand2_1
XTAP_TAPCELL_ROW_80_1623 VGND VPWR sky130_fd_sc_hd__tapvpwrvgnd_1
X_12613_ _06312_ _06315_ VGND VGND VPWR VPWR _06316_ sky130_fd_sc_hd__nor2_2
X_13593_ clknet_leaf_72_clk _00603_ VGND VGND VPWR VPWR u_interface.fifo_data\[3\]\[8\]
+ sky130_fd_sc_hd__dfxtp_1
XFILLER_8_501 VPWR VGND VPWR VGND sky130_ef_sc_hd__decap_12
XTAP_TAPCELL_ROW_14_558 VGND VPWR sky130_fd_sc_hd__tapvpwrvgnd_1
X_12544_ net197 _06267_ VGND VGND VPWR VPWR _06268_ sky130_fd_sc_hd__xnor2_1
XFILLER_8_545 VPWR VGND VPWR VGND sky130_ef_sc_hd__decap_12
XFILLER_126_900 VGND VGND VPWR VPWR sky130_fd_sc_hd__decap_3
XFILLER_8_589 VPWR VGND VPWR VGND sky130_ef_sc_hd__decap_12
X_12475_ _06199_ _06200_ VGND VGND VPWR VPWR _06201_ sky130_fd_sc_hd__nand2b_1
XFILLER_137_281 VGND VGND VPWR VPWR sky130_fd_sc_hd__fill_2
XFILLER_125_421 VGND VGND VPWR VPWR sky130_fd_sc_hd__fill_1
XANTENNA_6 u_interface.u_gelu_fp32.u_synth_top.s2_b\[18\] VGND VGND VPWR VPWR sky130_fd_sc_hd__diode_2
X_11426_ net675 net421 _05164_ _05165_ VGND VGND VPWR VPWR _05166_ sky130_fd_sc_hd__a22o_1
XFILLER_153_774 VGND VGND VPWR VPWR sky130_fd_sc_hd__fill_1
XPHY_EDGE_ROW_128_Left_284 VGND VGND VPWR VPWR sky130_fd_sc_hd__decap_3
XFILLER_113_605 VGND VGND VPWR VPWR sky130_fd_sc_hd__decap_8
XTAP_TAPCELL_ROW_111_2111 VGND VPWR sky130_fd_sc_hd__tapvpwrvgnd_1
XFILLER_98_305 VGND VGND VPWR VPWR sky130_fd_sc_hd__decap_3
XTAP_TAPCELL_ROW_78_1585 VGND VPWR sky130_fd_sc_hd__tapvpwrvgnd_1
X_14145_ clknet_leaf_70_clk _01071_ VGND VGND VPWR VPWR u_interface.fifo_data\[1\]\[5\]
+ sky130_fd_sc_hd__dfxtp_1
X_11357_ _05063_ _05097_ VGND VGND VPWR VPWR _05098_ sky130_fd_sc_hd__xnor2_2
X_14076_ clknet_leaf_17_clk net953 VGND VGND VPWR VPWR u_interface.u_gelu_fp32.u_fp32_to_q16.s2_norm_mag\[13\]
+ sky130_fd_sc_hd__dfxtp_1
X_10308_ _03937_ _03939_ _04056_ VGND VGND VPWR VPWR _04058_ sky130_fd_sc_hd__nand3_1
XFILLER_3_261 VPWR VGND VPWR VGND sky130_ef_sc_hd__decap_12
X_13027_ _01528_ _01529_ VGND VGND VPWR VPWR _01045_ sky130_fd_sc_hd__nor2_1
X_11288_ _04927_ _04937_ _04939_ VGND VGND VPWR VPWR _05029_ sky130_fd_sc_hd__a21oi_1
XTAP_TAPCELL_ROW_91_1796 VGND VPWR sky130_fd_sc_hd__tapvpwrvgnd_1
XTAP_TAPCELL_ROW_91_1785 VGND VPWR sky130_fd_sc_hd__tapvpwrvgnd_1
X_10239_ _03864_ _03875_ _03876_ VGND VGND VPWR VPWR _03989_ sky130_fd_sc_hd__a21bo_1
XFILLER_39_416 VPWR VGND VPWR VGND sky130_ef_sc_hd__decap_12
XFILLER_120_181 VGND VGND VPWR VPWR sky130_fd_sc_hd__fill_1
XFILLER_94_533 VGND VGND VPWR VPWR sky130_fd_sc_hd__decap_8
XFILLER_67_769 VGND VGND VPWR VPWR sky130_fd_sc_hd__decap_4
XFILLER_39_449 VGND VGND VPWR VPWR sky130_fd_sc_hd__decap_4
XTAP_TAPCELL_ROW_109_2073 VGND VPWR sky130_fd_sc_hd__tapvpwrvgnd_1
XPHY_EDGE_ROW_137_Left_293 VGND VGND VPWR VPWR sky130_fd_sc_hd__decap_3
XTAP_TAPCELL_ROW_109_2084 VGND VPWR sky130_fd_sc_hd__tapvpwrvgnd_1
X_13929_ clknet_leaf_5_clk _00014_ VGND VGND VPWR VPWR u_interface.u_gelu_fp32.u_synth_top.s1_hits\[1\]
+ sky130_fd_sc_hd__dfxtp_2
X_07450_ _01581_ _01584_ net553 VGND VGND VPWR VPWR _01585_ sky130_fd_sc_hd__mux2_1
XTAP_TAPCELL_ROW_122_2295 VGND VPWR sky130_fd_sc_hd__tapvpwrvgnd_1
XTAP_TAPCELL_ROW_122_2284 VGND VPWR sky130_fd_sc_hd__tapvpwrvgnd_1
XFILLER_90_772 VGND VGND VPWR VPWR sky130_fd_sc_hd__fill_1
XFILLER_62_474 VGND VGND VPWR VPWR sky130_fd_sc_hd__fill_2
XFILLER_23_839 VGND VGND VPWR VPWR sky130_fd_sc_hd__fill_1
X_07381_ net1041 net356 net239 VGND VGND VPWR VPWR _00411_ sky130_fd_sc_hd__mux2_1
X_09120_ net604 net496 _02823_ _02824_ VGND VGND VPWR VPWR _02879_ sky130_fd_sc_hd__a22o_1
XTAP_TAPCELL_ROW_33_856 VGND VPWR sky130_fd_sc_hd__tapvpwrvgnd_1
XTAP_TAPCELL_ROW_33_867 VGND VPWR sky130_fd_sc_hd__tapvpwrvgnd_1
X_09051_ _02806_ _02808_ _02809_ _02760_ VGND VGND VPWR VPWR _02810_ sky130_fd_sc_hd__o211a_1
XTAP_TAPCELL_ROW_98_1906 VGND VPWR sky130_fd_sc_hd__tapvpwrvgnd_1
X_08002_ net544 net305 _01642_ net278 VGND VGND VPWR VPWR _01866_ sky130_fd_sc_hd__a31o_1
XPHY_EDGE_ROW_6_Right_6 VGND VGND VPWR VPWR sky130_fd_sc_hd__decap_3
XFILLER_116_421 VGND VGND VPWR VPWR sky130_fd_sc_hd__fill_1
Xhold501 u_interface.fifo_data\[0\]\[6\] VGND VGND VPWR VPWR net1366 sky130_fd_sc_hd__dlygate4sd3_1
Xhold523 u_interface.fifo_data\[3\]\[16\] VGND VGND VPWR VPWR net1388 sky130_fd_sc_hd__dlygate4sd3_1
XFILLER_128_292 VPWR VGND VPWR VGND sky130_ef_sc_hd__decap_12
XFILLER_116_443 VGND VGND VPWR VPWR sky130_fd_sc_hd__fill_2
Xhold512 u_interface.fifo_data\[2\]\[24\] VGND VGND VPWR VPWR net1377 sky130_fd_sc_hd__dlygate4sd3_1
Xhold534 _00519_ VGND VGND VPWR VPWR net1399 sky130_fd_sc_hd__dlygate4sd3_1
Xhold545 u_interface.fifo_data\[12\]\[6\] VGND VGND VPWR VPWR net1410 sky130_fd_sc_hd__dlygate4sd3_1
Xhold556 _01014_ VGND VGND VPWR VPWR net1421 sky130_fd_sc_hd__dlygate4sd3_1
Xhold567 u_interface.fifo_data\[2\]\[10\] VGND VGND VPWR VPWR net1432 sky130_fd_sc_hd__dlygate4sd3_1
XFILLER_89_316 VPWR VGND VPWR VGND sky130_ef_sc_hd__decap_12
Xhold578 u_interface.fifo_data\[15\]\[15\] VGND VGND VPWR VPWR net1443 sky130_fd_sc_hd__dlygate4sd3_1
XFILLER_131_457 VGND VGND VPWR VPWR sky130_fd_sc_hd__decap_8
XFILLER_131_446 VGND VGND VPWR VPWR sky130_fd_sc_hd__fill_2
XTAP_TAPCELL_ROW_129_2405 VGND VPWR sky130_fd_sc_hd__tapvpwrvgnd_1
Xhold589 u_interface.fifo_data\[9\]\[13\] VGND VGND VPWR VPWR net1454 sky130_fd_sc_hd__dlygate4sd3_1
XFILLER_103_126 VGND VGND VPWR VPWR sky130_fd_sc_hd__decap_8
X_09953_ net455 net459 net631 net641 VGND VGND VPWR VPWR _03706_ sky130_fd_sc_hd__nand4_1
X_08904_ _02661_ _02662_ VGND VGND VPWR VPWR _02663_ sky130_fd_sc_hd__nand2_1
X_09884_ net499 net723 VGND VGND VPWR VPWR _03637_ sky130_fd_sc_hd__and2_1
XFILLER_85_511 VGND VGND VPWR VPWR sky130_fd_sc_hd__fill_1
X_08835_ _02582_ _02592_ VGND VGND VPWR VPWR _02594_ sky130_fd_sc_hd__xor2_1
XFILLER_111_181 VGND VGND VPWR VPWR sky130_fd_sc_hd__fill_1
XFILLER_97_393 VGND VGND VPWR VPWR sky130_fd_sc_hd__decap_3
XTAP_TAPCELL_ROW_142_2605 VGND VPWR sky130_fd_sc_hd__tapvpwrvgnd_1
X_08766_ _02473_ _02475_ _02474_ VGND VGND VPWR VPWR _02525_ sky130_fd_sc_hd__o21bai_1
XFILLER_111_192 VGND VGND VPWR VPWR sky130_fd_sc_hd__fill_1
XFILLER_85_577 VGND VGND VPWR VPWR sky130_fd_sc_hd__fill_2
XFILLER_100_899 VGND VGND VPWR VPWR sky130_fd_sc_hd__decap_6
X_07717_ _01128_ _01185_ _01760_ VGND VGND VPWR VPWR _00513_ sky130_fd_sc_hd__or3_1
XFILLER_66_791 VGND VGND VPWR VPWR sky130_fd_sc_hd__fill_1
XFILLER_57_279 VGND VGND VPWR VPWR sky130_fd_sc_hd__fill_1
XTAP_TAPCELL_ROW_49_1120 VGND VPWR sky130_fd_sc_hd__tapvpwrvgnd_1
XFILLER_45_419 VGND VGND VPWR VPWR sky130_fd_sc_hd__decap_8
X_08697_ net655 net663 net502 net508 VGND VGND VPWR VPWR _02456_ sky130_fd_sc_hd__and4_1
XFILLER_38_493 VGND VGND VPWR VPWR sky130_fd_sc_hd__fill_2
X_07648_ _01707_ _01733_ net306 VGND VGND VPWR VPWR _01734_ sky130_fd_sc_hd__mux2_1
XFILLER_13_316 VGND VGND VPWR VPWR sky130_fd_sc_hd__decap_6
XFILLER_26_699 VGND VGND VPWR VPWR sky130_fd_sc_hd__fill_1
X_07579_ net810 net1668 net302 _01686_ VGND VGND VPWR VPWR _00458_ sky130_fd_sc_hd__a22o_1
XTAP_TAPCELL_ROW_62_1331 VGND VPWR sky130_fd_sc_hd__tapvpwrvgnd_1
XTAP_TAPCELL_ROW_62_1320 VGND VPWR sky130_fd_sc_hd__tapvpwrvgnd_1
XFILLER_53_496 VGND VGND VPWR VPWR sky130_fd_sc_hd__fill_1
XFILLER_15_55 VGND VGND VPWR VPWR sky130_fd_sc_hd__fill_1
XFILLER_139_502 VGND VGND VPWR VPWR sky130_fd_sc_hd__fill_2
X_09318_ net583 net591 net506 net512 VGND VGND VPWR VPWR _03077_ sky130_fd_sc_hd__and4_1
XFILLER_9_309 VGND VGND VPWR VPWR sky130_fd_sc_hd__decap_8
XFILLER_22_861 VGND VGND VPWR VPWR sky130_fd_sc_hd__decap_6
X_10590_ net189 _04334_ _04335_ VGND VGND VPWR VPWR _04337_ sky130_fd_sc_hd__nand3_2
XTAP_TAPCELL_ROW_11_517 VGND VPWR sky130_fd_sc_hd__tapvpwrvgnd_1
XTAP_TAPCELL_ROW_11_506 VGND VPWR sky130_fd_sc_hd__tapvpwrvgnd_1
X_09249_ _02958_ _02961_ _02998_ VGND VGND VPWR VPWR _03008_ sky130_fd_sc_hd__a21oi_1
XTAP_TAPCELL_ROW_153_2789 VGND VPWR sky130_fd_sc_hd__tapvpwrvgnd_1
XTAP_TAPCELL_ROW_153_2778 VGND VPWR sky130_fd_sc_hd__tapvpwrvgnd_1
XFILLER_119_270 VGND VGND VPWR VPWR sky130_fd_sc_hd__fill_2
XFILLER_110_3 VGND VGND VPWR VPWR sky130_fd_sc_hd__decap_4
X_12260_ _05988_ _05989_ VGND VGND VPWR VPWR _05990_ sky130_fd_sc_hd__nand2b_1
XFILLER_107_432 VGND VGND VPWR VPWR sky130_fd_sc_hd__decap_8
X_11211_ net668 net677 net430 net425 VGND VGND VPWR VPWR _04953_ sky130_fd_sc_hd__nand4_1
XFILLER_5_559 VGND VGND VPWR VPWR sky130_fd_sc_hd__fill_1
X_12191_ _05867_ _05921_ VGND VGND VPWR VPWR _05922_ sky130_fd_sc_hd__xnor2_1
XFILLER_107_487 VPWR VGND VPWR VGND sky130_ef_sc_hd__decap_12
X_11142_ _04850_ _04884_ VGND VGND VPWR VPWR _04885_ sky130_fd_sc_hd__xnor2_1
XFILLER_1_721 VGND VGND VPWR VPWR sky130_fd_sc_hd__decap_6
XFILLER_103_671 VGND VGND VPWR VPWR sky130_fd_sc_hd__fill_1
X_11073_ net453 net457 net719 VGND VGND VPWR VPWR _04816_ sky130_fd_sc_hd__and3_1
XFILLER_0_253 VPWR VGND VPWR VGND sky130_ef_sc_hd__decap_12
XFILLER_1_765 VPWR VGND VPWR VGND sky130_ef_sc_hd__decap_12
X_10024_ _03643_ _03645_ _03771_ _03772_ VGND VGND VPWR VPWR _03776_ sky130_fd_sc_hd__a211o_1
XFILLER_88_371 VGND VGND VPWR VPWR sky130_fd_sc_hd__fill_1
XFILLER_76_533 VGND VGND VPWR VPWR sky130_fd_sc_hd__decap_3
XFILLER_76_511 VGND VGND VPWR VPWR sky130_fd_sc_hd__fill_1
XFILLER_91_503 VGND VGND VPWR VPWR sky130_fd_sc_hd__fill_1
XFILLER_48_268 VGND VGND VPWR VPWR sky130_fd_sc_hd__fill_1
XFILLER_48_246 VGND VGND VPWR VPWR sky130_fd_sc_hd__decap_3
XFILLER_56_62 VGND VGND VPWR VPWR sky130_fd_sc_hd__decap_4
XTAP_TAPCELL_ROW_19_639 VGND VPWR sky130_fd_sc_hd__tapvpwrvgnd_1
XFILLER_63_249 VGND VGND VPWR VPWR sky130_fd_sc_hd__fill_1
XFILLER_16_121 VPWR VGND VPWR VGND sky130_ef_sc_hd__decap_12
X_11975_ _05707_ _05708_ VGND VGND VPWR VPWR _05709_ sky130_fd_sc_hd__nand2_1
X_13714_ clknet_leaf_10_clk _00724_ VGND VGND VPWR VPWR u_interface.u_gelu_fp32.s1_data\[14\]
+ sky130_fd_sc_hd__dfxtp_2
X_10926_ _04667_ _04670_ VGND VGND VPWR VPWR _04671_ sky130_fd_sc_hd__or2_1
X_13645_ clknet_leaf_39_clk _00655_ VGND VGND VPWR VPWR u_interface.fifo_data\[13\]\[28\]
+ sky130_fd_sc_hd__dfxtp_1
XFILLER_112_90 VGND VGND VPWR VPWR sky130_fd_sc_hd__decap_6
X_10857_ _04598_ _04599_ net686 net448 VGND VGND VPWR VPWR _04602_ sky130_fd_sc_hd__and4b_1
XFILLER_31_102 VGND VGND VPWR VPWR sky130_fd_sc_hd__fill_1
XFILLER_31_113 VPWR VGND VPWR VGND sky130_ef_sc_hd__decap_12
XFILLER_32_625 VPWR VGND VPWR VGND sky130_ef_sc_hd__decap_12
XFILLER_31_157 VGND VGND VPWR VPWR sky130_fd_sc_hd__fill_2
XFILLER_32_669 VPWR VGND VPWR VGND sky130_ef_sc_hd__decap_12
X_13576_ clknet_leaf_44_clk _00586_ VGND VGND VPWR VPWR u_interface.fifo_data\[4\]\[23\]
+ sky130_fd_sc_hd__dfxtp_1
X_10788_ _04508_ _04509_ _04531_ _04532_ VGND VGND VPWR VPWR _04534_ sky130_fd_sc_hd__and4_1
XPHY_EDGE_ROW_59_Right_59 VGND VGND VPWR VPWR sky130_fd_sc_hd__decap_3
XFILLER_9_821 VPWR VGND VPWR VGND sky130_ef_sc_hd__decap_12
XTAP_TAPCELL_ROW_30_815 VGND VPWR sky130_fd_sc_hd__tapvpwrvgnd_1
XFILLER_9_865 VPWR VGND VPWR VGND sky130_ef_sc_hd__decap_12
X_12527_ _06135_ _06223_ VGND VGND VPWR VPWR _06251_ sky130_fd_sc_hd__nor2_1
XFILLER_12_393 VPWR VGND VPWR VGND sky130_ef_sc_hd__decap_12
X_12458_ net182 _06183_ VGND VGND VPWR VPWR _06184_ sky130_fd_sc_hd__xnor2_4
XFILLER_126_752 VGND VGND VPWR VPWR sky130_fd_sc_hd__decap_4
XTAP_TAPCELL_ROW_93_1825 VGND VPWR sky130_fd_sc_hd__tapvpwrvgnd_1
X_11409_ net703 net435 VGND VGND VPWR VPWR _05149_ sky130_fd_sc_hd__and2_1
X_12389_ net192 _06115_ VGND VGND VPWR VPWR _06117_ sky130_fd_sc_hd__nand2_1
X_14128_ clknet_leaf_30_clk _01054_ VGND VGND VPWR VPWR u_interface.in_flight_count\[1\]
+ sky130_fd_sc_hd__dfxtp_1
XFILLER_113_446 VGND VGND VPWR VPWR sky130_fd_sc_hd__fill_2
XFILLER_113_424 VGND VGND VPWR VPWR sky130_fd_sc_hd__fill_2
XFILLER_4_581 VGND VGND VPWR VPWR sky130_fd_sc_hd__decap_6
X_14059_ clknet_leaf_17_clk _00985_ VGND VGND VPWR VPWR u_interface.u_gelu_fp32.u_fp32_to_q16.s1_mant\[21\]
+ sky130_fd_sc_hd__dfxtp_1
XFILLER_98_168 VGND VGND VPWR VPWR sky130_fd_sc_hd__fill_1
X_06950_ u_interface.u_gelu_fp32.u_synth_top.s1_x\[26\] net275 _01479_ VGND VGND VPWR
+ VPWR _01481_ sky130_fd_sc_hd__a21o_1
XPHY_EDGE_ROW_68_Right_68 VGND VGND VPWR VPWR sky130_fd_sc_hd__decap_3
X_06881_ u_interface.fifo_data\[0\]\[31\] u_interface.fifo_data\[1\]\[31\] u_interface.fifo_data\[2\]\[31\]
+ u_interface.fifo_data\[3\]\[31\] net755 net738 VGND VGND VPWR VPWR _01425_ sky130_fd_sc_hd__mux4_1
XFILLER_39_202 VGND VGND VPWR VPWR sky130_fd_sc_hd__fill_1
XPHY_EDGE_ROW_145_Left_301 VGND VGND VPWR VPWR sky130_fd_sc_hd__decap_3
X_08620_ net153 _02395_ net800 VGND VGND VPWR VPWR _00791_ sky130_fd_sc_hd__a21oi_1
XFILLER_27_408 VPWR VGND VPWR VGND sky130_ef_sc_hd__decap_12
XTAP_TAPCELL_ROW_124_2324 VGND VPWR sky130_fd_sc_hd__tapvpwrvgnd_1
XTAP_TAPCELL_ROW_124_2313 VGND VPWR sky130_fd_sc_hd__tapvpwrvgnd_1
XFILLER_95_897 VGND VGND VPWR VPWR sky130_fd_sc_hd__fill_2
XFILLER_94_363 VGND VGND VPWR VPWR sky130_fd_sc_hd__fill_1
XFILLER_67_599 VGND VGND VPWR VPWR sky130_fd_sc_hd__fill_1
XTAP_TAPCELL_ROW_38_937 VGND VPWR sky130_fd_sc_hd__tapvpwrvgnd_1
XFILLER_39_279 VGND VGND VPWR VPWR sky130_fd_sc_hd__fill_1
X_08551_ _02164_ _02289_ _02163_ VGND VGND VPWR VPWR _02342_ sky130_fd_sc_hd__a21bo_1
XTAP_TAPCELL_ROW_38_948 VGND VPWR sky130_fd_sc_hd__tapvpwrvgnd_1
X_07502_ _01633_ VGND VGND VPWR VPWR _01634_ sky130_fd_sc_hd__inv_2
XFILLER_35_463 VPWR VGND VPWR VGND sky130_ef_sc_hd__decap_12
X_08482_ _02271_ _02272_ VGND VGND VPWR VPWR _02273_ sky130_fd_sc_hd__nand2b_1
X_07433_ _01560_ _01568_ net311 VGND VGND VPWR VPWR _01569_ sky130_fd_sc_hd__mux2_1
XTAP_TAPCELL_ROW_102_1965 VGND VPWR sky130_fd_sc_hd__tapvpwrvgnd_1
XPHY_EDGE_ROW_77_Right_77 VGND VGND VPWR VPWR sky130_fd_sc_hd__decap_3
XFILLER_50_466 VGND VGND VPWR VPWR sky130_fd_sc_hd__decap_8
XFILLER_11_809 VPWR VGND VPWR VGND sky130_ef_sc_hd__decap_12
XFILLER_148_321 VGND VGND VPWR VPWR sky130_fd_sc_hd__decap_8
X_09103_ _02821_ _02854_ VGND VGND VPWR VPWR _02862_ sky130_fd_sc_hd__nand2_1
X_07364_ net565 net1568 net244 VGND VGND VPWR VPWR _00394_ sky130_fd_sc_hd__mux2_1
XFILLER_50_477 VGND VGND VPWR VPWR sky130_fd_sc_hd__decap_8
XPHY_EDGE_ROW_154_Left_310 VGND VGND VPWR VPWR sky130_fd_sc_hd__decap_3
XFILLER_148_365 VGND VGND VPWR VPWR sky130_fd_sc_hd__fill_1
XFILLER_148_354 VGND VGND VPWR VPWR sky130_fd_sc_hd__decap_8
X_07295_ net1328 net575 net247 VGND VGND VPWR VPWR _00325_ sky130_fd_sc_hd__mux2_1
X_09034_ _02783_ _02792_ VGND VGND VPWR VPWR _02793_ sky130_fd_sc_hd__nor2_1
XFILLER_136_527 VGND VGND VPWR VPWR sky130_fd_sc_hd__decap_4
Xhold320 u_interface.fifo_data\[5\]\[28\] VGND VGND VPWR VPWR net1185 sky130_fd_sc_hd__dlygate4sd3_1
XTAP_TAPCELL_ROW_135_2497 VGND VPWR sky130_fd_sc_hd__tapvpwrvgnd_1
XFILLER_117_741 VGND VGND VPWR VPWR sky130_fd_sc_hd__fill_1
Xhold342 u_interface.fifo_tlast\[3\] VGND VGND VPWR VPWR net1207 sky130_fd_sc_hd__dlygate4sd3_1
Xhold353 _00707_ VGND VGND VPWR VPWR net1218 sky130_fd_sc_hd__dlygate4sd3_1
Xhold331 u_interface.fifo_data\[14\]\[19\] VGND VGND VPWR VPWR net1196 sky130_fd_sc_hd__dlygate4sd3_1
XFILLER_89_113 VGND VGND VPWR VPWR sky130_fd_sc_hd__decap_6
XFILLER_132_744 VGND VGND VPWR VPWR sky130_fd_sc_hd__fill_1
XFILLER_117_79 VGND VGND VPWR VPWR sky130_fd_sc_hd__fill_1
XFILLER_117_57 VGND VGND VPWR VPWR sky130_fd_sc_hd__decap_6
Xhold375 u_interface.fifo_data\[6\]\[23\] VGND VGND VPWR VPWR net1240 sky130_fd_sc_hd__dlygate4sd3_1
Xhold386 u_interface.fifo_data\[0\]\[4\] VGND VGND VPWR VPWR net1251 sky130_fd_sc_hd__dlygate4sd3_1
XFILLER_78_809 VGND VGND VPWR VPWR sky130_fd_sc_hd__decap_3
Xfanout800 net809 VGND VGND VPWR VPWR net800 sky130_fd_sc_hd__clkbuf_2
Xhold364 u_interface.fifo_data\[5\]\[5\] VGND VGND VPWR VPWR net1229 sky130_fd_sc_hd__dlygate4sd3_1
Xfanout822 net830 VGND VGND VPWR VPWR net822 sky130_fd_sc_hd__clkbuf_4
Xfanout811 net812 VGND VGND VPWR VPWR net811 sky130_fd_sc_hd__buf_2
Xhold397 u_interface.fifo_data\[12\]\[23\] VGND VGND VPWR VPWR net1262 sky130_fd_sc_hd__dlygate4sd3_1
X_09936_ net474 net479 net681 net691 VGND VGND VPWR VPWR _03689_ sky130_fd_sc_hd__and4_1
XPHY_EDGE_ROW_86_Right_86 VGND VGND VPWR VPWR sky130_fd_sc_hd__decap_3
XFILLER_58_533 VGND VGND VPWR VPWR sky130_fd_sc_hd__fill_2
X_09867_ _03467_ _03511_ _03618_ net172 VGND VGND VPWR VPWR _03621_ sky130_fd_sc_hd__a211oi_2
XFILLER_19_909 VPWR VGND VPWR VGND sky130_ef_sc_hd__decap_12
XFILLER_133_67 VGND VGND VPWR VPWR sky130_fd_sc_hd__decap_4
X_08818_ _02501_ _02517_ _02516_ _02509_ VGND VGND VPWR VPWR _02577_ sky130_fd_sc_hd__o211a_1
X_09798_ _03550_ _03551_ _03541_ VGND VGND VPWR VPWR _03552_ sky130_fd_sc_hd__a21oi_1
XFILLER_100_696 VGND VGND VPWR VPWR sky130_fd_sc_hd__decap_4
XFILLER_85_374 VPWR VGND VPWR VGND sky130_ef_sc_hd__decap_12
XFILLER_18_419 VGND VGND VPWR VPWR sky130_fd_sc_hd__fill_1
X_08749_ _02487_ _02489_ _02488_ VGND VGND VPWR VPWR _02508_ sky130_fd_sc_hd__o21ai_1
XFILLER_26_65 VPWR VGND VPWR VGND sky130_ef_sc_hd__decap_12
XFILLER_26_441 VGND VGND VPWR VPWR sky130_fd_sc_hd__fill_1
XFILLER_26_474 VGND VGND VPWR VPWR sky130_fd_sc_hd__fill_2
X_11760_ net201 _05494_ VGND VGND VPWR VPWR _05496_ sky130_fd_sc_hd__xnor2_1
XPHY_EDGE_ROW_95_Right_95 VGND VGND VPWR VPWR sky130_fd_sc_hd__decap_3
X_10711_ _04444_ _04454_ _04455_ VGND VGND VPWR VPWR _04457_ sky130_fd_sc_hd__and3_1
XFILLER_53_293 VPWR VGND VPWR VGND sky130_ef_sc_hd__decap_12
XFILLER_53_271 VGND VGND VPWR VPWR sky130_fd_sc_hd__fill_1
XFILLER_13_113 VPWR VGND VPWR VGND sky130_ef_sc_hd__decap_12
XFILLER_14_625 VPWR VGND VPWR VGND sky130_ef_sc_hd__decap_12
XFILLER_14_669 VPWR VGND VPWR VGND sky130_ef_sc_hd__decap_12
X_11691_ _05349_ _05352_ VGND VGND VPWR VPWR _05428_ sky130_fd_sc_hd__nand2_1
XTAP_TAPCELL_ROW_155_2829 VGND VPWR sky130_fd_sc_hd__tapvpwrvgnd_1
XTAP_TAPCELL_ROW_155_2818 VGND VPWR sky130_fd_sc_hd__tapvpwrvgnd_1
XFILLER_139_310 VPWR VGND VPWR VGND sky130_ef_sc_hd__decap_12
X_13430_ clknet_leaf_18_clk _00440_ VGND VGND VPWR VPWR u_interface.u_gelu_fp32.u_fp32_to_q16.s3_mag\[1\]
+ sky130_fd_sc_hd__dfxtp_1
X_10642_ _04387_ _04388_ _04288_ VGND VGND VPWR VPWR _04389_ sky130_fd_sc_hd__a21o_1
XFILLER_41_477 VPWR VGND VPWR VGND sky130_ef_sc_hd__decap_12
XFILLER_155_825 VGND VGND VPWR VPWR sky130_fd_sc_hd__decap_4
XFILLER_127_505 VPWR VGND VPWR VGND sky130_ef_sc_hd__decap_12
X_10573_ _04223_ _04254_ _04255_ VGND VGND VPWR VPWR _04320_ sky130_fd_sc_hd__a21bo_1
X_13361_ clknet_leaf_71_clk _00371_ VGND VGND VPWR VPWR u_interface.fifo_data\[7\]\[6\]
+ sky130_fd_sc_hd__dfxtp_1
X_13292_ clknet_leaf_53_clk _00302_ VGND VGND VPWR VPWR u_interface.fifo_data\[8\]\[1\]
+ sky130_fd_sc_hd__dfxtp_1
XFILLER_6_813 VPWR VGND VPWR VGND sky130_ef_sc_hd__decap_12
X_12312_ _06038_ _06039_ VGND VGND VPWR VPWR _06041_ sky130_fd_sc_hd__xor2_1
XFILLER_155_869 VGND VGND VPWR VPWR sky130_fd_sc_hd__fill_2
XFILLER_5_356 VGND VGND VPWR VPWR sky130_fd_sc_hd__decap_6
X_12243_ _05888_ _05905_ _05904_ VGND VGND VPWR VPWR _05973_ sky130_fd_sc_hd__o21a_1
XFILLER_154_379 VGND VGND VPWR VPWR sky130_fd_sc_hd__decap_8
XFILLER_142_519 VGND VGND VPWR VPWR sky130_fd_sc_hd__fill_2
XTAP_TAPCELL_ROW_75_1533 VGND VPWR sky130_fd_sc_hd__tapvpwrvgnd_1
XFILLER_69_809 VGND VGND VPWR VPWR sky130_fd_sc_hd__fill_2
X_12174_ _05902_ _05903_ VGND VGND VPWR VPWR _05905_ sky130_fd_sc_hd__xnor2_1
XFILLER_150_563 VGND VGND VPWR VPWR sky130_fd_sc_hd__fill_2
XFILLER_49_500 VGND VGND VPWR VPWR sky130_fd_sc_hd__decap_4
X_11125_ _04864_ _04867_ VGND VGND VPWR VPWR _04868_ sky130_fd_sc_hd__xnor2_1
XFILLER_110_438 VGND VGND VPWR VPWR sky130_fd_sc_hd__decap_4
X_11056_ _03659_ _04797_ VGND VGND VPWR VPWR _04799_ sky130_fd_sc_hd__or2_1
XFILLER_3_69 VPWR VGND VPWR VGND sky130_ef_sc_hd__decap_12
XFILLER_1_573 VPWR VGND VPWR VGND sky130_ef_sc_hd__decap_12
X_10007_ _03692_ _03700_ _03701_ VGND VGND VPWR VPWR _03759_ sky130_fd_sc_hd__a21o_1
XFILLER_77_864 VGND VGND VPWR VPWR sky130_fd_sc_hd__decap_4
XFILLER_76_352 VGND VGND VPWR VPWR sky130_fd_sc_hd__fill_1
XFILLER_76_363 VGND VGND VPWR VPWR sky130_fd_sc_hd__fill_1
XTAP_TAPCELL_ROW_106_2032 VGND VPWR sky130_fd_sc_hd__tapvpwrvgnd_1
XFILLER_91_333 VGND VGND VPWR VPWR sky130_fd_sc_hd__decap_3
XFILLER_36_249 VGND VGND VPWR VPWR sky130_fd_sc_hd__decap_3
XFILLER_17_463 VPWR VGND VPWR VGND sky130_ef_sc_hd__decap_12
X_11958_ _05682_ _05691_ VGND VGND VPWR VPWR _05692_ sky130_fd_sc_hd__xnor2_1
XFILLER_149_107 VGND VGND VPWR VPWR sky130_fd_sc_hd__decap_4
X_10909_ _04570_ _04571_ _04652_ _04653_ VGND VGND VPWR VPWR _04654_ sky130_fd_sc_hd__a22o_1
X_11889_ _05621_ _05622_ VGND VGND VPWR VPWR _05624_ sky130_fd_sc_hd__xnor2_1
X_13628_ clknet_leaf_52_clk _00638_ VGND VGND VPWR VPWR u_interface.fifo_data\[13\]\[11\]
+ sky130_fd_sc_hd__dfxtp_1
X_13559_ clknet_leaf_71_clk _00569_ VGND VGND VPWR VPWR u_interface.fifo_data\[4\]\[6\]
+ sky130_fd_sc_hd__dfxtp_1
XFILLER_145_313 VGND VGND VPWR VPWR sky130_fd_sc_hd__fill_1
XFILLER_118_527 VGND VGND VPWR VPWR sky130_fd_sc_hd__fill_1
XFILLER_73_3 VPWR VGND VPWR VGND sky130_ef_sc_hd__decap_12
XFILLER_9_673 VPWR VGND VPWR VGND sky130_ef_sc_hd__decap_12
X_07080_ net1298 net561 net207 VGND VGND VPWR VPWR _00120_ sky130_fd_sc_hd__mux2_1
XFILLER_126_582 VGND VGND VPWR VPWR sky130_fd_sc_hd__fill_1
XFILLER_141_552 VGND VGND VPWR VPWR sky130_fd_sc_hd__decap_3
X_07982_ net814 net1777 _01647_ net278 VGND VGND VPWR VPWR _01853_ sky130_fd_sc_hd__a22o_1
XFILLER_114_766 VGND VGND VPWR VPWR sky130_fd_sc_hd__decap_3
XFILLER_59_319 VGND VGND VPWR VPWR sky130_fd_sc_hd__decap_6
X_09721_ _03471_ _03475_ VGND VGND VPWR VPWR _03476_ sky130_fd_sc_hd__and2b_1
X_06933_ _01466_ _01467_ VGND VGND VPWR VPWR _00040_ sky130_fd_sc_hd__xnor2_1
X_06864_ net733 _01407_ net728 VGND VGND VPWR VPWR _01410_ sky130_fd_sc_hd__o21a_1
X_09652_ _03305_ _03308_ _03404_ net174 VGND VGND VPWR VPWR _03408_ sky130_fd_sc_hd__a211oi_2
XFILLER_103_15 VGND VGND VPWR VPWR sky130_fd_sc_hd__decap_6
XFILLER_94_160 VGND VGND VPWR VPWR sky130_fd_sc_hd__decap_4
XFILLER_82_300 VGND VGND VPWR VPWR sky130_fd_sc_hd__fill_2
XFILLER_67_385 VGND VGND VPWR VPWR sky130_fd_sc_hd__decap_6
XFILLER_27_205 VPWR VGND VPWR VGND sky130_ef_sc_hd__decap_12
X_09583_ _03287_ _03289_ _03288_ VGND VGND VPWR VPWR _03339_ sky130_fd_sc_hd__a21bo_1
XFILLER_94_193 VGND VGND VPWR VPWR sky130_fd_sc_hd__decap_3
X_08603_ net154 _02383_ net801 VGND VGND VPWR VPWR _00786_ sky130_fd_sc_hd__a21oi_1
X_06795_ _01348_ _01349_ net732 VGND VGND VPWR VPWR _01350_ sky130_fd_sc_hd__mux2_1
X_08534_ _02158_ _02324_ VGND VGND VPWR VPWR _02325_ sky130_fd_sc_hd__xnor2_1
XFILLER_36_750 VGND VGND VPWR VPWR sky130_fd_sc_hd__decap_6
XFILLER_35_271 VGND VGND VPWR VPWR sky130_fd_sc_hd__fill_1
X_08465_ _02254_ _02255_ VGND VGND VPWR VPWR _02256_ sky130_fd_sc_hd__nor2_1
XTAP_TAPCELL_ROW_42_1009 VGND VPWR sky130_fd_sc_hd__tapvpwrvgnd_1
X_07416_ _01550_ _01551_ net554 VGND VGND VPWR VPWR _01552_ sky130_fd_sc_hd__mux2_1
XTAP_TAPCELL_ROW_137_2526 VGND VPWR sky130_fd_sc_hd__tapvpwrvgnd_1
X_08396_ u_interface.u_gelu_fp32.u_synth_top.s3_mult\[27\] u_interface.u_gelu_fp32.u_synth_top.s3_b\[11\]
+ VGND VGND VPWR VPWR _02187_ sky130_fd_sc_hd__nor2_1
XFILLER_11_617 VPWR VGND VPWR VGND sky130_ef_sc_hd__decap_12
XFILLER_23_477 VPWR VGND VPWR VGND sky130_ef_sc_hd__decap_12
X_07347_ net361 net1414 net241 VGND VGND VPWR VPWR _00377_ sky130_fd_sc_hd__mux2_1
XFILLER_6_109 VPWR VGND VPWR VGND sky130_ef_sc_hd__decap_12
XTAP_TAPCELL_ROW_21_667 VGND VPWR sky130_fd_sc_hd__tapvpwrvgnd_1
XTAP_TAPCELL_ROW_21_678 VGND VPWR sky130_fd_sc_hd__tapvpwrvgnd_1
XTAP_TAPCELL_ROW_150_2737 VGND VPWR sky130_fd_sc_hd__tapvpwrvgnd_1
X_09017_ _02727_ _02769_ _02768_ VGND VGND VPWR VPWR _02776_ sky130_fd_sc_hd__a21o_1
XFILLER_136_335 VPWR VGND VPWR VGND sky130_ef_sc_hd__decap_12
X_07278_ net1507 net371 net247 VGND VGND VPWR VPWR _00308_ sky130_fd_sc_hd__mux2_1
XFILLER_151_305 VGND VGND VPWR VPWR sky130_fd_sc_hd__decap_4
XFILLER_128_67 VGND VGND VPWR VPWR sky130_fd_sc_hd__fill_1
XFILLER_124_519 VGND VGND VPWR VPWR sky130_fd_sc_hd__decap_8
Xhold161 u_interface.fifo_data\[9\]\[22\] VGND VGND VPWR VPWR net1026 sky130_fd_sc_hd__dlygate4sd3_1
XFILLER_151_349 VGND VGND VPWR VPWR sky130_fd_sc_hd__fill_1
XFILLER_132_530 VGND VGND VPWR VPWR sky130_fd_sc_hd__fill_2
XTAP_TAPCELL_ROW_57_1252 VGND VPWR sky130_fd_sc_hd__tapvpwrvgnd_1
XTAP_TAPCELL_ROW_57_1241 VGND VPWR sky130_fd_sc_hd__tapvpwrvgnd_1
Xhold150 u_interface.fifo_data\[6\]\[2\] VGND VGND VPWR VPWR net1015 sky130_fd_sc_hd__dlygate4sd3_1
Xhold172 u_interface.fifo_data\[15\]\[1\] VGND VGND VPWR VPWR net1037 sky130_fd_sc_hd__dlygate4sd3_1
Xhold194 u_interface.fifo_data\[5\]\[25\] VGND VGND VPWR VPWR net1059 sky130_fd_sc_hd__dlygate4sd3_1
Xhold183 _00897_ VGND VGND VPWR VPWR net1048 sky130_fd_sc_hd__dlygate4sd3_1
Xfanout630 net632 VGND VGND VPWR VPWR net630 sky130_fd_sc_hd__clkbuf_4
Xfanout641 u_interface.u_gelu_fp32.u_synth_top.s2_m\[7\] VGND VGND VPWR VPWR net641
+ sky130_fd_sc_hd__clkbuf_2
XFILLER_77_105 VGND VGND VPWR VPWR sky130_fd_sc_hd__decap_6
Xfanout663 net664 VGND VGND VPWR VPWR net663 sky130_fd_sc_hd__buf_2
X_09919_ _03670_ _03671_ VGND VGND VPWR VPWR _03672_ sky130_fd_sc_hd__and2b_1
XFILLER_86_650 VGND VGND VPWR VPWR sky130_fd_sc_hd__decap_4
Xfanout674 u_interface.u_gelu_fp32.u_synth_top.s2_m\[11\] VGND VGND VPWR VPWR net674
+ sky130_fd_sc_hd__clkbuf_2
XFILLER_77_149 VPWR VGND VPWR VGND sky130_ef_sc_hd__decap_12
Xfanout652 net653 VGND VGND VPWR VPWR net652 sky130_fd_sc_hd__buf_2
XTAP_TAPCELL_ROW_70_1463 VGND VPWR sky130_fd_sc_hd__tapvpwrvgnd_1
XTAP_TAPCELL_ROW_70_1452 VGND VPWR sky130_fd_sc_hd__tapvpwrvgnd_1
Xfanout685 u_interface.u_gelu_fp32.u_synth_top.s2_m\[13\] VGND VGND VPWR VPWR net685
+ sky130_fd_sc_hd__clkbuf_2
XTAP_TAPCELL_ROW_148_2699 VGND VPWR sky130_fd_sc_hd__tapvpwrvgnd_1
X_12930_ u_interface.in_flight_count\[2\] _06438_ _06451_ VGND VGND VPWR VPWR _06455_
+ sky130_fd_sc_hd__a21o_1
Xfanout696 net698 VGND VGND VPWR VPWR net696 sky130_fd_sc_hd__clkbuf_4
XFILLER_92_119 VGND VGND VPWR VPWR sky130_fd_sc_hd__fill_1
XFILLER_46_503 VPWR VGND VPWR VGND sky130_ef_sc_hd__decap_12
XFILLER_18_216 VPWR VGND VPWR VGND sky130_ef_sc_hd__decap_12
X_12861_ net1625 u_interface.u_gelu_fp32.u_fp32_to_q16.s2_norm_mag\[16\] net819 VGND
+ VGND VPWR VPWR _01005_ sky130_fd_sc_hd__mux2_1
XFILLER_46_558 VGND VGND VPWR VPWR sky130_fd_sc_hd__decap_4
XFILLER_73_366 VPWR VGND VPWR VGND sky130_ef_sc_hd__decap_12
X_11812_ _05499_ _05547_ VGND VGND VPWR VPWR _05548_ sky130_fd_sc_hd__xnor2_1
X_12792_ _01786_ net295 _06412_ VGND VGND VPWR VPWR _00956_ sky130_fd_sc_hd__and3b_1
XFILLER_27_783 VGND VGND VPWR VPWR sky130_fd_sc_hd__fill_1
X_11743_ _05478_ _05479_ VGND VGND VPWR VPWR _05480_ sky130_fd_sc_hd__nand2_1
XFILLER_14_433 VPWR VGND VPWR VGND sky130_ef_sc_hd__decap_12
XFILLER_14_499 VPWR VGND VPWR VGND sky130_ef_sc_hd__decap_12
X_11674_ _05409_ _05410_ VGND VGND VPWR VPWR _05411_ sky130_fd_sc_hd__nand2_1
X_13413_ clknet_leaf_42_clk _00423_ VGND VGND VPWR VPWR u_interface.fifo_data\[6\]\[26\]
+ sky130_fd_sc_hd__dfxtp_1
X_10625_ _04342_ _04369_ _04370_ VGND VGND VPWR VPWR _04372_ sky130_fd_sc_hd__and3_1
XTAP_TAPCELL_ROW_40_976 VGND VPWR sky130_fd_sc_hd__tapvpwrvgnd_1
XFILLER_128_869 VGND VGND VPWR VPWR sky130_fd_sc_hd__decap_4
X_10556_ _04221_ _04222_ _04301_ _04302_ VGND VGND VPWR VPWR _04304_ sky130_fd_sc_hd__nand4_2
XFILLER_6_643 VGND VGND VPWR VPWR sky130_fd_sc_hd__fill_1
X_13344_ clknet_leaf_77_clk _00354_ VGND VGND VPWR VPWR u_interface.fifo_data\[10\]\[21\]
+ sky130_fd_sc_hd__dfxtp_1
XFILLER_155_699 VGND VGND VPWR VPWR sky130_fd_sc_hd__fill_1
XFILLER_115_519 VGND VGND VPWR VPWR sky130_fd_sc_hd__decap_6
X_13275_ clknet_leaf_53_clk _00285_ VGND VGND VPWR VPWR u_interface.fifo_data\[0\]\[17\]
+ sky130_fd_sc_hd__dfxtp_1
X_10487_ _04231_ _04232_ _04233_ VGND VGND VPWR VPWR _04235_ sky130_fd_sc_hd__a21o_1
XFILLER_108_593 VPWR VGND VPWR VGND sky130_ef_sc_hd__decap_12
X_12226_ net401 net397 VGND VGND VPWR VPWR _05956_ sky130_fd_sc_hd__or2_1
X_12157_ _05886_ _05887_ VGND VGND VPWR VPWR _05888_ sky130_fd_sc_hd__nand2_1
XFILLER_151_894 VGND VGND VPWR VPWR sky130_fd_sc_hd__fill_2
XFILLER_123_574 VPWR VGND VPWR VGND sky130_ef_sc_hd__decap_12
XFILLER_78_71 VGND VGND VPWR VPWR sky130_fd_sc_hd__fill_1
X_11108_ net643 net422 _04746_ _04744_ VGND VGND VPWR VPWR _04851_ sky130_fd_sc_hd__a31o_1
XTAP_TAPCELL_ROW_9_481 VGND VPWR sky130_fd_sc_hd__tapvpwrvgnd_1
XFILLER_2_893 VPWR VGND VPWR VGND sky130_ef_sc_hd__decap_12
XFILLER_150_393 VPWR VGND VPWR VGND sky130_ef_sc_hd__decap_12
X_12088_ _05817_ _05819_ VGND VGND VPWR VPWR _05820_ sky130_fd_sc_hd__nor2_1
XFILLER_65_834 VGND VGND VPWR VPWR sky130_fd_sc_hd__decap_6
X_11039_ _04674_ _04782_ VGND VGND VPWR VPWR _04783_ sky130_fd_sc_hd__xor2_1
XTAP_TAPCELL_ROW_88_1746 VGND VPWR sky130_fd_sc_hd__tapvpwrvgnd_1
XFILLER_64_344 VGND VGND VPWR VPWR sky130_fd_sc_hd__fill_1
XFILLER_49_385 VGND VGND VPWR VPWR sky130_fd_sc_hd__decap_6
XFILLER_64_377 VPWR VGND VPWR VGND sky130_ef_sc_hd__decap_12
XFILLER_25_709 VPWR VGND VPWR VGND sky130_ef_sc_hd__decap_12
X_06580_ net535 _01168_ _00005_ VGND VGND VPWR VPWR _00006_ sky130_fd_sc_hd__nor3_1
XFILLER_17_271 VGND VGND VPWR VPWR sky130_fd_sc_hd__fill_1
XFILLER_17_293 VGND VGND VPWR VPWR sky130_fd_sc_hd__fill_1
XFILLER_33_753 VPWR VGND VPWR VGND sky130_ef_sc_hd__decap_12
X_08250_ _02070_ _02071_ VGND VGND VPWR VPWR _00745_ sky130_fd_sc_hd__nor2_1
XFILLER_33_797 VPWR VGND VPWR VGND sky130_ef_sc_hd__decap_12
XTAP_TAPCELL_ROW_119_2245 VGND VPWR sky130_fd_sc_hd__tapvpwrvgnd_1
XTAP_TAPCELL_ROW_119_2234 VGND VPWR sky130_fd_sc_hd__tapvpwrvgnd_1
X_08181_ net167 _02016_ net162 VGND VGND VPWR VPWR _02017_ sky130_fd_sc_hd__a21oi_1
X_07201_ net366 net1484 net257 VGND VGND VPWR VPWR _00241_ sky130_fd_sc_hd__mux2_1
XFILLER_32_296 VGND VGND VPWR VPWR sky130_fd_sc_hd__decap_3
X_07132_ net1411 net376 net218 VGND VGND VPWR VPWR _00172_ sky130_fd_sc_hd__mux2_1
XFILLER_145_165 VGND VGND VPWR VPWR sky130_fd_sc_hd__decap_3
XTAP_TAPCELL_ROW_132_2445 VGND VPWR sky130_fd_sc_hd__tapvpwrvgnd_1
X_07063_ net1321 net357 net209 VGND VGND VPWR VPWR _00103_ sky130_fd_sc_hd__mux2_1
XPHY_EDGE_ROW_151_Right_151 VGND VGND VPWR VPWR sky130_fd_sc_hd__decap_3
XFILLER_101_202 VGND VGND VPWR VPWR sky130_fd_sc_hd__fill_2
XFILLER_87_436 VGND VGND VPWR VPWR sky130_fd_sc_hd__fill_1
XFILLER_141_393 VPWR VGND VPWR VGND sky130_ef_sc_hd__decap_12
X_07965_ net544 _01642_ net278 _01844_ VGND VGND VPWR VPWR _00687_ sky130_fd_sc_hd__a31o_1
XFILLER_101_235 VGND VGND VPWR VPWR sky130_fd_sc_hd__fill_1
XFILLER_87_447 VGND VGND VPWR VPWR sky130_fd_sc_hd__fill_1
XFILLER_59_149 VGND VGND VPWR VPWR sky130_fd_sc_hd__fill_1
XTAP_TAPCELL_ROW_52_1160 VGND VPWR sky130_fd_sc_hd__tapvpwrvgnd_1
XFILLER_114_58 VPWR VGND VPWR VGND sky130_ef_sc_hd__decap_12
X_09704_ _03457_ _03458_ _03445_ VGND VGND VPWR VPWR _03459_ sky130_fd_sc_hd__o21a_1
X_06916_ _01449_ _01450_ VGND VGND VPWR VPWR _01454_ sky130_fd_sc_hd__nand2_1
XTAP_TAPCELL_ROW_52_1171 VGND VPWR sky130_fd_sc_hd__tapvpwrvgnd_1
X_09635_ _03382_ _03388_ _03389_ VGND VGND VPWR VPWR _03391_ sky130_fd_sc_hd__nand3_2
XFILLER_83_631 VGND VGND VPWR VPWR sky130_fd_sc_hd__decap_3
X_07896_ net1150 net564 net266 VGND VGND VPWR VPWR _00657_ sky130_fd_sc_hd__mux2_1
XFILLER_74_29 VGND VGND VPWR VPWR sky130_fd_sc_hd__decap_6
XFILLER_82_141 VPWR VGND VPWR VGND sky130_ef_sc_hd__decap_12
X_06847_ u_interface.fifo_data\[12\]\[27\] u_interface.fifo_data\[13\]\[27\] u_interface.fifo_data\[14\]\[27\]
+ u_interface.fifo_data\[15\]\[27\] net761 net744 VGND VGND VPWR VPWR _01395_ sky130_fd_sc_hd__mux4_1
XFILLER_56_878 VGND VGND VPWR VPWR sky130_fd_sc_hd__decap_4
XFILLER_28_569 VGND VGND VPWR VPWR sky130_fd_sc_hd__decap_3
X_09566_ _03320_ _03322_ net826 VGND VGND VPWR VPWR _03323_ sky130_fd_sc_hd__a21oi_1
X_06778_ u_interface.fifo_data\[4\]\[18\] u_interface.fifo_data\[5\]\[18\] u_interface.fifo_data\[6\]\[18\]
+ u_interface.fifo_data\[7\]\[18\] net765 net748 VGND VGND VPWR VPWR _01335_ sky130_fd_sc_hd__mux4_1
XFILLER_15_219 VGND VGND VPWR VPWR sky130_fd_sc_hd__decap_4
X_09497_ _03245_ _03251_ _03252_ VGND VGND VPWR VPWR _03254_ sky130_fd_sc_hd__nand3_2
XTAP_TAPCELL_ROW_26_748 VGND VPWR sky130_fd_sc_hd__tapvpwrvgnd_1
X_08517_ u_interface.u_gelu_fp32.u_synth_top.s3_mult\[51\] u_interface.u_gelu_fp32.u_synth_top.s3_mult\[50\]
+ u_interface.u_gelu_fp32.u_synth_top.s3_mult\[49\] u_interface.u_gelu_fp32.u_synth_top.s3_mult\[48\]
+ net521 VGND VGND VPWR VPWR _02308_ sky130_fd_sc_hd__o41ai_2
XTAP_TAPCELL_ROW_26_759 VGND VPWR sky130_fd_sc_hd__tapvpwrvgnd_1
X_08448_ _02177_ _02178_ VGND VGND VPWR VPWR _02239_ sky130_fd_sc_hd__nand2b_1
XFILLER_23_55 VGND VGND VPWR VPWR sky130_fd_sc_hd__fill_1
X_10410_ net627 net436 VGND VGND VPWR VPWR _04159_ sky130_fd_sc_hd__and2_1
X_08379_ net526 u_interface.u_gelu_fp32.u_synth_top.s3_mult\[37\] VGND VGND VPWR VPWR
+ _02170_ sky130_fd_sc_hd__xor2_2
XFILLER_136_110 VGND VGND VPWR VPWR sky130_fd_sc_hd__fill_1
XFILLER_109_335 VGND VGND VPWR VPWR sky130_fd_sc_hd__fill_1
XFILLER_99_15 VGND VGND VPWR VPWR sky130_fd_sc_hd__decap_4
X_11390_ _05031_ _05034_ _05033_ VGND VGND VPWR VPWR _05130_ sky130_fd_sc_hd__a21oi_1
X_10341_ net277 _03869_ _04089_ VGND VGND VPWR VPWR _04090_ sky130_fd_sc_hd__a21o_1
XFILLER_155_21 VGND VGND VPWR VPWR sky130_fd_sc_hd__decap_3
X_13060_ clknet_leaf_34_clk _00070_ VGND VGND VPWR VPWR u_interface.fifo_data\[14\]\[13\]
+ sky130_fd_sc_hd__dfxtp_1
XFILLER_118_891 VGND VGND VPWR VPWR sky130_fd_sc_hd__fill_1
X_10272_ _04020_ _04021_ _04017_ VGND VGND VPWR VPWR _04022_ sky130_fd_sc_hd__a21o_1
XFILLER_3_3 VPWR VGND VPWR VGND sky130_ef_sc_hd__decap_12
X_12011_ net717 net420 _05670_ _05742_ VGND VGND VPWR VPWR _05744_ sky130_fd_sc_hd__nand4_4
XFILLER_120_500 VGND VGND VPWR VPWR sky130_fd_sc_hd__decap_4
XFILLER_2_189 VGND VGND VPWR VPWR sky130_fd_sc_hd__decap_6
XFILLER_94_918 VGND VGND VPWR VPWR sky130_fd_sc_hd__decap_3
XFILLER_48_52 VPWR VGND VPWR VGND sky130_ef_sc_hd__decap_12
Xfanout493 net494 VGND VGND VPWR VPWR net493 sky130_fd_sc_hd__clkbuf_2
Xfanout471 u_interface.u_gelu_fp32.u_synth_top.s2_dx\[12\] VGND VGND VPWR VPWR net471
+ sky130_fd_sc_hd__buf_2
Xfanout482 u_interface.u_gelu_fp32.u_synth_top.s2_dx\[8\] VGND VGND VPWR VPWR net482
+ sky130_fd_sc_hd__buf_2
XFILLER_93_417 VPWR VGND VPWR VGND sky130_ef_sc_hd__decap_12
X_13962_ clknet_leaf_59_clk net1622 VGND VGND VPWR VPWR u_interface.u_gelu_fp32.u_q16_to_fp32.s2_mag\[7\]
+ sky130_fd_sc_hd__dfxtp_1
Xfanout460 u_interface.u_gelu_fp32.u_synth_top.s2_dx\[14\] VGND VGND VPWR VPWR net460
+ sky130_fd_sc_hd__clkbuf_4
XFILLER_48_85 VPWR VGND VPWR VGND sky130_ef_sc_hd__decap_12
XFILLER_19_503 VGND VGND VPWR VPWR sky130_fd_sc_hd__fill_1
XFILLER_19_514 VGND VGND VPWR VPWR sky130_fd_sc_hd__decap_8
X_12913_ _06439_ _06440_ VGND VGND VPWR VPWR _06441_ sky130_fd_sc_hd__nand2_2
XFILLER_74_642 VGND VGND VPWR VPWR sky130_fd_sc_hd__fill_2
XFILLER_46_333 VGND VGND VPWR VPWR sky130_fd_sc_hd__decap_4
XFILLER_46_322 VGND VGND VPWR VPWR sky130_fd_sc_hd__decap_6
XFILLER_0_15 VPWR VGND VPWR VGND sky130_ef_sc_hd__decap_12
XPHY_EDGE_ROW_100_Left_256 VGND VGND VPWR VPWR sky130_fd_sc_hd__decap_3
X_13893_ clknet_leaf_90_clk _00029_ VGND VGND VPWR VPWR u_interface.u_gelu_fp32.u_synth_top.s2_dx\[29\]
+ sky130_fd_sc_hd__dfxtp_1
XFILLER_73_152 VGND VGND VPWR VPWR sky130_fd_sc_hd__decap_8
XFILLER_19_558 VGND VGND VPWR VPWR sky130_fd_sc_hd__fill_2
X_12844_ net65 net64 net67 net66 VGND VGND VPWR VPWR _06426_ sky130_fd_sc_hd__or4_1
XFILLER_74_686 VGND VGND VPWR VPWR sky130_fd_sc_hd__fill_1
XFILLER_73_185 VGND VGND VPWR VPWR sky130_fd_sc_hd__decap_3
XFILLER_46_377 VGND VGND VPWR VPWR sky130_fd_sc_hd__decap_3
XTAP_TAPCELL_ROW_83_1665 VGND VPWR sky130_fd_sc_hd__tapvpwrvgnd_1
X_12775_ u_interface.u_gelu_fp32.u_q16_to_fp32.s3_norm_mag\[16\] _01780_ net296 VGND
+ VGND VPWR VPWR _06404_ sky130_fd_sc_hd__o21ai_1
XFILLER_15_753 VPWR VGND VPWR VGND sky130_ef_sc_hd__decap_12
XFILLER_15_797 VPWR VGND VPWR VGND sky130_ef_sc_hd__decap_12
XFILLER_30_701 VPWR VGND VPWR VGND sky130_ef_sc_hd__decap_12
X_11726_ _05460_ _05461_ VGND VGND VPWR VPWR _05463_ sky130_fd_sc_hd__xor2_1
XFILLER_9_57 VPWR VGND VPWR VGND sky130_ef_sc_hd__decap_12
XFILLER_128_622 VGND VGND VPWR VPWR sky130_fd_sc_hd__decap_8
X_11657_ _05392_ _05393_ VGND VGND VPWR VPWR _05395_ sky130_fd_sc_hd__xor2_1
X_10608_ net452 net678 net687 net456 VGND VGND VPWR VPWR _04355_ sky130_fd_sc_hd__a22o_1
X_11588_ _05325_ _05321_ VGND VGND VPWR VPWR _05326_ sky130_fd_sc_hd__nand2b_1
Xhold919 u_interface.u_gelu_fp32.u_fp32_to_q16.s1_exp\[7\] VGND VGND VPWR VPWR net1784
+ sky130_fd_sc_hd__dlygate4sd3_1
XFILLER_128_699 VGND VGND VPWR VPWR sky130_fd_sc_hd__fill_1
XFILLER_128_666 VGND VGND VPWR VPWR sky130_fd_sc_hd__decap_4
Xhold908 u_interface.u_gelu_fp32.u_fp32_to_q16.s3_mag\[9\] VGND VGND VPWR VPWR net1773
+ sky130_fd_sc_hd__dlygate4sd3_1
X_13327_ clknet_leaf_66_clk _00337_ VGND VGND VPWR VPWR u_interface.fifo_data\[10\]\[4\]
+ sky130_fd_sc_hd__dfxtp_1
X_10539_ _04143_ _04145_ _04144_ VGND VGND VPWR VPWR _04287_ sky130_fd_sc_hd__o21ba_1
XTAP_TAPCELL_ROW_114_2164 VGND VPWR sky130_fd_sc_hd__tapvpwrvgnd_1
XTAP_TAPCELL_ROW_114_2153 VGND VPWR sky130_fd_sc_hd__tapvpwrvgnd_1
XFILLER_89_70 VGND VGND VPWR VPWR sky130_fd_sc_hd__fill_2
X_13258_ clknet_leaf_62_clk _00268_ VGND VGND VPWR VPWR u_interface.fifo_data\[0\]\[0\]
+ sky130_fd_sc_hd__dfxtp_1
XFILLER_97_745 VGND VGND VPWR VPWR sky130_fd_sc_hd__fill_1
X_12209_ net177 _05873_ _05876_ VGND VGND VPWR VPWR _05939_ sky130_fd_sc_hd__nor3_1
XFILLER_36_3 VPWR VGND VPWR VGND sky130_ef_sc_hd__decap_12
X_13189_ clknet_leaf_75_clk _00199_ VGND VGND VPWR VPWR u_interface.fifo_data\[9\]\[31\]
+ sky130_fd_sc_hd__dfxtp_1
XFILLER_96_244 VGND VGND VPWR VPWR sky130_fd_sc_hd__fill_1
XFILLER_111_577 VPWR VGND VPWR VGND sky130_ef_sc_hd__decap_12
X_07750_ _01791_ _01793_ VGND VGND VPWR VPWR _00522_ sky130_fd_sc_hd__nor2_1
XFILLER_37_300 VGND VGND VPWR VPWR sky130_fd_sc_hd__fill_1
XFILLER_96_299 VGND VGND VPWR VPWR sky130_fd_sc_hd__decap_8
XFILLER_77_491 VGND VGND VPWR VPWR sky130_fd_sc_hd__decap_3
X_06701_ u_interface.fifo_data\[8\]\[9\] u_interface.fifo_data\[9\]\[9\] u_interface.fifo_data\[10\]\[9\]
+ u_interface.fifo_data\[11\]\[9\] net759 net742 VGND VGND VPWR VPWR _01267_ sky130_fd_sc_hd__mux4_1
XFILLER_37_311 VPWR VGND VPWR VGND sky130_ef_sc_hd__decap_12
X_07681_ u_interface.u_gelu_fp32.u_synth_top.s1_hits\[7\] net386 u_interface.u_gelu_fp32.u_synth_top.s1_hits\[6\]
+ VGND VGND VPWR VPWR _01756_ sky130_fd_sc_hd__or3_1
XFILLER_92_450 VGND VGND VPWR VPWR sky130_fd_sc_hd__decap_4
XFILLER_37_344 VGND VGND VPWR VPWR sky130_fd_sc_hd__fill_1
XFILLER_38_878 VGND VGND VPWR VPWR sky130_fd_sc_hd__decap_3
X_09420_ _03175_ _03176_ net510 net706 VGND VGND VPWR VPWR _03178_ sky130_fd_sc_hd__and4bb_1
X_06632_ net320 _01206_ net725 VGND VGND VPWR VPWR _01207_ sky130_fd_sc_hd__o21a_1
XFILLER_52_303 VGND VGND VPWR VPWR sky130_fd_sc_hd__decap_4
XFILLER_37_388 VGND VGND VPWR VPWR sky130_fd_sc_hd__decap_4
X_09351_ _03090_ _03092_ _03109_ _03071_ _03070_ VGND VGND VPWR VPWR _03110_ sky130_fd_sc_hd__a32o_1
X_06563_ net537 _01155_ VGND VGND VPWR VPWR _01157_ sky130_fd_sc_hd__or2_1
XFILLER_80_645 VGND VGND VPWR VPWR sky130_fd_sc_hd__decap_4
XFILLER_52_358 VGND VGND VPWR VPWR sky130_fd_sc_hd__decap_6
X_09282_ _03038_ _03040_ VGND VGND VPWR VPWR _03041_ sky130_fd_sc_hd__nand2b_1
XFILLER_100_27 VGND VGND VPWR VPWR sky130_fd_sc_hd__fill_1
X_08302_ _02108_ _02109_ VGND VGND VPWR VPWR _00759_ sky130_fd_sc_hd__nor2_1
XTAP_TAPCELL_ROW_23_707 VGND VPWR sky130_fd_sc_hd__tapvpwrvgnd_1
XFILLER_33_561 VPWR VGND VPWR VGND sky130_ef_sc_hd__decap_12
XFILLER_138_408 VGND VGND VPWR VPWR sky130_fd_sc_hd__decap_6
X_08233_ _02058_ _02060_ net289 VGND VGND VPWR VPWR _02061_ sky130_fd_sc_hd__o21ba_1
XFILLER_119_611 VGND VGND VPWR VPWR sky130_fd_sc_hd__decap_4
X_08164_ u_interface.u_gelu_fp32.u_fp32_to_q16.s3_mag\[18\] u_interface.u_gelu_fp32.u_fp32_to_q16.s3_mag\[17\]
+ _01884_ u_interface.u_gelu_fp32.u_fp32_to_q16.s3_mag\[19\] VGND VGND VPWR VPWR _02002_
+ sky130_fd_sc_hd__a31o_1
XFILLER_146_463 VPWR VGND VPWR VGND sky130_ef_sc_hd__decap_12
X_07115_ net1012 net325 net263 VGND VGND VPWR VPWR _00155_ sky130_fd_sc_hd__mux2_1
X_08095_ net313 _01943_ _01942_ VGND VGND VPWR VPWR _01945_ sky130_fd_sc_hd__o21ai_1
Xclkload70 clknet_leaf_35_clk VGND VGND VPWR VPWR clkload70/X sky130_fd_sc_hd__clkbuf_4
XFILLER_133_113 VGND VGND VPWR VPWR sky130_fd_sc_hd__decap_8
X_07046_ net1338 net566 net272 VGND VGND VPWR VPWR _00086_ sky130_fd_sc_hd__mux2_1
XFILLER_109_69 VPWR VGND VPWR VGND sky130_ef_sc_hd__decap_12
XFILLER_133_146 VGND VGND VPWR VPWR sky130_fd_sc_hd__fill_2
Xclkload81 clknet_leaf_46_clk VGND VGND VPWR VPWR clkload81/Y sky130_fd_sc_hd__clkinv_8
XFILLER_88_701 VGND VGND VPWR VPWR sky130_fd_sc_hd__fill_2
XTAP_TAPCELL_ROW_54_1200 VGND VPWR sky130_fd_sc_hd__tapvpwrvgnd_1
XFILLER_102_500 VPWR VGND VPWR VGND sky130_ef_sc_hd__decap_12
X_08997_ _02710_ _02754_ _02755_ VGND VGND VPWR VPWR _02756_ sky130_fd_sc_hd__nand3_1
XTAP_TAPCELL_ROW_145_2658 VGND VPWR sky130_fd_sc_hd__tapvpwrvgnd_1
X_07948_ _01812_ _01836_ _01815_ VGND VGND VPWR VPWR _01837_ sky130_fd_sc_hd__o21ai_1
XFILLER_141_34 VGND VGND VPWR VPWR sky130_fd_sc_hd__fill_1
X_07879_ net1464 net359 net267 VGND VGND VPWR VPWR _00640_ sky130_fd_sc_hd__mux2_1
XFILLER_18_77 VGND VGND VPWR VPWR sky130_fd_sc_hd__decap_6
XFILLER_29_889 VGND VGND VPWR VPWR sky130_fd_sc_hd__decap_6
X_09618_ _03367_ _03371_ _03372_ VGND VGND VPWR VPWR _03374_ sky130_fd_sc_hd__or3_1
X_10890_ _04510_ _04634_ VGND VGND VPWR VPWR _04635_ sky130_fd_sc_hd__nor2_1
XFILLER_56_697 VGND VGND VPWR VPWR sky130_fd_sc_hd__decap_3
X_09549_ _03166_ _03304_ VGND VGND VPWR VPWR _03306_ sky130_fd_sc_hd__xor2_1
XFILLER_70_133 VGND VGND VPWR VPWR sky130_fd_sc_hd__decap_6
XTAP_TAPCELL_ROW_65_1373 VGND VPWR sky130_fd_sc_hd__tapvpwrvgnd_1
XFILLER_12_701 VPWR VGND VPWR VGND sky130_ef_sc_hd__decap_12
X_12560_ net782 net915 VGND VGND VPWR VPWR _00858_ sky130_fd_sc_hd__and2_1
XFILLER_138_920 VGND VGND VPWR VPWR sky130_fd_sc_hd__fill_1
XFILLER_11_266 VPWR VGND VPWR VGND sky130_ef_sc_hd__decap_12
X_12491_ _06216_ VGND VGND VPWR VPWR _06217_ sky130_fd_sc_hd__inv_2
X_11511_ net214 _05249_ VGND VGND VPWR VPWR _05250_ sky130_fd_sc_hd__xor2_1
XFILLER_11_288 VPWR VGND VPWR VGND sky130_ef_sc_hd__decap_12
XFILLER_8_749 VGND VGND VPWR VPWR sky130_fd_sc_hd__decap_6
XFILLER_7_237 VPWR VGND VPWR VGND sky130_ef_sc_hd__decap_12
X_11442_ _05177_ _05181_ VGND VGND VPWR VPWR _05182_ sky130_fd_sc_hd__xnor2_1
X_11373_ net195 _05113_ VGND VGND VPWR VPWR _05114_ sky130_fd_sc_hd__xnor2_1
X_14161_ clknet_leaf_76_clk _01087_ VGND VGND VPWR VPWR u_interface.fifo_data\[1\]\[21\]
+ sky130_fd_sc_hd__dfxtp_1
X_13112_ clknet_leaf_54_clk _00122_ VGND VGND VPWR VPWR u_interface.fifo_data\[2\]\[1\]
+ sky130_fd_sc_hd__dfxtp_1
X_10324_ _03956_ _03958_ _04071_ _04072_ VGND VGND VPWR VPWR _04074_ sky130_fd_sc_hd__o211a_1
X_14092_ clknet_leaf_20_clk net1617 VGND VGND VPWR VPWR u_interface.u_gelu_fp32.u_fp32_to_q16.s2_norm_mag\[29\]
+ sky130_fd_sc_hd__dfxtp_1
XFILLER_152_477 VPWR VGND VPWR VGND sky130_ef_sc_hd__decap_12
X_13043_ clknet_leaf_35_clk _00053_ VGND VGND VPWR VPWR u_interface.fifo_tuser\[2\]
+ sky130_fd_sc_hd__dfxtp_1
X_10255_ net473 net699 VGND VGND VPWR VPWR _04005_ sky130_fd_sc_hd__and2_1
XFILLER_132_190 VGND VGND VPWR VPWR sky130_fd_sc_hd__decap_6
XFILLER_121_831 VGND VGND VPWR VPWR sky130_fd_sc_hd__decap_8
XFILLER_120_330 VGND VGND VPWR VPWR sky130_fd_sc_hd__decap_8
XFILLER_105_393 VGND VGND VPWR VPWR sky130_fd_sc_hd__fill_2
X_10186_ _03936_ _03935_ VGND VGND VPWR VPWR _03937_ sky130_fd_sc_hd__nand2b_1
XFILLER_79_745 VPWR VGND VPWR VGND sky130_ef_sc_hd__decap_12
XFILLER_67_918 VGND VGND VPWR VPWR sky130_fd_sc_hd__decap_3
XFILLER_120_363 VGND VGND VPWR VPWR sky130_fd_sc_hd__fill_1
XFILLER_120_352 VGND VGND VPWR VPWR sky130_fd_sc_hd__fill_1
Xfanout290 net293 VGND VGND VPWR VPWR net290 sky130_fd_sc_hd__dlymetal6s2s_1
XFILLER_93_225 VGND VGND VPWR VPWR sky130_fd_sc_hd__fill_1
XFILLER_19_322 VPWR VGND VPWR VGND sky130_ef_sc_hd__decap_12
X_13945_ clknet_leaf_5_clk _00012_ VGND VGND VPWR VPWR u_interface.u_gelu_fp32.u_synth_top.s1_hits\[17\]
+ sky130_fd_sc_hd__dfxtp_1
XFILLER_46_141 VPWR VGND VPWR VGND sky130_ef_sc_hd__decap_12
X_13876_ clknet_leaf_2_clk net878 VGND VGND VPWR VPWR u_interface.u_gelu_fp32.u_synth_top.s2_dx\[12\]
+ sky130_fd_sc_hd__dfxtp_1
XFILLER_19_399 VGND VGND VPWR VPWR sky130_fd_sc_hd__fill_1
XFILLER_34_325 VPWR VGND VPWR VGND sky130_ef_sc_hd__decap_12
X_12827_ net778 net87 VGND VGND VPWR VPWR _00985_ sky130_fd_sc_hd__and2_1
XFILLER_15_561 VPWR VGND VPWR VGND sky130_ef_sc_hd__decap_12
XFILLER_91_93 VGND VGND VPWR VPWR sky130_fd_sc_hd__decap_3
X_12758_ u_interface.u_gelu_fp32.u_q16_to_fp32.s3_norm_mag\[1\] u_interface.u_gelu_fp32.u_q16_to_fp32.s3_norm_mag\[0\]
+ u_interface.u_gelu_fp32.u_q16_to_fp32.s3_norm_mag\[3\] u_interface.u_gelu_fp32.u_q16_to_fp32.s3_norm_mag\[2\]
+ VGND VGND VPWR VPWR _06395_ sky130_fd_sc_hd__or4_1
XFILLER_30_531 VGND VGND VPWR VPWR sky130_fd_sc_hd__fill_1
XFILLER_42_380 VPWR VGND VPWR VGND sky130_ef_sc_hd__decap_12
X_12689_ u_interface.u_gelu_fp32.u_q16_to_fp32.s2_mag\[18\] u_interface.u_gelu_fp32.u_q16_to_fp32.s2_mag\[17\]
+ net337 VGND VGND VPWR VPWR _06349_ sky130_fd_sc_hd__mux2_1
X_11709_ net642 net391 VGND VGND VPWR VPWR _05446_ sky130_fd_sc_hd__nand2_1
XFILLER_155_293 VGND VGND VPWR VPWR sky130_fd_sc_hd__decap_4
Xhold716 u_interface.u_gelu_fp32.u_fp32_to_q16.s3_frac\[0\] VGND VGND VPWR VPWR net1581
+ sky130_fd_sc_hd__dlygate4sd3_1
Xhold727 u_interface.u_gelu_fp32.u_fp32_to_q16.s3_frac\[30\] VGND VGND VPWR VPWR net1592
+ sky130_fd_sc_hd__dlygate4sd3_1
Xhold705 u_interface.fifo_data\[7\]\[23\] VGND VGND VPWR VPWR net1570 sky130_fd_sc_hd__dlygate4sd3_1
XFILLER_116_625 VGND VGND VPWR VPWR sky130_fd_sc_hd__decap_8
XFILLER_115_113 VGND VGND VPWR VPWR sky130_fd_sc_hd__fill_1
XTAP_TAPCELL_ROW_96_1878 VGND VPWR sky130_fd_sc_hd__tapvpwrvgnd_1
XTAP_TAPCELL_ROW_96_1867 VGND VPWR sky130_fd_sc_hd__tapvpwrvgnd_1
Xhold749 u_interface.u_gelu_fp32.u_fp32_to_q16.s1_mant\[9\] VGND VGND VPWR VPWR net1614
+ sky130_fd_sc_hd__dlygate4sd3_1
XFILLER_143_455 VPWR VGND VPWR VGND sky130_ef_sc_hd__decap_12
XFILLER_116_669 VGND VGND VPWR VPWR sky130_fd_sc_hd__decap_4
Xhold738 u_interface.u_gelu_fp32.u_q16_to_fp32.s3_norm_mag\[4\] VGND VGND VPWR VPWR
+ net1603 sky130_fd_sc_hd__dlygate4sd3_1
XFILLER_143_488 VGND VGND VPWR VPWR sky130_fd_sc_hd__fill_1
X_08920_ net639 net484 _02605_ _02604_ VGND VGND VPWR VPWR _02679_ sky130_fd_sc_hd__a31o_1
X_08851_ net599 net467 net605 net470 VGND VGND VPWR VPWR _02610_ sky130_fd_sc_hd__a22o_1
XFILLER_112_864 VGND VGND VPWR VPWR sky130_fd_sc_hd__decap_4
XFILLER_111_363 VGND VGND VPWR VPWR sky130_fd_sc_hd__fill_1
XFILLER_84_203 VGND VGND VPWR VPWR sky130_fd_sc_hd__decap_3
X_07802_ net1317 net384 net229 VGND VGND VPWR VPWR _00563_ sky130_fd_sc_hd__mux2_1
X_08782_ _02539_ _02540_ _02536_ VGND VGND VPWR VPWR _02541_ sky130_fd_sc_hd__a21o_1
XTAP_TAPCELL_ROW_127_2366 VGND VPWR sky130_fd_sc_hd__tapvpwrvgnd_1
X_07733_ u_interface.u_gelu_fp32.u_q16_to_fp32.s3_norm_mag\[11\] u_interface.u_gelu_fp32.u_q16_to_fp32.s3_norm_mag\[10\]
+ _01775_ VGND VGND VPWR VPWR _01777_ sky130_fd_sc_hd__and3_1
XFILLER_72_409 VGND VGND VPWR VPWR sky130_fd_sc_hd__fill_1
X_07664_ _01745_ _01739_ _01732_ _01726_ net333 net330 VGND VGND VPWR VPWR _01746_
+ sky130_fd_sc_hd__mux4_1
XFILLER_65_461 VPWR VGND VPWR VGND sky130_ef_sc_hd__decap_12
XFILLER_26_837 VPWR VGND VPWR VGND sky130_ef_sc_hd__decap_12
X_06615_ u_interface.fifo_tuser\[12\] u_interface.fifo_tuser\[13\] u_interface.fifo_tuser\[14\]
+ u_interface.fifo_tuser\[15\] net769 net752 VGND VGND VPWR VPWR _01192_ sky130_fd_sc_hd__mux4_1
X_09403_ _03150_ _03160_ VGND VGND VPWR VPWR _03161_ sky130_fd_sc_hd__or2_1
XFILLER_111_15 VPWR VGND VPWR VGND sky130_ef_sc_hd__decap_12
XTAP_TAPCELL_ROW_140_2577 VGND VPWR sky130_fd_sc_hd__tapvpwrvgnd_1
X_07595_ net308 _01674_ VGND VGND VPWR VPWR _01693_ sky130_fd_sc_hd__and2_1
XFILLER_80_475 VGND VGND VPWR VPWR sky130_fd_sc_hd__fill_1
XFILLER_34_881 VPWR VGND VPWR VGND sky130_ef_sc_hd__decap_12
X_09334_ net600 net606 net513 net517 VGND VGND VPWR VPWR _03093_ sky130_fd_sc_hd__and4_1
X_06546_ u_interface.u_gelu_fp32.s1_data\[11\] u_interface.u_gelu_fp32.s1_data\[10\]
+ u_interface.u_gelu_fp32.s1_data\[9\] u_interface.u_gelu_fp32.s1_data\[8\] VGND VGND
+ VPWR VPWR _01142_ sky130_fd_sc_hd__or4_1
XTAP_TAPCELL_ROW_47_1092 VGND VPWR sky130_fd_sc_hd__tapvpwrvgnd_1
XTAP_TAPCELL_ROW_47_1081 VGND VPWR sky130_fd_sc_hd__tapvpwrvgnd_1
XFILLER_40_339 VGND VGND VPWR VPWR sky130_fd_sc_hd__decap_4
X_09265_ _03021_ _03022_ _03019_ VGND VGND VPWR VPWR _03024_ sky130_fd_sc_hd__a21bo_1
XFILLER_154_709 VGND VGND VPWR VPWR sky130_fd_sc_hd__decap_4
X_09196_ _02911_ _02916_ _02954_ VGND VGND VPWR VPWR _02955_ sky130_fd_sc_hd__nand3_1
XFILLER_138_238 VPWR VGND VPWR VGND sky130_ef_sc_hd__decap_12
X_08216_ _02041_ _02043_ VGND VGND VPWR VPWR _02046_ sky130_fd_sc_hd__or2_1
XTAP_TAPCELL_ROW_60_1292 VGND VPWR sky130_fd_sc_hd__tapvpwrvgnd_1
XFILLER_119_474 VGND VGND VPWR VPWR sky130_fd_sc_hd__fill_1
X_08147_ _01977_ _01978_ _01982_ VGND VGND VPWR VPWR _01988_ sky130_fd_sc_hd__nor3b_1
XFILLER_107_647 VGND VGND VPWR VPWR sky130_fd_sc_hd__decap_4
X_08078_ net292 _01930_ VGND VGND VPWR VPWR _00714_ sky130_fd_sc_hd__nor2_1
XFILLER_136_45 VGND VGND VPWR VPWR sky130_fd_sc_hd__fill_1
XFILLER_134_477 VGND VGND VPWR VPWR sky130_fd_sc_hd__fill_2
XFILLER_122_639 VGND VGND VPWR VPWR sky130_fd_sc_hd__decap_4
XFILLER_121_105 VGND VGND VPWR VPWR sky130_fd_sc_hd__fill_1
X_07029_ net1284 net360 net270 VGND VGND VPWR VPWR _00069_ sky130_fd_sc_hd__mux2_1
XFILLER_121_149 VGND VGND VPWR VPWR sky130_fd_sc_hd__decap_3
XFILLER_114_190 VGND VGND VPWR VPWR sky130_fd_sc_hd__fill_1
X_10040_ net588 net596 net432 net428 VGND VGND VPWR VPWR _03792_ sky130_fd_sc_hd__and4_1
Xhold21 u_interface.u_gelu_fp32.s1_data\[9\] VGND VGND VPWR VPWR net886 sky130_fd_sc_hd__dlygate4sd3_1
Xhold10 u_interface.u_gelu_fp32.u_synth_top.s1_x\[13\] VGND VGND VPWR VPWR net875
+ sky130_fd_sc_hd__dlygate4sd3_1
Xhold32 u_interface.u_gelu_fp32.s1_data\[23\] VGND VGND VPWR VPWR net897 sky130_fd_sc_hd__dlygate4sd3_1
XFILLER_49_918 VGND VGND VPWR VPWR sky130_fd_sc_hd__decap_3
XFILLER_48_417 VGND VGND VPWR VPWR sky130_fd_sc_hd__decap_3
Xhold54 u_interface.meta_tuser_pipe\[8\] VGND VGND VPWR VPWR net919 sky130_fd_sc_hd__dlygate4sd3_1
Xhold65 u_interface.u_gelu_fp32.u_fp32_to_q16.s2_overflow VGND VGND VPWR VPWR net930
+ sky130_fd_sc_hd__dlygate4sd3_1
Xhold43 u_interface.u_gelu_fp32.s1_data\[22\] VGND VGND VPWR VPWR net908 sky130_fd_sc_hd__dlygate4sd3_1
XFILLER_75_225 VGND VGND VPWR VPWR sky130_fd_sc_hd__decap_8
XFILLER_152_77 VGND VGND VPWR VPWR sky130_fd_sc_hd__decap_6
Xhold87 u_interface.u_gelu_fp32.u_fp32_to_q16.s1_mant\[5\] VGND VGND VPWR VPWR net952
+ sky130_fd_sc_hd__dlygate4sd3_1
Xhold98 u_interface.fifo_tlast\[0\] VGND VGND VPWR VPWR net963 sky130_fd_sc_hd__dlygate4sd3_1
Xhold76 u_interface.meta_tuser_pipe\[5\] VGND VGND VPWR VPWR net941 sky130_fd_sc_hd__dlygate4sd3_1
XFILLER_63_409 VPWR VGND VPWR VGND sky130_ef_sc_hd__decap_12
XFILLER_28_141 VGND VGND VPWR VPWR sky130_fd_sc_hd__decap_8
XFILLER_29_653 VPWR VGND VPWR VGND sky130_ef_sc_hd__decap_12
X_11991_ net184 _05653_ _05652_ VGND VGND VPWR VPWR _05724_ sky130_fd_sc_hd__a21o_1
X_13730_ clknet_leaf_7_clk _00740_ VGND VGND VPWR VPWR u_interface.u_gelu_fp32.s1_data\[30\]
+ sky130_fd_sc_hd__dfxtp_1
XFILLER_91_729 VGND VGND VPWR VPWR sky130_fd_sc_hd__fill_1
XTAP_TAPCELL_ROW_67_1413 VGND VPWR sky130_fd_sc_hd__tapvpwrvgnd_1
XTAP_TAPCELL_ROW_67_1402 VGND VPWR sky130_fd_sc_hd__tapvpwrvgnd_1
X_10942_ _04226_ _04576_ _04685_ VGND VGND VPWR VPWR _04686_ sky130_fd_sc_hd__a21oi_1
XFILLER_44_623 VGND VGND VPWR VPWR sky130_fd_sc_hd__decap_3
XFILLER_16_314 VGND VGND VPWR VPWR sky130_fd_sc_hd__decap_8
XFILLER_29_697 VPWR VGND VPWR VGND sky130_ef_sc_hd__decap_12
X_13661_ clknet_leaf_14_clk _00671_ VGND VGND VPWR VPWR u_interface.u_gelu_fp32.u_fp32_to_q16.s1_exp\[7\]
+ sky130_fd_sc_hd__dfxtp_1
X_10873_ _04511_ _04513_ _04512_ VGND VGND VPWR VPWR _04618_ sky130_fd_sc_hd__o21ba_1
X_13592_ clknet_leaf_44_clk _00602_ VGND VGND VPWR VPWR u_interface.fifo_data\[3\]\[7\]
+ sky130_fd_sc_hd__dfxtp_1
XTAP_TAPCELL_ROW_80_1613 VGND VPWR sky130_fd_sc_hd__tapvpwrvgnd_1
X_12612_ u_interface.u_gelu_fp32.u_q16_to_fp32.s1_mag\[13\] net211 net186 _06314_
+ u_interface.u_gelu_fp32.u_q16_to_fp32.s1_mag\[29\] VGND VGND VPWR VPWR _06315_ sky130_fd_sc_hd__a221o_1
XFILLER_101_81 VGND VGND VPWR VPWR sky130_fd_sc_hd__decap_3
XFILLER_8_513 VPWR VGND VPWR VGND sky130_ef_sc_hd__decap_12
X_12543_ _06262_ _06266_ VGND VGND VPWR VPWR _06267_ sky130_fd_sc_hd__xnor2_1
XFILLER_12_531 VGND VGND VPWR VPWR sky130_fd_sc_hd__fill_1
XTAP_TAPCELL_ROW_14_559 VGND VPWR sky130_fd_sc_hd__tapvpwrvgnd_1
XFILLER_40_895 VGND VGND VPWR VPWR sky130_fd_sc_hd__fill_1
X_12474_ _06135_ _06152_ _06151_ VGND VGND VPWR VPWR _06200_ sky130_fd_sc_hd__a21bo_1
XFILLER_8_557 VPWR VGND VPWR VGND sky130_ef_sc_hd__decap_12
XANTENNA_7 u_interface.u_gelu_fp32.u_synth_top.s2_b\[1\] VGND VGND VPWR VPWR sky130_fd_sc_hd__diode_2
X_11425_ net667 net419 net412 net659 VGND VGND VPWR VPWR _05165_ sky130_fd_sc_hd__a22o_1
XFILLER_152_241 VGND VGND VPWR VPWR sky130_fd_sc_hd__decap_8
XFILLER_141_915 VGND VGND VPWR VPWR sky130_fd_sc_hd__fill_2
XTAP_TAPCELL_ROW_111_2112 VGND VPWR sky130_fd_sc_hd__tapvpwrvgnd_1
X_14144_ clknet_leaf_48_clk _01070_ VGND VGND VPWR VPWR u_interface.fifo_data\[1\]\[4\]
+ sky130_fd_sc_hd__dfxtp_1
XTAP_TAPCELL_ROW_78_1586 VGND VPWR sky130_fd_sc_hd__tapvpwrvgnd_1
X_11356_ _05094_ _05095_ VGND VGND VPWR VPWR _05097_ sky130_fd_sc_hd__xnor2_2
X_14075_ clknet_leaf_17_clk net1359 VGND VGND VPWR VPWR u_interface.u_gelu_fp32.u_fp32_to_q16.s2_norm_mag\[12\]
+ sky130_fd_sc_hd__dfxtp_1
XFILLER_113_617 VGND VGND VPWR VPWR sky130_fd_sc_hd__decap_8
X_10307_ _03937_ _03939_ _04056_ VGND VGND VPWR VPWR _04057_ sky130_fd_sc_hd__a21o_1
XFILLER_112_127 VPWR VGND VPWR VGND sky130_ef_sc_hd__decap_12
X_11287_ net185 _05027_ VGND VGND VPWR VPWR _05028_ sky130_fd_sc_hd__xor2_1
XFILLER_3_273 VGND VGND VPWR VPWR sky130_fd_sc_hd__decap_6
X_13026_ net170 net165 net161 net160 _06250_ VGND VGND VPWR VPWR _00853_ sky130_fd_sc_hd__o2111a_1
XTAP_TAPCELL_ROW_91_1797 VGND VPWR sky130_fd_sc_hd__tapvpwrvgnd_1
XTAP_TAPCELL_ROW_91_1786 VGND VPWR sky130_fd_sc_hd__tapvpwrvgnd_1
X_10238_ _03977_ _03985_ _03986_ VGND VGND VPWR VPWR _03988_ sky130_fd_sc_hd__nand3_1
XFILLER_39_406 VGND VGND VPWR VPWR sky130_fd_sc_hd__fill_1
X_10169_ _03800_ _03917_ _03918_ VGND VGND VPWR VPWR _03920_ sky130_fd_sc_hd__nand3_1
XFILLER_39_428 VGND VGND VPWR VPWR sky130_fd_sc_hd__fill_1
XTAP_TAPCELL_ROW_109_2074 VGND VPWR sky130_fd_sc_hd__tapvpwrvgnd_1
XFILLER_19_141 VGND VGND VPWR VPWR sky130_fd_sc_hd__fill_1
XTAP_TAPCELL_ROW_109_2085 VGND VPWR sky130_fd_sc_hd__tapvpwrvgnd_1
XFILLER_94_589 VPWR VGND VPWR VGND sky130_ef_sc_hd__decap_12
X_13928_ clknet_leaf_5_clk _00004_ VGND VGND VPWR VPWR u_interface.u_gelu_fp32.u_synth_top.s1_hits\[0\]
+ sky130_fd_sc_hd__dfxtp_1
XFILLER_81_228 VPWR VGND VPWR VGND sky130_ef_sc_hd__decap_12
XFILLER_35_601 VPWR VGND VPWR VGND sky130_ef_sc_hd__decap_12
XFILLER_47_494 VGND VGND VPWR VPWR sky130_fd_sc_hd__fill_1
XTAP_TAPCELL_ROW_122_2285 VGND VPWR sky130_fd_sc_hd__tapvpwrvgnd_1
X_13859_ clknet_leaf_87_clk _00869_ VGND VGND VPWR VPWR u_interface.u_gelu_fp32.u_synth_top.s3_b\[15\]
+ sky130_fd_sc_hd__dfxtp_1
XFILLER_22_306 VGND VGND VPWR VPWR sky130_fd_sc_hd__fill_2
X_07380_ net1241 net358 net239 VGND VGND VPWR VPWR _00410_ sky130_fd_sc_hd__mux2_1
XFILLER_16_881 VPWR VGND VPWR VGND sky130_ef_sc_hd__decap_12
XFILLER_15_391 VGND VGND VPWR VPWR sky130_fd_sc_hd__fill_1
XTAP_TAPCELL_ROW_33_857 VGND VPWR sky130_fd_sc_hd__tapvpwrvgnd_1
XTAP_TAPCELL_ROW_33_868 VGND VPWR sky130_fd_sc_hd__tapvpwrvgnd_1
X_09050_ _02758_ _02759_ _02754_ VGND VGND VPWR VPWR _02809_ sky130_fd_sc_hd__a21bo_1
XTAP_TAPCELL_ROW_98_1907 VGND VPWR sky130_fd_sc_hd__tapvpwrvgnd_1
XFILLER_31_895 VGND VGND VPWR VPWR sky130_fd_sc_hd__fill_1
X_08001_ net814 net1605 net301 _01692_ _01865_ VGND VGND VPWR VPWR _00702_ sky130_fd_sc_hd__a221o_1
Xhold502 u_interface.fifo_tuser\[4\] VGND VGND VPWR VPWR net1367 sky130_fd_sc_hd__dlygate4sd3_1
Xhold513 u_interface.u_gelu_fp32.u_fp32_to_q16.s1_mant\[3\] VGND VGND VPWR VPWR net1378
+ sky130_fd_sc_hd__dlygate4sd3_1
Xhold524 u_interface.fifo_data\[10\]\[7\] VGND VGND VPWR VPWR net1389 sky130_fd_sc_hd__dlygate4sd3_1
XFILLER_116_433 VGND VGND VPWR VPWR sky130_fd_sc_hd__fill_2
Xhold535 u_interface.fifo_data\[4\]\[15\] VGND VGND VPWR VPWR net1400 sky130_fd_sc_hd__dlygate4sd3_1
Xhold579 u_interface.fifo_tlast\[7\] VGND VGND VPWR VPWR net1444 sky130_fd_sc_hd__dlygate4sd3_1
X_09952_ net612 net450 _03571_ _03570_ VGND VGND VPWR VPWR _03705_ sky130_fd_sc_hd__a31o_1
XFILLER_89_328 VGND VGND VPWR VPWR sky130_fd_sc_hd__decap_8
Xhold568 u_interface.fifo_data\[15\]\[4\] VGND VGND VPWR VPWR net1433 sky130_fd_sc_hd__dlygate4sd3_1
Xhold546 u_interface.fifo_data\[9\]\[4\] VGND VGND VPWR VPWR net1411 sky130_fd_sc_hd__dlygate4sd3_1
Xhold557 u_interface.fifo_data\[9\]\[20\] VGND VGND VPWR VPWR net1422 sky130_fd_sc_hd__dlygate4sd3_1
XTAP_TAPCELL_ROW_129_2406 VGND VPWR sky130_fd_sc_hd__tapvpwrvgnd_1
X_08903_ net515 net706 net519 net714 VGND VGND VPWR VPWR _02662_ sky130_fd_sc_hd__a22o_1
XFILLER_106_26 VGND VGND VPWR VPWR sky130_fd_sc_hd__fill_2
X_09883_ net483 net688 _03581_ _03580_ VGND VGND VPWR VPWR _03636_ sky130_fd_sc_hd__a31o_1
XFILLER_85_501 VGND VGND VPWR VPWR sky130_fd_sc_hd__decap_3
XFILLER_58_715 VGND VGND VPWR VPWR sky130_fd_sc_hd__decap_3
X_08834_ _02582_ _02592_ VGND VGND VPWR VPWR _02593_ sky130_fd_sc_hd__nand2_1
XTAP_TAPCELL_ROW_142_2606 VGND VPWR sky130_fd_sc_hd__tapvpwrvgnd_1
X_08765_ _02520_ _02521_ _02522_ VGND VGND VPWR VPWR _02524_ sky130_fd_sc_hd__nand3_1
X_07716_ _01768_ _01769_ VGND VGND VPWR VPWR _00512_ sky130_fd_sc_hd__or2_1
XFILLER_26_601 VPWR VGND VPWR VGND sky130_ef_sc_hd__decap_12
X_08696_ net679 net511 _02448_ _02449_ VGND VGND VPWR VPWR _02455_ sky130_fd_sc_hd__o2bb2a_1
XFILLER_82_29 VPWR VGND VPWR VGND sky130_ef_sc_hd__decap_12
XTAP_TAPCELL_ROW_49_1121 VGND VPWR sky130_fd_sc_hd__tapvpwrvgnd_1
XFILLER_25_111 VGND VGND VPWR VPWR sky130_fd_sc_hd__fill_1
XFILLER_26_645 VPWR VGND VPWR VGND sky130_ef_sc_hd__decap_12
X_07647_ _01732_ _01726_ _01719_ _01711_ net333 net330 VGND VGND VPWR VPWR _01733_
+ sky130_fd_sc_hd__mux4_1
XFILLER_41_604 VPWR VGND VPWR VGND sky130_ef_sc_hd__decap_12
X_07578_ net310 _01620_ VGND VGND VPWR VPWR _01686_ sky130_fd_sc_hd__and2_1
XTAP_TAPCELL_ROW_62_1321 VGND VPWR sky130_fd_sc_hd__tapvpwrvgnd_1
X_09317_ _03046_ _03048_ _03047_ VGND VGND VPWR VPWR _03076_ sky130_fd_sc_hd__o21ai_1
X_06529_ u_interface.u_gelu_fp32.u_synth_top.s1_hits\[15\] u_interface.u_gelu_fp32.u_synth_top.s1_hits\[5\]
+ VGND VGND VPWR VPWR _01128_ sky130_fd_sc_hd__or2_2
XTAP_TAPCELL_ROW_62_1332 VGND VPWR sky130_fd_sc_hd__tapvpwrvgnd_1
XFILLER_139_558 VGND VGND VPWR VPWR sky130_fd_sc_hd__fill_2
XTAP_TAPCELL_ROW_11_507 VGND VPWR sky130_fd_sc_hd__tapvpwrvgnd_1
XTAP_TAPCELL_ROW_11_518 VGND VPWR sky130_fd_sc_hd__tapvpwrvgnd_1
X_09248_ _03005_ _03006_ VGND VGND VPWR VPWR _03007_ sky130_fd_sc_hd__nor2_1
XFILLER_139_569 VGND VGND VPWR VPWR sky130_fd_sc_hd__fill_1
XFILLER_5_505 VPWR VGND VPWR VGND sky130_ef_sc_hd__decap_12
XTAP_TAPCELL_ROW_153_2779 VGND VPWR sky130_fd_sc_hd__tapvpwrvgnd_1
X_09179_ _02935_ _02936_ _02933_ VGND VGND VPWR VPWR _02938_ sky130_fd_sc_hd__a21bo_1
XFILLER_31_55 VGND VGND VPWR VPWR sky130_fd_sc_hd__fill_1
XFILLER_135_753 VGND VGND VPWR VPWR sky130_fd_sc_hd__decap_6
X_11210_ net687 net434 VGND VGND VPWR VPWR _04952_ sky130_fd_sc_hd__and2_1
X_12190_ _05918_ _05919_ VGND VGND VPWR VPWR _05921_ sky130_fd_sc_hd__xor2_1
XFILLER_135_775 VGND VGND VPWR VPWR sky130_fd_sc_hd__decap_8
XFILLER_134_263 VGND VGND VPWR VPWR sky130_fd_sc_hd__fill_1
XFILLER_103_3 VPWR VGND VPWR VGND sky130_ef_sc_hd__decap_12
X_11141_ _04881_ _04882_ VGND VGND VPWR VPWR _04884_ sky130_fd_sc_hd__xnor2_2
XFILLER_122_436 VPWR VGND VPWR VGND sky130_ef_sc_hd__decap_12
XFILLER_107_499 VGND VGND VPWR VPWR sky130_fd_sc_hd__decap_4
XFILLER_0_221 VGND VGND VPWR VPWR sky130_fd_sc_hd__decap_3
Xinput100 s_axis_tdata[4] VGND VGND VPWR VPWR net100 sky130_fd_sc_hd__clkbuf_1
XFILLER_122_469 VGND VGND VPWR VPWR sky130_fd_sc_hd__decap_6
XFILLER_76_501 VGND VGND VPWR VPWR sky130_fd_sc_hd__fill_1
X_11072_ net452 net712 net719 net456 VGND VGND VPWR VPWR _04815_ sky130_fd_sc_hd__a22o_1
XFILLER_1_777 VGND VGND VPWR VPWR sky130_fd_sc_hd__decap_6
XFILLER_103_683 VGND VGND VPWR VPWR sky130_fd_sc_hd__fill_1
X_10023_ _03643_ _03645_ _03771_ _03772_ VGND VGND VPWR VPWR _03775_ sky130_fd_sc_hd__a211oi_1
XFILLER_0_265 VPWR VGND VPWR VGND sky130_ef_sc_hd__decap_12
XFILLER_76_556 VPWR VGND VPWR VGND sky130_ef_sc_hd__decap_12
XFILLER_56_41 VGND VGND VPWR VPWR sky130_fd_sc_hd__decap_8
XFILLER_56_74 VGND VGND VPWR VPWR sky130_fd_sc_hd__fill_2
X_11974_ _05705_ _05706_ VGND VGND VPWR VPWR _05708_ sky130_fd_sc_hd__or2_1
X_13713_ clknet_leaf_2_clk _00723_ VGND VGND VPWR VPWR u_interface.u_gelu_fp32.s1_data\[13\]
+ sky130_fd_sc_hd__dfxtp_1
X_10925_ _04441_ _04669_ _04552_ VGND VGND VPWR VPWR _04670_ sky130_fd_sc_hd__o21ba_1
XFILLER_44_464 VPWR VGND VPWR VGND sky130_ef_sc_hd__decap_12
XFILLER_16_133 VGND VGND VPWR VPWR sky130_fd_sc_hd__decap_6
X_13644_ clknet_leaf_67_clk _00654_ VGND VGND VPWR VPWR u_interface.fifo_data\[13\]\[27\]
+ sky130_fd_sc_hd__dfxtp_1
X_10856_ net686 net448 _04600_ VGND VGND VPWR VPWR _04601_ sky130_fd_sc_hd__a21oi_1
XFILLER_31_125 VGND VGND VPWR VPWR sky130_fd_sc_hd__decap_8
XFILLER_32_637 VGND VGND VPWR VPWR sky130_fd_sc_hd__decap_6
X_13575_ clknet_leaf_35_clk _00585_ VGND VGND VPWR VPWR u_interface.fifo_data\[4\]\[22\]
+ sky130_fd_sc_hd__dfxtp_1
X_10787_ _04508_ _04509_ _04531_ _04532_ VGND VGND VPWR VPWR _04533_ sky130_fd_sc_hd__a22oi_2
XFILLER_9_833 VGND VGND VPWR VPWR sky130_fd_sc_hd__decap_6
XFILLER_13_895 VGND VGND VPWR VPWR sky130_fd_sc_hd__fill_1
XTAP_TAPCELL_ROW_30_816 VGND VPWR sky130_fd_sc_hd__tapvpwrvgnd_1
XFILLER_9_877 VPWR VGND VPWR VGND sky130_ef_sc_hd__decap_12
X_12526_ net772 _06249_ net151 VGND VGND VPWR VPWR _00842_ sky130_fd_sc_hd__and3_1
XFILLER_8_365 VGND VGND VPWR VPWR sky130_fd_sc_hd__fill_2
X_12457_ _06181_ _06182_ VGND VGND VPWR VPWR _06183_ sky130_fd_sc_hd__nor2_2
XFILLER_125_230 VGND VGND VPWR VPWR sky130_fd_sc_hd__decap_3
XTAP_TAPCELL_ROW_93_1826 VGND VPWR sky130_fd_sc_hd__tapvpwrvgnd_1
X_11408_ _05046_ _05147_ VGND VGND VPWR VPWR _05148_ sky130_fd_sc_hd__xor2_1
X_14127_ clknet_leaf_30_clk _01053_ VGND VGND VPWR VPWR u_interface.in_flight_count\[0\]
+ sky130_fd_sc_hd__dfxtp_1
XFILLER_99_604 VPWR VGND VPWR VGND sky130_ef_sc_hd__decap_12
X_12388_ net192 _06115_ VGND VGND VPWR VPWR _06116_ sky130_fd_sc_hd__or2_1
X_11339_ _05078_ _05079_ VGND VGND VPWR VPWR _05080_ sky130_fd_sc_hd__nor2_1
X_14058_ clknet_leaf_17_clk _00984_ VGND VGND VPWR VPWR u_interface.u_gelu_fp32.u_fp32_to_q16.s1_mant\[20\]
+ sky130_fd_sc_hd__dfxtp_1
XFILLER_140_299 VGND VGND VPWR VPWR sky130_fd_sc_hd__fill_1
X_13009_ net1279 net571 net223 VGND VGND VPWR VPWR _01092_ sky130_fd_sc_hd__mux2_1
X_06880_ net320 _01421_ net725 VGND VGND VPWR VPWR _01424_ sky130_fd_sc_hd__o21a_1
XFILLER_39_225 VGND VGND VPWR VPWR sky130_fd_sc_hd__decap_8
XFILLER_94_353 VGND VGND VPWR VPWR sky130_fd_sc_hd__fill_2
XFILLER_94_331 VGND VGND VPWR VPWR sky130_fd_sc_hd__fill_1
XTAP_TAPCELL_ROW_124_2325 VGND VPWR sky130_fd_sc_hd__tapvpwrvgnd_1
XTAP_TAPCELL_ROW_124_2314 VGND VPWR sky130_fd_sc_hd__tapvpwrvgnd_1
XFILLER_36_910 VGND VGND VPWR VPWR sky130_fd_sc_hd__decap_3
XTAP_TAPCELL_ROW_38_938 VGND VPWR sky130_fd_sc_hd__tapvpwrvgnd_1
XFILLER_94_397 VPWR VGND VPWR VGND sky130_ef_sc_hd__decap_12
X_08550_ _02320_ _02340_ VGND VGND VPWR VPWR _02341_ sky130_fd_sc_hd__and2_1
XTAP_TAPCELL_ROW_38_949 VGND VPWR sky130_fd_sc_hd__tapvpwrvgnd_1
X_07501_ net550 _01563_ VGND VGND VPWR VPWR _01633_ sky130_fd_sc_hd__nand2_1
XFILLER_35_475 VGND VGND VPWR VPWR sky130_fd_sc_hd__fill_2
X_08481_ net522 u_interface.u_gelu_fp32.u_synth_top.s3_mult\[42\] VGND VGND VPWR VPWR
+ _02272_ sky130_fd_sc_hd__or2_1
X_07432_ net548 _01567_ VGND VGND VPWR VPWR _01568_ sky130_fd_sc_hd__and2_1
XTAP_TAPCELL_ROW_102_1966 VGND VPWR sky130_fd_sc_hd__tapvpwrvgnd_1
XTAP_TAPCELL_ROW_44_1040 VGND VPWR sky130_fd_sc_hd__tapvpwrvgnd_1
X_07363_ net567 net1461 net244 VGND VGND VPWR VPWR _00393_ sky130_fd_sc_hd__mux2_1
X_09102_ _02821_ _02854_ VGND VGND VPWR VPWR _02861_ sky130_fd_sc_hd__and2_1
XFILLER_10_309 VPWR VGND VPWR VGND sky130_ef_sc_hd__decap_12
X_07294_ net1054 net577 net247 VGND VGND VPWR VPWR _00324_ sky130_fd_sc_hd__mux2_1
X_09033_ net663 net516 net520 net671 VGND VGND VPWR VPWR _02792_ sky130_fd_sc_hd__a22oi_1
XFILLER_136_517 VGND VGND VPWR VPWR sky130_fd_sc_hd__decap_3
XTAP_TAPCELL_ROW_135_2498 VGND VPWR sky130_fd_sc_hd__tapvpwrvgnd_1
Xhold310 u_interface.fifo_data\[14\]\[11\] VGND VGND VPWR VPWR net1175 sky130_fd_sc_hd__dlygate4sd3_1
XFILLER_116_274 VGND VGND VPWR VPWR sky130_fd_sc_hd__fill_2
Xhold332 u_interface.u_gelu_fp32.u_q16_to_fp32.s1_mag\[8\] VGND VGND VPWR VPWR net1197
+ sky130_fd_sc_hd__dlygate4sd3_1
Xhold321 u_interface.fifo_data\[6\]\[6\] VGND VGND VPWR VPWR net1186 sky130_fd_sc_hd__dlygate4sd3_1
Xhold343 u_interface.fifo_data\[10\]\[2\] VGND VGND VPWR VPWR net1208 sky130_fd_sc_hd__dlygate4sd3_1
Xhold354 u_interface.fifo_data\[8\]\[10\] VGND VGND VPWR VPWR net1219 sky130_fd_sc_hd__dlygate4sd3_1
XFILLER_132_734 VGND VGND VPWR VPWR sky130_fd_sc_hd__fill_1
Xhold376 u_interface.fifo_data\[6\]\[13\] VGND VGND VPWR VPWR net1241 sky130_fd_sc_hd__dlygate4sd3_1
XFILLER_104_447 VPWR VGND VPWR VGND sky130_ef_sc_hd__decap_12
XFILLER_104_436 VGND VGND VPWR VPWR sky130_fd_sc_hd__decap_8
Xhold387 u_interface.fifo_data\[10\]\[4\] VGND VGND VPWR VPWR net1252 sky130_fd_sc_hd__dlygate4sd3_1
Xhold365 u_interface.u_gelu_fp32.u_q16_to_fp32.s3_norm_mag\[3\] VGND VGND VPWR VPWR
+ net1230 sky130_fd_sc_hd__dlygate4sd3_1
Xfanout812 net822 VGND VGND VPWR VPWR net812 sky130_fd_sc_hd__clkbuf_2
Xfanout823 net826 VGND VGND VPWR VPWR net823 sky130_fd_sc_hd__clkbuf_4
X_09935_ net483 net699 VGND VGND VPWR VPWR _03688_ sky130_fd_sc_hd__nand2_1
Xfanout801 net809 VGND VGND VPWR VPWR net801 sky130_fd_sc_hd__buf_2
Xhold398 u_interface.fifo_data\[0\]\[21\] VGND VGND VPWR VPWR net1263 sky130_fd_sc_hd__dlygate4sd3_1
XFILLER_131_299 VGND VGND VPWR VPWR sky130_fd_sc_hd__fill_1
X_09866_ _03618_ net172 _03467_ _03511_ VGND VGND VPWR VPWR _03620_ sky130_fd_sc_hd__o211a_1
X_08817_ _02559_ _02574_ _02575_ VGND VGND VPWR VPWR _02576_ sky130_fd_sc_hd__nand3_2
XFILLER_58_567 VGND VGND VPWR VPWR sky130_fd_sc_hd__fill_1
X_09797_ _03542_ _03548_ _03549_ VGND VGND VPWR VPWR _03551_ sky130_fd_sc_hd__nand3_2
XFILLER_85_386 VGND VGND VPWR VPWR sky130_fd_sc_hd__decap_6
XFILLER_45_206 VPWR VGND VPWR VGND sky130_ef_sc_hd__decap_12
X_08748_ net613 net485 _02505_ _02503_ VGND VGND VPWR VPWR _02507_ sky130_fd_sc_hd__a31o_1
XFILLER_54_751 VGND VGND VPWR VPWR sky130_fd_sc_hd__decap_4
X_08679_ net772 _02353_ net152 VGND VGND VPWR VPWR _00807_ sky130_fd_sc_hd__and3_1
X_10710_ _04454_ _04455_ _04444_ VGND VGND VPWR VPWR _04456_ sky130_fd_sc_hd__a21oi_1
XFILLER_14_637 VGND VGND VPWR VPWR sky130_fd_sc_hd__decap_6
XFILLER_26_77 VGND VGND VPWR VPWR sky130_fd_sc_hd__decap_6
XTAP_TAPCELL_ROW_155_2808 VGND VPWR sky130_fd_sc_hd__tapvpwrvgnd_1
XFILLER_13_125 VPWR VGND VPWR VGND sky130_ef_sc_hd__decap_12
X_11690_ _05413_ _05426_ VGND VGND VPWR VPWR _05427_ sky130_fd_sc_hd__xor2_1
XTAP_TAPCELL_ROW_155_2819 VGND VPWR sky130_fd_sc_hd__tapvpwrvgnd_1
X_10641_ _04378_ _04385_ _04386_ VGND VGND VPWR VPWR _04388_ sky130_fd_sc_hd__nand3_2
XFILLER_13_169 VGND VGND VPWR VPWR sky130_fd_sc_hd__fill_2
XFILLER_41_489 VGND VGND VPWR VPWR sky130_fd_sc_hd__decap_6
XFILLER_155_804 VGND VGND VPWR VPWR sky130_fd_sc_hd__decap_4
X_10572_ _04216_ _04218_ VGND VGND VPWR VPWR _04319_ sky130_fd_sc_hd__nand2_1
X_13360_ clknet_leaf_70_clk _00370_ VGND VGND VPWR VPWR u_interface.fifo_data\[7\]\[5\]
+ sky130_fd_sc_hd__dfxtp_1
XFILLER_22_681 VPWR VGND VPWR VGND sky130_ef_sc_hd__decap_12
XFILLER_42_76 VGND VGND VPWR VPWR sky130_fd_sc_hd__fill_1
XFILLER_139_399 VGND VGND VPWR VPWR sky130_fd_sc_hd__fill_1
XFILLER_127_517 VPWR VGND VPWR VGND sky130_ef_sc_hd__decap_12
X_13291_ clknet_leaf_63_clk _00301_ VGND VGND VPWR VPWR u_interface.fifo_data\[8\]\[0\]
+ sky130_fd_sc_hd__dfxtp_1
XFILLER_6_825 VPWR VGND VPWR VGND sky130_ef_sc_hd__decap_12
X_12311_ _06038_ _06039_ VGND VGND VPWR VPWR _06040_ sky130_fd_sc_hd__nor2_1
XFILLER_154_347 VGND VGND VPWR VPWR sky130_fd_sc_hd__fill_1
X_12242_ _05955_ _05971_ VGND VGND VPWR VPWR _05972_ sky130_fd_sc_hd__xor2_1
XFILLER_6_869 VPWR VGND VPWR VGND sky130_ef_sc_hd__decap_12
XFILLER_108_797 VGND VGND VPWR VPWR sky130_fd_sc_hd__fill_1
XTAP_TAPCELL_ROW_75_1534 VGND VPWR sky130_fd_sc_hd__tapvpwrvgnd_1
X_12173_ _05902_ _05903_ VGND VGND VPWR VPWR _05904_ sky130_fd_sc_hd__or2_1
XFILLER_123_778 VGND VGND VPWR VPWR sky130_fd_sc_hd__decap_6
XFILLER_111_918 VGND VGND VPWR VPWR sky130_fd_sc_hd__decap_3
XFILLER_68_309 VGND VGND VPWR VPWR sky130_fd_sc_hd__decap_6
X_11124_ _04865_ _04866_ VGND VGND VPWR VPWR _04867_ sky130_fd_sc_hd__nor2_1
XFILLER_1_541 VPWR VGND VPWR VGND sky130_ef_sc_hd__decap_12
XFILLER_3_15 VPWR VGND VPWR VGND sky130_ef_sc_hd__decap_12
XFILLER_150_597 VGND VGND VPWR VPWR sky130_fd_sc_hd__decap_3
X_11055_ _03659_ _04797_ VGND VGND VPWR VPWR _04798_ sky130_fd_sc_hd__nand2_1
XFILLER_49_512 VGND VGND VPWR VPWR sky130_fd_sc_hd__decap_4
XFILLER_1_585 VPWR VGND VPWR VGND sky130_ef_sc_hd__decap_12
X_10006_ net189 VGND VGND VPWR VPWR _03758_ sky130_fd_sc_hd__inv_2
XFILLER_49_567 VGND VGND VPWR VPWR sky130_fd_sc_hd__fill_2
XFILLER_91_301 VGND VGND VPWR VPWR sky130_fd_sc_hd__decap_8
XFILLER_64_504 VPWR VGND VPWR VGND sky130_ef_sc_hd__decap_12
XTAP_TAPCELL_ROW_106_2033 VGND VPWR sky130_fd_sc_hd__tapvpwrvgnd_1
XFILLER_17_420 VPWR VGND VPWR VGND sky130_ef_sc_hd__decap_12
X_11957_ _05688_ _05689_ VGND VGND VPWR VPWR _05691_ sky130_fd_sc_hd__xor2_1
XFILLER_91_389 VGND VGND VPWR VPWR sky130_fd_sc_hd__decap_3
XFILLER_83_72 VGND VGND VPWR VPWR sky130_fd_sc_hd__decap_8
X_10908_ _04649_ _04650_ _04651_ VGND VGND VPWR VPWR _04653_ sky130_fd_sc_hd__nand3_2
XFILLER_17_475 VGND VGND VPWR VPWR sky130_fd_sc_hd__decap_8
XFILLER_32_401 VPWR VGND VPWR VGND sky130_ef_sc_hd__decap_12
XFILLER_60_754 VGND VGND VPWR VPWR sky130_fd_sc_hd__fill_2
X_11888_ _05621_ _05622_ VGND VGND VPWR VPWR _05623_ sky130_fd_sc_hd__and2b_1
X_13627_ clknet_leaf_39_clk _00637_ VGND VGND VPWR VPWR u_interface.fifo_data\[13\]\[10\]
+ sky130_fd_sc_hd__dfxtp_1
X_10839_ _04580_ _04583_ VGND VGND VPWR VPWR _04584_ sky130_fd_sc_hd__xnor2_1
X_13558_ clknet_leaf_70_clk _00568_ VGND VGND VPWR VPWR u_interface.fifo_data\[4\]\[5\]
+ sky130_fd_sc_hd__dfxtp_1
XFILLER_9_641 VPWR VGND VPWR VGND sky130_ef_sc_hd__decap_12
XPHY_EDGE_ROW_132_Right_132 VGND VGND VPWR VPWR sky130_fd_sc_hd__decap_3
XFILLER_118_517 VGND VGND VPWR VPWR sky130_fd_sc_hd__decap_3
XFILLER_9_685 VPWR VGND VPWR VGND sky130_ef_sc_hd__decap_12
X_12509_ _06232_ _06233_ VGND VGND VPWR VPWR _06234_ sky130_fd_sc_hd__nand2_1
X_13489_ clknet_leaf_23_clk _00499_ VGND VGND VPWR VPWR u_interface.u_gelu_fp32.u_synth_top.s2_b\[4\]
+ sky130_fd_sc_hd__dfxtp_1
XFILLER_66_3 VPWR VGND VPWR VGND sky130_ef_sc_hd__decap_12
XFILLER_154_881 VPWR VGND VPWR VGND sky130_ef_sc_hd__decap_12
XFILLER_113_200 VGND VGND VPWR VPWR sky130_fd_sc_hd__decap_4
X_07981_ net774 net969 _01852_ VGND VGND VPWR VPWR _00695_ sky130_fd_sc_hd__o21a_1
XFILLER_113_244 VGND VGND VPWR VPWR sky130_fd_sc_hd__decap_4
XFILLER_141_597 VGND VGND VPWR VPWR sky130_fd_sc_hd__decap_3
X_09720_ _03368_ _03474_ VGND VGND VPWR VPWR _03475_ sky130_fd_sc_hd__xor2_1
X_06932_ _01460_ _01465_ VGND VGND VPWR VPWR _01467_ sky130_fd_sc_hd__nand2_1
XFILLER_68_865 VGND VGND VPWR VPWR sky130_fd_sc_hd__decap_3
X_06863_ net322 _01408_ VGND VGND VPWR VPWR _01409_ sky130_fd_sc_hd__or2_1
X_09651_ _03404_ _03405_ _03305_ _03308_ VGND VGND VPWR VPWR _03407_ sky130_fd_sc_hd__o211a_1
XFILLER_95_673 VGND VGND VPWR VPWR sky130_fd_sc_hd__decap_6
XFILLER_83_835 VGND VGND VPWR VPWR sky130_fd_sc_hd__fill_1
XFILLER_27_217 VGND VGND VPWR VPWR sky130_fd_sc_hd__fill_1
X_09582_ _03334_ _03335_ _03336_ VGND VGND VPWR VPWR _03338_ sky130_fd_sc_hd__nand3_1
XFILLER_83_857 VGND VGND VPWR VPWR sky130_fd_sc_hd__decap_4
X_08602_ _02230_ net158 _02382_ VGND VGND VPWR VPWR _02383_ sky130_fd_sc_hd__nand3b_1
X_06794_ u_interface.fifo_data\[4\]\[20\] u_interface.fifo_data\[5\]\[20\] u_interface.fifo_data\[6\]\[20\]
+ u_interface.fifo_data\[7\]\[20\] net758 net741 VGND VGND VPWR VPWR _01349_ sky130_fd_sc_hd__mux4_1
XFILLER_83_879 VGND VGND VPWR VPWR sky130_fd_sc_hd__fill_2
X_08533_ net524 u_interface.u_gelu_fp32.u_synth_top.s3_mult\[56\] _02157_ _02315_
+ VGND VGND VPWR VPWR _02324_ sky130_fd_sc_hd__a22o_1
XFILLER_36_773 VGND VGND VPWR VPWR sky130_fd_sc_hd__fill_2
X_08464_ net526 u_interface.u_gelu_fp32.u_synth_top.s3_mult\[36\] VGND VGND VPWR VPWR
+ _02255_ sky130_fd_sc_hd__nor2_1
XFILLER_50_242 VGND VGND VPWR VPWR sky130_fd_sc_hd__decap_3
XFILLER_23_445 VGND VGND VPWR VPWR sky130_fd_sc_hd__decap_3
X_07415_ u_interface.u_gelu_fp32.u_fp32_to_q16.s2_norm_mag\[26\] u_interface.u_gelu_fp32.u_fp32_to_q16.s2_norm_mag\[27\]
+ net560 VGND VGND VPWR VPWR _01551_ sky130_fd_sc_hd__mux2_1
X_08395_ _02184_ _02185_ VGND VGND VPWR VPWR _02186_ sky130_fd_sc_hd__nand2_1
XFILLER_50_264 VPWR VGND VPWR VGND sky130_ef_sc_hd__decap_12
XFILLER_50_253 VGND VGND VPWR VPWR sky130_fd_sc_hd__fill_1
XFILLER_11_629 VPWR VGND VPWR VGND sky130_ef_sc_hd__decap_12
XFILLER_148_141 VPWR VGND VPWR VGND sky130_ef_sc_hd__decap_12
XTAP_TAPCELL_ROW_137_2527 VGND VPWR sky130_fd_sc_hd__tapvpwrvgnd_1
X_07346_ net362 net1441 net244 VGND VGND VPWR VPWR _00376_ sky130_fd_sc_hd__mux2_1
XFILLER_50_297 VGND VGND VPWR VPWR sky130_fd_sc_hd__fill_2
XFILLER_10_139 VGND VGND VPWR VPWR sky130_fd_sc_hd__fill_1
XTAP_TAPCELL_ROW_21_668 VGND VPWR sky130_fd_sc_hd__tapvpwrvgnd_1
XTAP_TAPCELL_ROW_21_679 VGND VPWR sky130_fd_sc_hd__tapvpwrvgnd_1
XTAP_TAPCELL_ROW_150_2738 VGND VPWR sky130_fd_sc_hd__tapvpwrvgnd_1
X_09016_ net613 net497 _02773_ _02771_ VGND VGND VPWR VPWR _02775_ sky130_fd_sc_hd__a31o_1
XFILLER_136_347 VGND VGND VPWR VPWR sky130_fd_sc_hd__decap_8
X_07277_ net1438 net372 net245 VGND VGND VPWR VPWR _00307_ sky130_fd_sc_hd__mux2_1
XFILLER_117_561 VPWR VGND VPWR VGND sky130_ef_sc_hd__decap_12
Xhold151 u_interface.fifo_data\[9\]\[28\] VGND VGND VPWR VPWR net1016 sky130_fd_sc_hd__dlygate4sd3_1
XFILLER_144_380 VGND VGND VPWR VPWR sky130_fd_sc_hd__decap_3
Xhold162 u_interface.fifo_data\[2\]\[19\] VGND VGND VPWR VPWR net1027 sky130_fd_sc_hd__dlygate4sd3_1
Xhold140 u_interface.fifo_data\[14\]\[1\] VGND VGND VPWR VPWR net1005 sky130_fd_sc_hd__dlygate4sd3_1
XTAP_TAPCELL_ROW_57_1253 VGND VPWR sky130_fd_sc_hd__tapvpwrvgnd_1
XTAP_TAPCELL_ROW_57_1242 VGND VPWR sky130_fd_sc_hd__tapvpwrvgnd_1
XFILLER_3_839 VGND VGND VPWR VPWR sky130_fd_sc_hd__fill_1
XFILLER_78_607 VGND VGND VPWR VPWR sky130_fd_sc_hd__fill_1
Xhold184 u_interface.fifo_data\[13\]\[12\] VGND VGND VPWR VPWR net1049 sky130_fd_sc_hd__dlygate4sd3_1
Xhold195 u_interface.fifo_data\[1\]\[31\] VGND VGND VPWR VPWR net1060 sky130_fd_sc_hd__dlygate4sd3_1
Xhold173 u_interface.fifo_data\[14\]\[31\] VGND VGND VPWR VPWR net1038 sky130_fd_sc_hd__dlygate4sd3_1
XFILLER_104_288 VGND VGND VPWR VPWR sky130_fd_sc_hd__fill_2
Xfanout631 net632 VGND VGND VPWR VPWR net631 sky130_fd_sc_hd__buf_2
Xfanout620 net624 VGND VGND VPWR VPWR net620 sky130_fd_sc_hd__clkbuf_4
X_09918_ net612 net446 net441 net608 VGND VGND VPWR VPWR _03671_ sky130_fd_sc_hd__a22o_1
XFILLER_78_629 VPWR VGND VPWR VGND sky130_ef_sc_hd__decap_12
Xfanout642 u_interface.u_gelu_fp32.u_synth_top.s2_m\[8\] VGND VGND VPWR VPWR net642
+ sky130_fd_sc_hd__buf_2
Xfanout664 net665 VGND VGND VPWR VPWR net664 sky130_fd_sc_hd__clkbuf_2
Xfanout653 u_interface.u_gelu_fp32.u_synth_top.s2_m\[9\] VGND VGND VPWR VPWR net653
+ sky130_fd_sc_hd__clkbuf_2
XTAP_TAPCELL_ROW_70_1453 VGND VPWR sky130_fd_sc_hd__tapvpwrvgnd_1
Xfanout675 net683 VGND VGND VPWR VPWR net675 sky130_fd_sc_hd__buf_2
Xfanout697 net698 VGND VGND VPWR VPWR net697 sky130_fd_sc_hd__clkbuf_2
X_09849_ _03601_ _03602_ _03595_ VGND VGND VPWR VPWR _03603_ sky130_fd_sc_hd__a21o_1
Xfanout686 net687 VGND VGND VPWR VPWR net686 sky130_fd_sc_hd__buf_2
XFILLER_46_515 VGND VGND VPWR VPWR sky130_fd_sc_hd__decap_8
XFILLER_19_729 VPWR VGND VPWR VGND sky130_ef_sc_hd__decap_12
X_12860_ net1594 u_interface.u_gelu_fp32.u_fp32_to_q16.s2_norm_mag\[15\] net819 VGND
+ VGND VPWR VPWR _01004_ sky130_fd_sc_hd__mux2_1
XFILLER_18_228 VGND VGND VPWR VPWR sky130_fd_sc_hd__fill_2
XFILLER_73_378 VGND VGND VPWR VPWR sky130_fd_sc_hd__decap_6
X_11811_ _05544_ _05545_ VGND VGND VPWR VPWR _05547_ sky130_fd_sc_hd__xor2_1
X_12791_ u_interface.u_gelu_fp32.u_q16_to_fp32.s3_norm_mag\[23\] u_interface.u_gelu_fp32.u_q16_to_fp32.s3_norm_mag\[22\]
+ _01784_ u_interface.u_gelu_fp32.u_q16_to_fp32.s3_norm_mag\[24\] VGND VGND VPWR VPWR
+ _06412_ sky130_fd_sc_hd__a31o_1
XFILLER_61_529 VGND VGND VPWR VPWR sky130_fd_sc_hd__decap_4
X_11742_ _05476_ _05477_ VGND VGND VPWR VPWR _05479_ sky130_fd_sc_hd__nand2_1
XFILLER_14_445 VPWR VGND VPWR VGND sky130_ef_sc_hd__decap_12
XFILLER_30_905 VPWR VGND VPWR VGND sky130_ef_sc_hd__decap_12
X_11673_ _05342_ _05344_ net201 VGND VGND VPWR VPWR _05410_ sky130_fd_sc_hd__a21o_1
XFILLER_42_787 VGND VGND VPWR VPWR sky130_fd_sc_hd__fill_1
X_13412_ clknet_leaf_49_clk _00422_ VGND VGND VPWR VPWR u_interface.fifo_data\[6\]\[25\]
+ sky130_fd_sc_hd__dfxtp_1
X_10624_ _04369_ _04370_ _04342_ VGND VGND VPWR VPWR _04371_ sky130_fd_sc_hd__a21oi_1
XFILLER_41_286 VPWR VGND VPWR VGND sky130_ef_sc_hd__decap_12
XFILLER_155_623 VGND VGND VPWR VPWR sky130_fd_sc_hd__decap_3
XFILLER_155_601 VGND VGND VPWR VPWR sky130_fd_sc_hd__decap_4
XFILLER_127_303 VPWR VGND VPWR VGND sky130_ef_sc_hd__decap_12
X_13343_ clknet_leaf_68_clk _00353_ VGND VGND VPWR VPWR u_interface.fifo_data\[10\]\[20\]
+ sky130_fd_sc_hd__dfxtp_1
XTAP_TAPCELL_ROW_40_977 VGND VPWR sky130_fd_sc_hd__tapvpwrvgnd_1
XFILLER_155_645 VGND VGND VPWR VPWR sky130_fd_sc_hd__fill_2
X_10555_ _04221_ _04222_ _04301_ _04302_ VGND VGND VPWR VPWR _04303_ sky130_fd_sc_hd__a22o_1
XFILLER_155_678 VGND VGND VPWR VPWR sky130_fd_sc_hd__decap_4
XFILLER_154_155 VGND VGND VPWR VPWR sky130_fd_sc_hd__fill_1
X_13274_ clknet_leaf_32_clk _00284_ VGND VGND VPWR VPWR u_interface.fifo_data\[0\]\[16\]
+ sky130_fd_sc_hd__dfxtp_1
X_10486_ _04231_ _04232_ _04233_ VGND VGND VPWR VPWR _04234_ sky130_fd_sc_hd__a21oi_1
XFILLER_142_339 VPWR VGND VPWR VGND sky130_ef_sc_hd__decap_12
XFILLER_6_699 VGND VGND VPWR VPWR sky130_fd_sc_hd__fill_1
X_12225_ _05815_ _05954_ VGND VGND VPWR VPWR _05955_ sky130_fd_sc_hd__xnor2_1
XFILLER_2_861 VGND VGND VPWR VPWR sky130_fd_sc_hd__decap_6
X_12156_ _05815_ _05885_ VGND VGND VPWR VPWR _05887_ sky130_fd_sc_hd__nand2_1
XFILLER_123_586 VPWR VGND VPWR VGND sky130_ef_sc_hd__decap_12
X_11107_ _04848_ _04849_ VGND VGND VPWR VPWR _04850_ sky130_fd_sc_hd__and2b_1
XTAP_TAPCELL_ROW_9_482 VGND VPWR sky130_fd_sc_hd__tapvpwrvgnd_1
XFILLER_1_393 VPWR VGND VPWR VGND sky130_ef_sc_hd__decap_12
X_12087_ _05743_ _05744_ _05816_ VGND VGND VPWR VPWR _05819_ sky130_fd_sc_hd__and3_1
XFILLER_76_161 VGND VGND VPWR VPWR sky130_fd_sc_hd__fill_1
X_11038_ _04779_ _04780_ VGND VGND VPWR VPWR _04782_ sky130_fd_sc_hd__xnor2_1
XFILLER_92_632 VPWR VGND VPWR VGND sky130_ef_sc_hd__decap_12
XTAP_TAPCELL_ROW_88_1747 VGND VPWR sky130_fd_sc_hd__tapvpwrvgnd_1
XTAP_TAPCELL_ROW_88_1736 VGND VPWR sky130_fd_sc_hd__tapvpwrvgnd_1
XFILLER_76_172 VGND VGND VPWR VPWR sky130_fd_sc_hd__fill_1
XFILLER_37_548 VPWR VGND VPWR VGND sky130_ef_sc_hd__decap_12
XFILLER_91_175 VGND VGND VPWR VPWR sky130_fd_sc_hd__fill_1
XFILLER_64_389 VPWR VGND VPWR VGND sky130_ef_sc_hd__decap_12
X_12989_ net1192 net373 net221 VGND VGND VPWR VPWR _01072_ sky130_fd_sc_hd__mux2_1
XFILLER_33_721 VGND VGND VPWR VPWR sky130_fd_sc_hd__decap_6
XTAP_TAPCELL_ROW_28_790 VGND VPWR sky130_fd_sc_hd__tapvpwrvgnd_1
XFILLER_33_765 VPWR VGND VPWR VGND sky130_ef_sc_hd__decap_12
XFILLER_20_404 VPWR VGND VPWR VGND sky130_ef_sc_hd__decap_12
XFILLER_32_253 VGND VGND VPWR VPWR sky130_fd_sc_hd__decap_6
XTAP_TAPCELL_ROW_119_2235 VGND VPWR sky130_fd_sc_hd__tapvpwrvgnd_1
X_08180_ _02014_ _02015_ VGND VGND VPWR VPWR _02016_ sky130_fd_sc_hd__xor2_1
X_07200_ net368 net1596 net257 VGND VGND VPWR VPWR _00240_ sky130_fd_sc_hd__mux2_1
XTAP_TAPCELL_ROW_119_2246 VGND VPWR sky130_fd_sc_hd__tapvpwrvgnd_1
X_07131_ net1001 net378 net217 VGND VGND VPWR VPWR _00171_ sky130_fd_sc_hd__mux2_1
XFILLER_9_460 VPWR VGND VPWR VGND sky130_ef_sc_hd__decap_12
XFILLER_146_634 VGND VGND VPWR VPWR sky130_fd_sc_hd__fill_1
XFILLER_146_645 VGND VGND VPWR VPWR sky130_fd_sc_hd__fill_1
XFILLER_134_829 VGND VGND VPWR VPWR sky130_fd_sc_hd__decap_8
XTAP_TAPCELL_ROW_132_2446 VGND VPWR sky130_fd_sc_hd__tapvpwrvgnd_1
X_07062_ net1224 net359 net209 VGND VGND VPWR VPWR _00102_ sky130_fd_sc_hd__mux2_1
XFILLER_114_553 VGND VGND VPWR VPWR sky130_fd_sc_hd__decap_3
XFILLER_114_586 VGND VGND VPWR VPWR sky130_fd_sc_hd__fill_2
X_07964_ net815 net1767 net300 _01676_ VGND VGND VPWR VPWR _01844_ sky130_fd_sc_hd__a22o_1
XFILLER_102_748 VGND VGND VPWR VPWR sky130_fd_sc_hd__decap_8
XFILLER_101_247 VGND VGND VPWR VPWR sky130_fd_sc_hd__fill_2
XFILLER_114_26 VGND VGND VPWR VPWR sky130_fd_sc_hd__fill_2
X_07895_ net1190 net566 net268 VGND VGND VPWR VPWR _00656_ sky130_fd_sc_hd__mux2_1
X_09703_ _03351_ _03353_ _03456_ VGND VGND VPWR VPWR _03458_ sky130_fd_sc_hd__o21a_1
X_06915_ u_interface.u_gelu_fp32.u_synth_top.s1_x\[18\] u_interface.u_gelu_fp32.u_synth_top.s1_x\[19\]
+ net274 VGND VGND VPWR VPWR _01453_ sky130_fd_sc_hd__o21ai_1
XFILLER_68_651 VGND VGND VPWR VPWR sky130_fd_sc_hd__decap_6
XFILLER_56_802 VGND VGND VPWR VPWR sky130_fd_sc_hd__decap_8
XTAP_TAPCELL_ROW_52_1172 VGND VPWR sky130_fd_sc_hd__tapvpwrvgnd_1
XTAP_TAPCELL_ROW_52_1161 VGND VPWR sky130_fd_sc_hd__tapvpwrvgnd_1
X_09634_ _03388_ _03389_ _03382_ VGND VGND VPWR VPWR _03390_ sky130_fd_sc_hd__a21o_1
X_06846_ net731 _01393_ VGND VGND VPWR VPWR _01394_ sky130_fd_sc_hd__or2_1
XFILLER_82_153 VPWR VGND VPWR VGND sky130_ef_sc_hd__decap_12
X_09565_ _03133_ _03222_ _03321_ VGND VGND VPWR VPWR _03322_ sky130_fd_sc_hd__o21a_1
X_06777_ u_interface.fifo_data\[0\]\[18\] u_interface.fifo_data\[1\]\[18\] u_interface.fifo_data\[2\]\[18\]
+ u_interface.fifo_data\[3\]\[18\] net765 net748 VGND VGND VPWR VPWR _01334_ sky130_fd_sc_hd__mux4_1
XFILLER_70_304 VGND VGND VPWR VPWR sky130_fd_sc_hd__decap_4
X_09496_ _03251_ _03252_ _03245_ VGND VGND VPWR VPWR _03253_ sky130_fd_sc_hd__a21o_1
XFILLER_12_905 VPWR VGND VPWR VGND sky130_ef_sc_hd__decap_12
X_08516_ _02299_ _02302_ _02303_ _02306_ VGND VGND VPWR VPWR _02307_ sky130_fd_sc_hd__or4_1
XTAP_TAPCELL_ROW_26_749 VGND VPWR sky130_fd_sc_hd__tapvpwrvgnd_1
X_08447_ u_interface.u_gelu_fp32.u_synth_top.s3_mult\[30\] u_interface.u_gelu_fp32.u_synth_top.s3_b\[14\]
+ _02178_ _02177_ VGND VGND VPWR VPWR _02238_ sky130_fd_sc_hd__a31oi_2
XFILLER_139_12 VPWR VGND VPWR VGND sky130_ef_sc_hd__decap_12
XFILLER_149_472 VPWR VGND VPWR VGND sky130_ef_sc_hd__decap_12
XFILLER_149_461 VGND VGND VPWR VPWR sky130_fd_sc_hd__decap_3
XFILLER_7_419 VGND VGND VPWR VPWR sky130_fd_sc_hd__decap_8
X_08378_ _02165_ _02168_ VGND VGND VPWR VPWR _02169_ sky130_fd_sc_hd__or2_1
XFILLER_139_89 VGND VGND VPWR VPWR sky130_fd_sc_hd__fill_1
X_07329_ net1296 net572 net256 VGND VGND VPWR VPWR _00359_ sky130_fd_sc_hd__mux2_1
XFILLER_137_689 VGND VGND VPWR VPWR sky130_fd_sc_hd__fill_2
X_10340_ _03999_ _04002_ _04001_ VGND VGND VPWR VPWR _04089_ sky130_fd_sc_hd__a21o_1
XFILLER_117_380 VPWR VGND VPWR VGND sky130_ef_sc_hd__decap_12
X_10271_ net460 net673 _04018_ _04019_ VGND VGND VPWR VPWR _04021_ sky130_fd_sc_hd__nand4_1
XFILLER_155_55 VGND VGND VPWR VPWR sky130_fd_sc_hd__fill_1
XFILLER_105_553 VGND VGND VPWR VPWR sky130_fd_sc_hd__decap_6
X_12010_ net717 _05670_ _05742_ _05592_ VGND VGND VPWR VPWR _05743_ sky130_fd_sc_hd__a31o_1
XFILLER_105_564 VPWR VGND VPWR VGND sky130_ef_sc_hd__decap_12
XFILLER_132_383 VPWR VGND VPWR VGND sky130_ef_sc_hd__decap_12
Xfanout450 net451 VGND VGND VPWR VPWR net450 sky130_fd_sc_hd__clkbuf_4
XTAP_TAPCELL_ROW_6_430 VGND VPWR sky130_fd_sc_hd__tapvpwrvgnd_1
XFILLER_120_589 VPWR VGND VPWR VGND sky130_ef_sc_hd__decap_12
Xfanout483 u_interface.u_gelu_fp32.u_synth_top.s2_dx\[8\] VGND VGND VPWR VPWR net483
+ sky130_fd_sc_hd__clkbuf_2
Xfanout472 net473 VGND VGND VPWR VPWR net472 sky130_fd_sc_hd__clkbuf_2
XFILLER_93_429 VGND VGND VPWR VPWR sky130_fd_sc_hd__decap_8
Xfanout461 u_interface.u_gelu_fp32.u_synth_top.s2_dx\[14\] VGND VGND VPWR VPWR net461
+ sky130_fd_sc_hd__clkbuf_2
X_13961_ clknet_leaf_59_clk net1657 VGND VGND VPWR VPWR u_interface.u_gelu_fp32.u_q16_to_fp32.s2_mag\[6\]
+ sky130_fd_sc_hd__dfxtp_1
XFILLER_48_64 VGND VGND VPWR VPWR sky130_fd_sc_hd__fill_1
X_12912_ _01100_ _01535_ VGND VGND VPWR VPWR _06440_ sky130_fd_sc_hd__nand2_1
Xfanout494 net495 VGND VGND VPWR VPWR net494 sky130_fd_sc_hd__buf_2
XFILLER_74_632 VGND VGND VPWR VPWR sky130_fd_sc_hd__fill_1
XFILLER_48_97 VGND VGND VPWR VPWR sky130_fd_sc_hd__decap_8
X_13892_ clknet_leaf_90_clk _00028_ VGND VGND VPWR VPWR u_interface.u_gelu_fp32.u_synth_top.s2_dx\[28\]
+ sky130_fd_sc_hd__dfxtp_1
XFILLER_0_27 VGND VGND VPWR VPWR sky130_fd_sc_hd__fill_1
X_12843_ net38 net37 net40 net39 VGND VGND VPWR VPWR _06425_ sky130_fd_sc_hd__or4_1
XFILLER_64_52 VGND VGND VPWR VPWR sky130_fd_sc_hd__decap_6
XFILLER_15_721 VGND VGND VPWR VPWR sky130_fd_sc_hd__decap_6
X_12774_ _01780_ net296 _06403_ VGND VGND VPWR VPWR _00947_ sky130_fd_sc_hd__and3b_1
XFILLER_61_337 VPWR VGND VPWR VGND sky130_ef_sc_hd__decap_12
XTAP_TAPCELL_ROW_83_1666 VGND VPWR sky130_fd_sc_hd__tapvpwrvgnd_1
XFILLER_15_765 VPWR VGND VPWR VGND sky130_ef_sc_hd__decap_12
XFILLER_30_713 VPWR VGND VPWR VGND sky130_ef_sc_hd__decap_12
X_11725_ _05460_ _05461_ VGND VGND VPWR VPWR _05462_ sky130_fd_sc_hd__nor2_1
XFILLER_42_562 VGND VGND VPWR VPWR sky130_fd_sc_hd__fill_1
XFILLER_147_409 VGND VGND VPWR VPWR sky130_fd_sc_hd__fill_1
XFILLER_9_69 VPWR VGND VPWR VGND sky130_ef_sc_hd__decap_12
XFILLER_30_757 VPWR VGND VPWR VGND sky130_ef_sc_hd__decap_12
XFILLER_128_601 VGND VGND VPWR VPWR sky130_fd_sc_hd__decap_4
X_11656_ _05392_ _05393_ VGND VGND VPWR VPWR _05394_ sky130_fd_sc_hd__nor2_1
XFILLER_128_645 VGND VGND VPWR VPWR sky130_fd_sc_hd__decap_4
XFILLER_127_111 VGND VGND VPWR VPWR sky130_fd_sc_hd__fill_1
X_10607_ net452 net456 net678 net687 VGND VGND VPWR VPWR _04354_ sky130_fd_sc_hd__nand4_1
X_11587_ net205 _05324_ VGND VGND VPWR VPWR _05325_ sky130_fd_sc_hd__xnor2_1
XFILLER_155_475 VGND VGND VPWR VPWR sky130_fd_sc_hd__fill_1
Xhold909 u_interface.u_gelu_fp32.u_fp32_to_q16.s3_mag\[18\] VGND VGND VPWR VPWR net1774
+ sky130_fd_sc_hd__dlygate4sd3_1
X_10538_ _04282_ _04285_ VGND VGND VPWR VPWR _04286_ sky130_fd_sc_hd__xnor2_1
X_13326_ clknet_leaf_73_clk _00336_ VGND VGND VPWR VPWR u_interface.fifo_data\[10\]\[3\]
+ sky130_fd_sc_hd__dfxtp_1
XFILLER_10_481 VPWR VGND VPWR VGND sky130_ef_sc_hd__decap_12
X_13257_ clknet_leaf_31_clk _00267_ VGND VGND VPWR VPWR _00003_ sky130_fd_sc_hd__dfxtp_2
XFILLER_127_177 VGND VGND VPWR VPWR sky130_fd_sc_hd__fill_1
XFILLER_115_328 VGND VGND VPWR VPWR sky130_fd_sc_hd__decap_3
XTAP_TAPCELL_ROW_114_2165 VGND VPWR sky130_fd_sc_hd__tapvpwrvgnd_1
XTAP_TAPCELL_ROW_114_2154 VGND VPWR sky130_fd_sc_hd__tapvpwrvgnd_1
X_10469_ _04215_ _04216_ net189 VGND VGND VPWR VPWR _04217_ sky130_fd_sc_hd__a21o_1
X_12208_ net183 _05870_ _05869_ VGND VGND VPWR VPWR _05938_ sky130_fd_sc_hd__a21o_1
X_13188_ clknet_leaf_68_clk _00198_ VGND VGND VPWR VPWR u_interface.fifo_data\[9\]\[30\]
+ sky130_fd_sc_hd__dfxtp_1
X_12139_ _05868_ _05869_ VGND VGND VPWR VPWR _05870_ sky130_fd_sc_hd__nor2_1
XFILLER_111_589 VPWR VGND VPWR VGND sky130_ef_sc_hd__decap_12
XFILLER_97_779 VGND VGND VPWR VPWR sky130_fd_sc_hd__decap_4
XFILLER_96_267 VGND VGND VPWR VPWR sky130_fd_sc_hd__decap_4
XFILLER_29_3 VPWR VGND VPWR VGND sky130_ef_sc_hd__decap_12
XFILLER_65_610 VGND VGND VPWR VPWR sky130_fd_sc_hd__decap_6
X_06700_ _01262_ _01263_ _01266_ net316 VGND VGND VPWR VPWR net139 sky130_fd_sc_hd__a22o_1
XFILLER_37_323 VPWR VGND VPWR VGND sky130_ef_sc_hd__decap_12
X_07680_ u_interface.u_gelu_fp32.u_synth_top.s1_hits\[1\] _01753_ _01754_ _01755_
+ VGND VGND VPWR VPWR _00490_ sky130_fd_sc_hd__or4_1
XFILLER_49_194 VGND VGND VPWR VPWR sky130_fd_sc_hd__fill_1
XFILLER_92_473 VGND VGND VPWR VPWR sky130_fd_sc_hd__decap_3
X_06631_ u_interface.fifo_data\[12\]\[0\] u_interface.fifo_data\[13\]\[0\] u_interface.fifo_data\[14\]\[0\]
+ u_interface.fifo_data\[15\]\[0\] net756 net739 VGND VGND VPWR VPWR _01206_ sky130_fd_sc_hd__mux4_1
X_09350_ _03073_ _03091_ _03108_ _03088_ VGND VGND VPWR VPWR _03109_ sky130_fd_sc_hd__a2bb2o_1
X_06562_ _01155_ VGND VGND VPWR VPWR _01156_ sky130_fd_sc_hd__inv_2
XFILLER_64_197 VGND VGND VPWR VPWR sky130_fd_sc_hd__decap_8
X_09281_ _02993_ _03037_ _03036_ VGND VGND VPWR VPWR _03040_ sky130_fd_sc_hd__a21o_1
X_08301_ net531 net1588 _02107_ net799 VGND VGND VPWR VPWR _02109_ sky130_fd_sc_hd__a31o_1
XTAP_TAPCELL_ROW_23_708 VGND VPWR sky130_fd_sc_hd__tapvpwrvgnd_1
XFILLER_33_573 VPWR VGND VPWR VGND sky130_ef_sc_hd__decap_12
X_08232_ net539 _02059_ _02047_ VGND VGND VPWR VPWR _02060_ sky130_fd_sc_hd__a21o_1
X_08163_ net289 _02001_ VGND VGND VPWR VPWR _00728_ sky130_fd_sc_hd__nor2_1
X_07114_ net998 net325 net267 VGND VGND VPWR VPWR _00154_ sky130_fd_sc_hd__mux2_1
XFILLER_146_475 VGND VGND VPWR VPWR sky130_fd_sc_hd__fill_1
X_08094_ net313 _01942_ _01943_ VGND VGND VPWR VPWR _01944_ sky130_fd_sc_hd__or3_1
XFILLER_107_818 VGND VGND VPWR VPWR sky130_fd_sc_hd__decap_6
X_07045_ net1386 net568 net271 VGND VGND VPWR VPWR _00085_ sky130_fd_sc_hd__mux2_1
XFILLER_106_317 VGND VGND VPWR VPWR sky130_fd_sc_hd__decap_3
Xclkload71 clknet_leaf_51_clk VGND VGND VPWR VPWR clkload71/Y sky130_fd_sc_hd__inv_6
Xclkload60 clknet_leaf_71_clk VGND VGND VPWR VPWR clkload60/X sky130_fd_sc_hd__clkbuf_4
Xclkload82 clknet_leaf_47_clk VGND VGND VPWR VPWR clkload82/Y sky130_fd_sc_hd__inv_8
XTAP_TAPCELL_ROW_54_1201 VGND VPWR sky130_fd_sc_hd__tapvpwrvgnd_1
XFILLER_133_169 VGND VGND VPWR VPWR sky130_fd_sc_hd__decap_3
XFILLER_121_309 VPWR VGND VPWR VGND sky130_ef_sc_hd__decap_12
XFILLER_115_895 VGND VGND VPWR VPWR sky130_fd_sc_hd__fill_1
XFILLER_102_512 VPWR VGND VPWR VGND sky130_ef_sc_hd__decap_12
XFILLER_0_617 VPWR VGND VPWR VGND sky130_ef_sc_hd__decap_12
X_08996_ _02598_ _02711_ _02735_ _02752_ VGND VGND VPWR VPWR _02755_ sky130_fd_sc_hd__a211o_1
XFILLER_87_223 VGND VGND VPWR VPWR sky130_fd_sc_hd__fill_1
X_07947_ u_interface.u_gelu_fp32.u_fp32_to_q16.s1_exp\[4\] _01811_ u_interface.u_gelu_fp32.u_fp32_to_q16.s1_exp\[5\]
+ VGND VGND VPWR VPWR _01836_ sky130_fd_sc_hd__o21a_1
XFILLER_102_589 VGND VGND VPWR VPWR sky130_fd_sc_hd__fill_1
XTAP_TAPCELL_ROW_145_2659 VGND VPWR sky130_fd_sc_hd__tapvpwrvgnd_1
XTAP_TAPCELL_ROW_145_2648 VGND VPWR sky130_fd_sc_hd__tapvpwrvgnd_1
XFILLER_28_301 VGND VGND VPWR VPWR sky130_fd_sc_hd__decap_6
X_07878_ net1049 net360 net266 VGND VGND VPWR VPWR _00639_ sky130_fd_sc_hd__mux2_1
XFILLER_16_507 VPWR VGND VPWR VGND sky130_ef_sc_hd__decap_12
X_09617_ _03371_ _03372_ _03367_ VGND VGND VPWR VPWR _03373_ sky130_fd_sc_hd__o21ai_1
X_06829_ u_interface.fifo_data\[12\]\[25\] u_interface.fifo_data\[13\]\[25\] u_interface.fifo_data\[14\]\[25\]
+ u_interface.fifo_data\[15\]\[25\] net765 net748 VGND VGND VPWR VPWR _01379_ sky130_fd_sc_hd__mux4_1
XFILLER_71_602 VPWR VGND VPWR VGND sky130_ef_sc_hd__decap_12
XFILLER_55_175 VGND VGND VPWR VPWR sky130_fd_sc_hd__fill_1
X_09548_ _03166_ _03304_ VGND VGND VPWR VPWR _03305_ sky130_fd_sc_hd__or2_1
XFILLER_83_495 VGND VGND VPWR VPWR sky130_fd_sc_hd__decap_8
XFILLER_71_657 VPWR VGND VPWR VGND sky130_ef_sc_hd__decap_12
XFILLER_43_337 VPWR VGND VPWR VGND sky130_ef_sc_hd__decap_12
XTAP_TAPCELL_ROW_65_1374 VGND VPWR sky130_fd_sc_hd__tapvpwrvgnd_1
XFILLER_12_713 VPWR VGND VPWR VGND sky130_ef_sc_hd__decap_12
X_09479_ _03175_ _03178_ VGND VGND VPWR VPWR _03236_ sky130_fd_sc_hd__or2_1
XFILLER_51_381 VGND VGND VPWR VPWR sky130_fd_sc_hd__decap_8
XFILLER_11_212 VGND VGND VPWR VPWR sky130_fd_sc_hd__fill_1
X_11510_ _05247_ _05248_ VGND VGND VPWR VPWR _05249_ sky130_fd_sc_hd__nand2_1
XFILLER_133_3 VGND VGND VPWR VPWR sky130_fd_sc_hd__decap_3
XFILLER_7_205 VPWR VGND VPWR VGND sky130_ef_sc_hd__decap_12
XFILLER_12_757 VPWR VGND VPWR VGND sky130_ef_sc_hd__decap_12
X_12490_ _06164_ _06167_ _06213_ VGND VGND VPWR VPWR _06216_ sky130_fd_sc_hd__a21oi_1
XFILLER_11_278 VGND VGND VPWR VPWR sky130_fd_sc_hd__fill_2
X_11441_ _05178_ _05179_ VGND VGND VPWR VPWR _05181_ sky130_fd_sc_hd__xnor2_1
X_14160_ clknet_leaf_69_clk _01086_ VGND VGND VPWR VPWR u_interface.fifo_data\[1\]\[20\]
+ sky130_fd_sc_hd__dfxtp_1
X_11372_ _05110_ _05111_ VGND VGND VPWR VPWR _05113_ sky130_fd_sc_hd__xor2_1
XFILLER_7_249 VGND VGND VPWR VPWR sky130_fd_sc_hd__decap_8
XFILLER_137_475 VPWR VGND VPWR VGND sky130_ef_sc_hd__decap_12
XFILLER_109_177 VGND VGND VPWR VPWR sky130_fd_sc_hd__decap_4
X_10323_ _04071_ _04072_ _03956_ _03958_ VGND VGND VPWR VPWR _04073_ sky130_fd_sc_hd__a211oi_1
X_13111_ clknet_leaf_62_clk _00121_ VGND VGND VPWR VPWR u_interface.fifo_data\[2\]\[0\]
+ sky130_fd_sc_hd__dfxtp_1
X_14091_ clknet_leaf_20_clk net1599 VGND VGND VPWR VPWR u_interface.u_gelu_fp32.u_fp32_to_q16.s2_norm_mag\[28\]
+ sky130_fd_sc_hd__dfxtp_1
XFILLER_152_489 VPWR VGND VPWR VGND sky130_ef_sc_hd__decap_12
X_13042_ clknet_leaf_35_clk _00052_ VGND VGND VPWR VPWR u_interface.fifo_tuser\[3\]
+ sky130_fd_sc_hd__dfxtp_1
X_10254_ _04000_ _04003_ VGND VGND VPWR VPWR _04004_ sky130_fd_sc_hd__xnor2_1
X_10185_ _03791_ _03793_ _03792_ VGND VGND VPWR VPWR _03936_ sky130_fd_sc_hd__o21ba_1
XFILLER_79_757 VPWR VGND VPWR VGND sky130_ef_sc_hd__decap_12
XFILLER_121_887 VGND VGND VPWR VPWR sky130_fd_sc_hd__fill_1
Xfanout291 net293 VGND VGND VPWR VPWR net291 sky130_fd_sc_hd__buf_2
XFILLER_120_397 VPWR VGND VPWR VGND sky130_ef_sc_hd__decap_12
Xfanout280 _01748_ VGND VGND VPWR VPWR net280 sky130_fd_sc_hd__buf_2
XFILLER_47_632 VGND VGND VPWR VPWR sky130_fd_sc_hd__fill_1
X_13944_ clknet_leaf_5_clk _00011_ VGND VGND VPWR VPWR u_interface.u_gelu_fp32.u_synth_top.s1_hits\[16\]
+ sky130_fd_sc_hd__dfxtp_1
XFILLER_74_440 VPWR VGND VPWR VGND sky130_ef_sc_hd__decap_12
XFILLER_46_120 VGND VGND VPWR VPWR sky130_fd_sc_hd__decap_8
XFILLER_19_334 VGND VGND VPWR VPWR sky130_fd_sc_hd__fill_2
X_13875_ clknet_leaf_2_clk net874 VGND VGND VPWR VPWR u_interface.u_gelu_fp32.u_synth_top.s2_dx\[11\]
+ sky130_fd_sc_hd__dfxtp_1
XFILLER_46_153 VGND VGND VPWR VPWR sky130_fd_sc_hd__fill_1
X_12826_ net779 net86 VGND VGND VPWR VPWR _00984_ sky130_fd_sc_hd__and2_1
XFILLER_46_197 VPWR VGND VPWR VGND sky130_ef_sc_hd__decap_12
XFILLER_46_186 VGND VGND VPWR VPWR sky130_fd_sc_hd__decap_8
XFILLER_34_337 VGND VGND VPWR VPWR sky130_fd_sc_hd__decap_4
XFILLER_34_348 VGND VGND VPWR VPWR sky130_fd_sc_hd__decap_4
XFILLER_50_819 VGND VGND VPWR VPWR sky130_fd_sc_hd__fill_1
X_12757_ net791 net912 VGND VGND VPWR VPWR _00939_ sky130_fd_sc_hd__and2_1
XFILLER_15_573 VPWR VGND VPWR VGND sky130_ef_sc_hd__decap_12
X_12688_ _01730_ net280 _06347_ net281 _06348_ VGND VGND VPWR VPWR _00916_ sky130_fd_sc_hd__a221o_1
X_11708_ net633 net387 VGND VGND VPWR VPWR _05445_ sky130_fd_sc_hd__and2b_1
XFILLER_42_392 VGND VGND VPWR VPWR sky130_fd_sc_hd__decap_6
X_11639_ _05263_ _05264_ _05282_ _05281_ _05280_ VGND VGND VPWR VPWR _05377_ sky130_fd_sc_hd__o32a_1
XFILLER_155_272 VGND VGND VPWR VPWR sky130_fd_sc_hd__decap_4
XFILLER_128_486 VGND VGND VPWR VPWR sky130_fd_sc_hd__decap_4
Xhold728 u_interface.fifo_data\[7\]\[17\] VGND VGND VPWR VPWR net1593 sky130_fd_sc_hd__dlygate4sd3_1
Xhold706 u_interface.u_gelu_fp32.u_q16_to_fp32.s3_exp\[5\] VGND VGND VPWR VPWR net1571
+ sky130_fd_sc_hd__dlygate4sd3_1
XTAP_TAPCELL_ROW_96_1879 VGND VPWR sky130_fd_sc_hd__tapvpwrvgnd_1
XTAP_TAPCELL_ROW_96_1868 VGND VPWR sky130_fd_sc_hd__tapvpwrvgnd_1
X_13309_ clknet_leaf_50_clk _00319_ VGND VGND VPWR VPWR u_interface.fifo_data\[8\]\[18\]
+ sky130_fd_sc_hd__dfxtp_1
Xhold717 u_interface.u_gelu_fp32.s2_data\[16\] VGND VGND VPWR VPWR net1582 sky130_fd_sc_hd__dlygate4sd3_1
XFILLER_7_783 VGND VGND VPWR VPWR sky130_fd_sc_hd__fill_1
Xhold739 u_interface.u_gelu_fp32.s2_data\[30\] VGND VGND VPWR VPWR net1604 sky130_fd_sc_hd__dlygate4sd3_1
XFILLER_124_670 VGND VGND VPWR VPWR sky130_fd_sc_hd__fill_2
XFILLER_112_810 VGND VGND VPWR VPWR sky130_fd_sc_hd__fill_2
X_08850_ net599 net467 net605 net470 VGND VGND VPWR VPWR _02609_ sky130_fd_sc_hd__nand4_1
XFILLER_112_843 VGND VGND VPWR VPWR sky130_fd_sc_hd__decap_4
XFILLER_85_716 VGND VGND VPWR VPWR sky130_fd_sc_hd__fill_1
XFILLER_58_919 VGND VGND VPWR VPWR sky130_fd_sc_hd__fill_2
X_07801_ net1022 net562 net233 VGND VGND VPWR VPWR _00562_ sky130_fd_sc_hd__mux2_1
XFILLER_29_109 VGND VGND VPWR VPWR sky130_fd_sc_hd__decap_3
X_08781_ net663 net498 _02537_ _02538_ VGND VGND VPWR VPWR _02540_ sky130_fd_sc_hd__nand4_1
XTAP_TAPCELL_ROW_127_2367 VGND VPWR sky130_fd_sc_hd__tapvpwrvgnd_1
X_07732_ u_interface.u_gelu_fp32.u_q16_to_fp32.s3_norm_mag\[10\] _01775_ VGND VGND
+ VPWR VPWR _01776_ sky130_fd_sc_hd__and2_1
XFILLER_26_805 VGND VGND VPWR VPWR sky130_fd_sc_hd__decap_6
XFILLER_38_643 VGND VGND VPWR VPWR sky130_fd_sc_hd__fill_1
XFILLER_38_665 VGND VGND VPWR VPWR sky130_fd_sc_hd__fill_1
XFILLER_92_270 VGND VGND VPWR VPWR sky130_fd_sc_hd__decap_6
XFILLER_80_410 VGND VGND VPWR VPWR sky130_fd_sc_hd__decap_8
X_07663_ u_interface.u_gelu_fp32.u_q16_to_fp32.s2_mag\[14\] u_interface.u_gelu_fp32.u_q16_to_fp32.s2_mag\[13\]
+ net337 VGND VGND VPWR VPWR _01745_ sky130_fd_sc_hd__mux2_1
XFILLER_65_473 VPWR VGND VPWR VGND sky130_ef_sc_hd__decap_12
XFILLER_1_81 VPWR VGND VPWR VGND sky130_ef_sc_hd__decap_12
X_06614_ net736 _01190_ VGND VGND VPWR VPWR _01191_ sky130_fd_sc_hd__or2_1
X_09402_ _02635_ _03158_ VGND VGND VPWR VPWR _03160_ sky130_fd_sc_hd__xnor2_1
XFILLER_80_421 VGND VGND VPWR VPWR sky130_fd_sc_hd__decap_8
XFILLER_52_112 VPWR VGND VPWR VGND sky130_ef_sc_hd__decap_12
XFILLER_25_337 VGND VGND VPWR VPWR sky130_fd_sc_hd__fill_1
XFILLER_26_849 VPWR VGND VPWR VGND sky130_ef_sc_hd__decap_12
X_09333_ _03073_ _03091_ VGND VGND VPWR VPWR _03092_ sky130_fd_sc_hd__nand2_1
XTAP_TAPCELL_ROW_140_2578 VGND VPWR sky130_fd_sc_hd__tapvpwrvgnd_1
X_07594_ net810 net1696 net302 _01692_ VGND VGND VPWR VPWR _00467_ sky130_fd_sc_hd__a22o_1
XFILLER_25_359 VGND VGND VPWR VPWR sky130_fd_sc_hd__fill_2
XFILLER_40_307 VGND VGND VPWR VPWR sky130_fd_sc_hd__fill_1
X_06545_ _01141_ VGND VGND VPWR VPWR _00012_ sky130_fd_sc_hd__inv_2
XTAP_TAPCELL_ROW_47_1093 VGND VPWR sky130_fd_sc_hd__tapvpwrvgnd_1
XTAP_TAPCELL_ROW_47_1082 VGND VPWR sky130_fd_sc_hd__tapvpwrvgnd_1
XFILLER_21_521 VPWR VGND VPWR VGND sky130_ef_sc_hd__decap_12
XFILLER_34_893 VPWR VGND VPWR VGND sky130_ef_sc_hd__decap_12
XFILLER_40_318 VGND VGND VPWR VPWR sky130_fd_sc_hd__decap_8
X_09264_ _03019_ _03021_ _03022_ VGND VGND VPWR VPWR _03023_ sky130_fd_sc_hd__nand3_1
XFILLER_138_206 VPWR VGND VPWR VGND sky130_ef_sc_hd__decap_12
XTAP_TAPCELL_ROW_16_590 VGND VPWR sky130_fd_sc_hd__tapvpwrvgnd_1
XFILLER_21_543 VPWR VGND VPWR VGND sky130_ef_sc_hd__decap_12
X_09195_ _02951_ _02953_ VGND VGND VPWR VPWR _02954_ sky130_fd_sc_hd__or2_1
X_08215_ _02042_ _02044_ _02045_ VGND VGND VPWR VPWR _00736_ sky130_fd_sc_hd__o21a_1
X_08146_ _01884_ _01986_ VGND VGND VPWR VPWR _01987_ sky130_fd_sc_hd__nand2b_1
XTAP_TAPCELL_ROW_60_1293 VGND VPWR sky130_fd_sc_hd__tapvpwrvgnd_1
XFILLER_5_709 VPWR VGND VPWR VGND sky130_ef_sc_hd__decap_12
XFILLER_146_261 VGND VGND VPWR VPWR sky130_fd_sc_hd__fill_1
XFILLER_107_615 VGND VGND VPWR VPWR sky130_fd_sc_hd__fill_1
XFILLER_134_456 VPWR VGND VPWR VGND sky130_ef_sc_hd__decap_12
X_08077_ net169 _01928_ _01929_ net163 VGND VGND VPWR VPWR _01930_ sky130_fd_sc_hd__a31oi_1
X_07028_ net1175 net362 net272 VGND VGND VPWR VPWR _00068_ sky130_fd_sc_hd__mux2_1
XFILLER_106_158 VGND VGND VPWR VPWR sky130_fd_sc_hd__decap_6
XFILLER_88_521 VGND VGND VPWR VPWR sky130_fd_sc_hd__decap_8
Xhold22 u_interface.u_gelu_fp32.s1_data\[2\] VGND VGND VPWR VPWR net887 sky130_fd_sc_hd__dlygate4sd3_1
Xhold11 u_interface.u_gelu_fp32.u_synth_top.s1_x\[8\] VGND VGND VPWR VPWR net876 sky130_fd_sc_hd__dlygate4sd3_1
X_08979_ _02590_ _02591_ VGND VGND VPWR VPWR _02738_ sky130_fd_sc_hd__xor2_1
Xhold55 u_interface.u_gelu_fp32.u_synth_top.s2_b\[3\] VGND VGND VPWR VPWR net920 sky130_fd_sc_hd__dlygate4sd3_1
Xhold44 u_interface.u_gelu_fp32.u_q16_to_fp32.s2_is_zero VGND VGND VPWR VPWR net909
+ sky130_fd_sc_hd__dlygate4sd3_1
Xhold33 u_interface.u_gelu_fp32.s1_data\[20\] VGND VGND VPWR VPWR net898 sky130_fd_sc_hd__dlygate4sd3_1
XFILLER_29_55 VGND VGND VPWR VPWR sky130_fd_sc_hd__fill_1
Xhold88 _01002_ VGND VGND VPWR VPWR net953 sky130_fd_sc_hd__dlygate4sd3_1
Xhold77 u_interface.meta_tuser_pipe\[4\] VGND VGND VPWR VPWR net942 sky130_fd_sc_hd__dlygate4sd3_1
Xhold66 _00706_ VGND VGND VPWR VPWR net931 sky130_fd_sc_hd__dlygate4sd3_1
XFILLER_75_248 VGND VGND VPWR VPWR sky130_fd_sc_hd__fill_2
Xhold99 u_interface.fifo_data\[1\]\[20\] VGND VGND VPWR VPWR net964 sky130_fd_sc_hd__dlygate4sd3_1
X_11990_ _05721_ _05722_ _05723_ VGND VGND VPWR VPWR _00833_ sky130_fd_sc_hd__o21a_1
XFILLER_29_99 VGND VGND VPWR VPWR sky130_fd_sc_hd__fill_1
XFILLER_29_665 VGND VGND VPWR VPWR sky130_fd_sc_hd__decap_6
XFILLER_84_771 VGND VGND VPWR VPWR sky130_fd_sc_hd__fill_1
XTAP_TAPCELL_ROW_67_1414 VGND VPWR sky130_fd_sc_hd__tapvpwrvgnd_1
XTAP_TAPCELL_ROW_67_1403 VGND VPWR sky130_fd_sc_hd__tapvpwrvgnd_1
X_10941_ net473 _04573_ VGND VGND VPWR VPWR _04685_ sky130_fd_sc_hd__and2_1
XFILLER_45_21 VGND VGND VPWR VPWR sky130_fd_sc_hd__fill_1
X_13660_ clknet_leaf_14_clk _00670_ VGND VGND VPWR VPWR u_interface.u_gelu_fp32.u_fp32_to_q16.s1_exp\[6\]
+ sky130_fd_sc_hd__dfxtp_1
XFILLER_83_281 VPWR VGND VPWR VGND sky130_ef_sc_hd__decap_12
XFILLER_83_270 VGND VGND VPWR VPWR sky130_fd_sc_hd__fill_2
XFILLER_28_197 VPWR VGND VPWR VGND sky130_ef_sc_hd__decap_12
X_12611_ u_interface.u_gelu_fp32.u_q16_to_fp32.s1_mag\[5\] net211 u_interface.u_gelu_fp32.u_q16_to_fp32.s1_mag\[21\]
+ VGND VGND VPWR VPWR _06314_ sky130_fd_sc_hd__a21o_1
X_10872_ _04520_ _04523_ VGND VGND VPWR VPWR _04617_ sky130_fd_sc_hd__nand2_1
XTAP_TAPCELL_ROW_80_1614 VGND VPWR sky130_fd_sc_hd__tapvpwrvgnd_1
X_13591_ clknet_leaf_71_clk _00601_ VGND VGND VPWR VPWR u_interface.fifo_data\[3\]\[6\]
+ sky130_fd_sc_hd__dfxtp_1
XFILLER_43_189 VGND VGND VPWR VPWR sky130_fd_sc_hd__decap_3
X_12542_ _06221_ _06265_ VGND VGND VPWR VPWR _06266_ sky130_fd_sc_hd__xnor2_1
XFILLER_40_863 VGND VGND VPWR VPWR sky130_fd_sc_hd__decap_4
X_12473_ _06135_ _06197_ VGND VGND VPWR VPWR _06199_ sky130_fd_sc_hd__xnor2_1
XFILLER_8_525 VGND VGND VPWR VPWR sky130_fd_sc_hd__decap_6
XFILLER_12_587 VGND VGND VPWR VPWR sky130_fd_sc_hd__fill_1
XFILLER_8_569 VPWR VGND VPWR VGND sky130_ef_sc_hd__decap_12
XFILLER_6_15 VPWR VGND VPWR VGND sky130_ef_sc_hd__decap_12
X_11424_ net659 net667 net419 net412 VGND VGND VPWR VPWR _05164_ sky130_fd_sc_hd__nand4_1
XFILLER_138_784 VGND VGND VPWR VPWR sky130_fd_sc_hd__decap_8
XANTENNA_8 u_interface.u_gelu_fp32.u_synth_top.s2_dx\[31\] VGND VGND VPWR VPWR sky130_fd_sc_hd__diode_2
XTAP_TAPCELL_ROW_111_2113 VGND VPWR sky130_fd_sc_hd__tapvpwrvgnd_1
XTAP_TAPCELL_ROW_78_1587 VGND VPWR sky130_fd_sc_hd__tapvpwrvgnd_1
XTAP_TAPCELL_ROW_78_1576 VGND VPWR sky130_fd_sc_hd__tapvpwrvgnd_1
X_14143_ clknet_leaf_73_clk _01069_ VGND VGND VPWR VPWR u_interface.fifo_data\[1\]\[3\]
+ sky130_fd_sc_hd__dfxtp_1
X_11355_ _05095_ _05094_ VGND VGND VPWR VPWR _05096_ sky130_fd_sc_hd__and2b_1
X_14074_ clknet_leaf_16_clk net1379 VGND VGND VPWR VPWR u_interface.u_gelu_fp32.u_fp32_to_q16.s2_norm_mag\[11\]
+ sky130_fd_sc_hd__dfxtp_1
XFILLER_140_415 VGND VGND VPWR VPWR sky130_fd_sc_hd__decap_4
X_10306_ _04047_ _04055_ VGND VGND VPWR VPWR _04056_ sky130_fd_sc_hd__xnor2_1
X_11286_ _05025_ _05026_ VGND VGND VPWR VPWR _05027_ sky130_fd_sc_hd__nor2_1
XFILLER_112_139 VGND VGND VPWR VPWR sky130_fd_sc_hd__fill_1
XFILLER_112_117 VGND VGND VPWR VPWR sky130_fd_sc_hd__decap_4
X_10237_ _03985_ _03986_ _03977_ VGND VGND VPWR VPWR _03987_ sky130_fd_sc_hd__a21o_1
XFILLER_79_521 VGND VGND VPWR VPWR sky130_fd_sc_hd__decap_3
XPHY_EDGE_ROW_5_Left_161 VGND VGND VPWR VPWR sky130_fd_sc_hd__decap_3
X_13025_ _06268_ _06274_ net161 net160 _06250_ VGND VGND VPWR VPWR _00852_ sky130_fd_sc_hd__o2111a_1
XTAP_TAPCELL_ROW_91_1798 VGND VPWR sky130_fd_sc_hd__tapvpwrvgnd_1
XTAP_TAPCELL_ROW_91_1787 VGND VPWR sky130_fd_sc_hd__tapvpwrvgnd_1
XFILLER_86_83 VGND VGND VPWR VPWR sky130_fd_sc_hd__fill_1
X_10168_ _03917_ _03918_ _03800_ VGND VGND VPWR VPWR _03919_ sky130_fd_sc_hd__a21o_1
X_10099_ _03753_ _03848_ _03849_ VGND VGND VPWR VPWR _03851_ sky130_fd_sc_hd__nor3_1
XTAP_TAPCELL_ROW_109_2086 VGND VPWR sky130_fd_sc_hd__tapvpwrvgnd_1
XTAP_TAPCELL_ROW_109_2075 VGND VPWR sky130_fd_sc_hd__tapvpwrvgnd_1
X_13927_ clknet_leaf_6_clk net536 VGND VGND VPWR VPWR u_interface.u_gelu_fp32.u_synth_top.s1_x\[31\]
+ sky130_fd_sc_hd__dfxtp_1
XFILLER_75_782 VGND VGND VPWR VPWR sky130_fd_sc_hd__fill_2
XFILLER_75_760 VGND VGND VPWR VPWR sky130_fd_sc_hd__decap_4
XFILLER_35_613 VGND VGND VPWR VPWR sky130_fd_sc_hd__decap_3
XFILLER_62_421 VGND VGND VPWR VPWR sky130_fd_sc_hd__decap_6
XFILLER_34_123 VGND VGND VPWR VPWR sky130_fd_sc_hd__fill_1
XTAP_TAPCELL_ROW_122_2286 VGND VPWR sky130_fd_sc_hd__tapvpwrvgnd_1
X_13858_ clknet_leaf_87_clk _00868_ VGND VGND VPWR VPWR u_interface.u_gelu_fp32.u_synth_top.s3_b\[14\]
+ sky130_fd_sc_hd__dfxtp_1
XFILLER_62_454 VPWR VGND VPWR VGND sky130_ef_sc_hd__decap_12
X_12809_ net776 net99 VGND VGND VPWR VPWR _00967_ sky130_fd_sc_hd__and2_1
XFILLER_96_3 VGND VGND VPWR VPWR sky130_fd_sc_hd__decap_4
X_13789_ clknet_leaf_81_clk _00799_ VGND VGND VPWR VPWR u_interface.u_gelu_fp32.s2_data\[23\]
+ sky130_fd_sc_hd__dfxtp_1
XFILLER_16_893 VPWR VGND VPWR VGND sky130_ef_sc_hd__decap_12
XFILLER_148_515 VGND VGND VPWR VPWR sky130_fd_sc_hd__decap_6
XFILLER_31_841 VPWR VGND VPWR VGND sky130_ef_sc_hd__decap_12
XTAP_TAPCELL_ROW_33_858 VGND VPWR sky130_fd_sc_hd__tapvpwrvgnd_1
XTAP_TAPCELL_ROW_33_869 VGND VPWR sky130_fd_sc_hd__tapvpwrvgnd_1
XFILLER_148_526 VGND VGND VPWR VPWR sky130_fd_sc_hd__decap_6
XTAP_TAPCELL_ROW_98_1908 VGND VPWR sky130_fd_sc_hd__tapvpwrvgnd_1
X_08000_ net309 _01672_ _01864_ VGND VGND VPWR VPWR _01865_ sky130_fd_sc_hd__o21a_1
XFILLER_129_762 VPWR VGND VPWR VGND sky130_ef_sc_hd__decap_12
Xhold514 _01000_ VGND VGND VPWR VPWR net1379 sky130_fd_sc_hd__dlygate4sd3_1
Xhold536 u_interface.fifo_data\[2\]\[26\] VGND VGND VPWR VPWR net1401 sky130_fd_sc_hd__dlygate4sd3_1
Xhold503 u_interface.fifo_data\[1\]\[25\] VGND VGND VPWR VPWR net1368 sky130_fd_sc_hd__dlygate4sd3_1
Xhold525 u_interface.fifo_data\[4\]\[21\] VGND VGND VPWR VPWR net1390 sky130_fd_sc_hd__dlygate4sd3_1
XFILLER_143_253 VGND VGND VPWR VPWR sky130_fd_sc_hd__fill_2
X_09951_ _03597_ _03600_ VGND VGND VPWR VPWR _03704_ sky130_fd_sc_hd__nand2_1
Xhold569 u_interface.fifo_data\[8\]\[4\] VGND VGND VPWR VPWR net1434 sky130_fd_sc_hd__dlygate4sd3_1
Xhold547 u_interface.fifo_data\[9\]\[9\] VGND VGND VPWR VPWR net1412 sky130_fd_sc_hd__dlygate4sd3_1
Xhold558 u_interface.fifo_data\[10\]\[31\] VGND VGND VPWR VPWR net1423 sky130_fd_sc_hd__dlygate4sd3_1
XTAP_TAPCELL_ROW_129_2407 VGND VPWR sky130_fd_sc_hd__tapvpwrvgnd_1
X_08902_ _02660_ VGND VGND VPWR VPWR _02661_ sky130_fd_sc_hd__inv_2
XFILLER_112_651 VGND VGND VPWR VPWR sky130_fd_sc_hd__fill_1
XFILLER_106_49 VGND VGND VPWR VPWR sky130_fd_sc_hd__decap_4
X_09882_ _03544_ _03547_ VGND VGND VPWR VPWR _03635_ sky130_fd_sc_hd__nand2_1
X_08833_ _02587_ _02588_ _02590_ _02591_ VGND VGND VPWR VPWR _02592_ sky130_fd_sc_hd__a22o_1
XTAP_TAPCELL_ROW_142_2607 VGND VPWR sky130_fd_sc_hd__tapvpwrvgnd_1
X_08764_ _02521_ _02522_ _02520_ VGND VGND VPWR VPWR _02523_ sky130_fd_sc_hd__a21o_1
XFILLER_57_259 VGND VGND VPWR VPWR sky130_fd_sc_hd__decap_6
X_07715_ u_interface.u_gelu_fp32.u_synth_top.s1_hits\[11\] u_interface.u_gelu_fp32.u_synth_top.s1_hits\[1\]
+ _01441_ _01764_ VGND VGND VPWR VPWR _01769_ sky130_fd_sc_hd__or4_1
XFILLER_26_613 VPWR VGND VPWR VGND sky130_ef_sc_hd__decap_12
X_08695_ _02441_ _02453_ VGND VGND VPWR VPWR _02454_ sky130_fd_sc_hd__xnor2_1
XFILLER_65_281 VPWR VGND VPWR VGND sky130_ef_sc_hd__decap_12
XTAP_TAPCELL_ROW_49_1122 VGND VPWR sky130_fd_sc_hd__tapvpwrvgnd_1
XFILLER_26_657 VPWR VGND VPWR VGND sky130_ef_sc_hd__decap_12
XPHY_EDGE_ROW_146_Right_146 VGND VGND VPWR VPWR sky130_fd_sc_hd__decap_3
XFILLER_80_251 VGND VGND VPWR VPWR sky130_fd_sc_hd__fill_1
X_07646_ u_interface.u_gelu_fp32.u_q16_to_fp32.s2_mag\[10\] u_interface.u_gelu_fp32.u_q16_to_fp32.s2_mag\[9\]
+ net338 VGND VGND VPWR VPWR _01732_ sky130_fd_sc_hd__mux2_1
XFILLER_53_465 VGND VGND VPWR VPWR sky130_fd_sc_hd__fill_1
X_07577_ net810 net1774 net302 _01685_ VGND VGND VPWR VPWR _00457_ sky130_fd_sc_hd__a22o_1
XTAP_TAPCELL_ROW_62_1322 VGND VPWR sky130_fd_sc_hd__tapvpwrvgnd_1
XFILLER_15_57 VPWR VGND VPWR VGND sky130_ef_sc_hd__decap_12
X_06528_ _01127_ VGND VGND VPWR VPWR net150 sky130_fd_sc_hd__inv_2
X_09316_ _03051_ _03054_ _03053_ VGND VGND VPWR VPWR _03075_ sky130_fd_sc_hd__a21o_1
XTAP_TAPCELL_ROW_62_1333 VGND VPWR sky130_fd_sc_hd__tapvpwrvgnd_1
X_09247_ _02812_ _02818_ _02867_ VGND VGND VPWR VPWR _03006_ sky130_fd_sc_hd__and3_1
XFILLER_139_537 VGND VGND VPWR VPWR sky130_fd_sc_hd__fill_1
XTAP_TAPCELL_ROW_11_508 VGND VPWR sky130_fd_sc_hd__tapvpwrvgnd_1
XTAP_TAPCELL_ROW_11_519 VGND VPWR sky130_fd_sc_hd__tapvpwrvgnd_1
XFILLER_108_902 VGND VGND VPWR VPWR sky130_fd_sc_hd__fill_1
XFILLER_21_384 VGND VGND VPWR VPWR sky130_fd_sc_hd__decap_8
X_09178_ _02933_ _02935_ _02936_ VGND VGND VPWR VPWR _02937_ sky130_fd_sc_hd__nand3_1
XFILLER_5_517 VPWR VGND VPWR VGND sky130_ef_sc_hd__decap_12
X_08129_ net313 _01971_ _01972_ VGND VGND VPWR VPWR _01973_ sky130_fd_sc_hd__or3_1
XFILLER_31_89 VGND VGND VPWR VPWR sky130_fd_sc_hd__decap_3
XFILLER_134_253 VGND VGND VPWR VPWR sky130_fd_sc_hd__decap_3
X_11140_ _04882_ _04881_ VGND VGND VPWR VPWR _04883_ sky130_fd_sc_hd__and2b_1
XFILLER_122_448 VPWR VGND VPWR VGND sky130_ef_sc_hd__decap_12
Xinput101 s_axis_tdata[5] VGND VGND VPWR VPWR net101 sky130_fd_sc_hd__clkbuf_1
XFILLER_150_779 VGND VGND VPWR VPWR sky130_fd_sc_hd__decap_3
X_11071_ net694 net448 _04723_ _04722_ VGND VGND VPWR VPWR _04814_ sky130_fd_sc_hd__a31o_1
XFILLER_49_705 VGND VGND VPWR VPWR sky130_fd_sc_hd__fill_1
X_10022_ _03771_ _03772_ _03643_ _03645_ VGND VGND VPWR VPWR _03774_ sky130_fd_sc_hd__o211a_1
XFILLER_88_362 VGND VGND VPWR VPWR sky130_fd_sc_hd__fill_2
XFILLER_49_738 VGND VGND VPWR VPWR sky130_fd_sc_hd__decap_4
XFILLER_0_277 VGND VGND VPWR VPWR sky130_fd_sc_hd__decap_3
XFILLER_76_568 VGND VGND VPWR VPWR sky130_fd_sc_hd__decap_4
XFILLER_44_432 VPWR VGND VPWR VGND sky130_ef_sc_hd__decap_12
X_11973_ _05705_ _05706_ VGND VGND VPWR VPWR _05707_ sky130_fd_sc_hd__nand2_1
XPHY_EDGE_ROW_113_Right_113 VGND VGND VPWR VPWR sky130_fd_sc_hd__decap_3
X_13712_ clknet_leaf_2_clk _00722_ VGND VGND VPWR VPWR u_interface.u_gelu_fp32.s1_data\[12\]
+ sky130_fd_sc_hd__dfxtp_1
X_10924_ _04433_ _04553_ VGND VGND VPWR VPWR _04669_ sky130_fd_sc_hd__or2_1
XFILLER_72_752 VGND VGND VPWR VPWR sky130_fd_sc_hd__decap_4
X_13643_ clknet_leaf_41_clk _00653_ VGND VGND VPWR VPWR u_interface.fifo_data\[13\]\[26\]
+ sky130_fd_sc_hd__dfxtp_1
X_10855_ _04598_ _04599_ VGND VGND VPWR VPWR _04600_ sky130_fd_sc_hd__and2b_1
XFILLER_72_85 VGND VGND VPWR VPWR sky130_fd_sc_hd__decap_4
X_13574_ clknet_leaf_83_clk _00584_ VGND VGND VPWR VPWR u_interface.fifo_data\[4\]\[21\]
+ sky130_fd_sc_hd__dfxtp_1
XFILLER_13_841 VPWR VGND VPWR VGND sky130_ef_sc_hd__decap_12
X_10786_ _04528_ _04529_ _04407_ VGND VGND VPWR VPWR _04532_ sky130_fd_sc_hd__or3b_1
X_12525_ _06247_ _06248_ VGND VGND VPWR VPWR _06250_ sky130_fd_sc_hd__nand2_1
XTAP_TAPCELL_ROW_30_817 VGND VPWR sky130_fd_sc_hd__tapvpwrvgnd_1
XFILLER_9_889 VGND VGND VPWR VPWR sky130_fd_sc_hd__decap_6
X_12456_ _06131_ _06134_ net177 VGND VGND VPWR VPWR _06182_ sky130_fd_sc_hd__o21a_1
XTAP_TAPCELL_ROW_93_1816 VGND VPWR sky130_fd_sc_hd__tapvpwrvgnd_1
X_11407_ net712 _05146_ _05145_ VGND VGND VPWR VPWR _05147_ sky130_fd_sc_hd__a21bo_1
X_12387_ _06066_ _06114_ VGND VGND VPWR VPWR _06115_ sky130_fd_sc_hd__xor2_1
X_14126_ clknet_leaf_33_clk _01052_ VGND VGND VPWR VPWR u_interface.fifo_wr_ptr\[3\]
+ sky130_fd_sc_hd__dfxtp_1
XTAP_TAPCELL_ROW_93_1827 VGND VPWR sky130_fd_sc_hd__tapvpwrvgnd_1
X_11338_ net633 net403 net399 net625 VGND VGND VPWR VPWR _05079_ sky130_fd_sc_hd__a22oi_1
XFILLER_125_297 VGND VGND VPWR VPWR sky130_fd_sc_hd__decap_3
XFILLER_125_275 VGND VGND VPWR VPWR sky130_fd_sc_hd__decap_4
X_14057_ clknet_leaf_16_clk _00983_ VGND VGND VPWR VPWR u_interface.u_gelu_fp32.u_fp32_to_q16.s1_mant\[19\]
+ sky130_fd_sc_hd__dfxtp_1
XFILLER_140_267 VPWR VGND VPWR VGND sky130_ef_sc_hd__decap_12
XFILLER_140_245 VGND VGND VPWR VPWR sky130_fd_sc_hd__decap_6
X_11269_ _05010_ _05009_ VGND VGND VPWR VPWR _05011_ sky130_fd_sc_hd__nand2b_1
X_13008_ net1368 net573 net224 VGND VGND VPWR VPWR _01091_ sky130_fd_sc_hd__mux2_1
XFILLER_67_513 VPWR VGND VPWR VGND sky130_ef_sc_hd__decap_12
XFILLER_11_3 VPWR VGND VPWR VGND sky130_ef_sc_hd__decap_12
XFILLER_39_248 VGND VGND VPWR VPWR sky130_fd_sc_hd__fill_1
XTAP_TAPCELL_ROW_124_2326 VGND VPWR sky130_fd_sc_hd__tapvpwrvgnd_1
XTAP_TAPCELL_ROW_124_2315 VGND VPWR sky130_fd_sc_hd__tapvpwrvgnd_1
XFILLER_94_365 VGND VGND VPWR VPWR sky130_fd_sc_hd__fill_2
XFILLER_48_782 VGND VGND VPWR VPWR sky130_fd_sc_hd__fill_2
X_07500_ _01566_ _01545_ net550 VGND VGND VPWR VPWR _01632_ sky130_fd_sc_hd__mux2_1
XFILLER_82_549 VGND VGND VPWR VPWR sky130_fd_sc_hd__fill_1
XFILLER_47_281 VGND VGND VPWR VPWR sky130_fd_sc_hd__decap_8
XTAP_TAPCELL_ROW_38_939 VGND VPWR sky130_fd_sc_hd__tapvpwrvgnd_1
XFILLER_63_752 VGND VGND VPWR VPWR sky130_fd_sc_hd__fill_1
XFILLER_62_240 VPWR VGND VPWR VGND sky130_ef_sc_hd__decap_12
XPHY_EDGE_ROW_59_Left_215 VGND VGND VPWR VPWR sky130_fd_sc_hd__decap_3
XTAP_TAPCELL_ROW_18_630 VGND VPWR sky130_fd_sc_hd__tapvpwrvgnd_1
X_08480_ net522 u_interface.u_gelu_fp32.u_synth_top.s3_mult\[42\] VGND VGND VPWR VPWR
+ _02271_ sky130_fd_sc_hd__and2_1
X_07431_ _01563_ _01566_ net550 VGND VGND VPWR VPWR _01567_ sky130_fd_sc_hd__mux2_1
XFILLER_149_813 VGND VGND VPWR VPWR sky130_fd_sc_hd__fill_1
X_07362_ net569 net1545 net242 VGND VGND VPWR VPWR _00392_ sky130_fd_sc_hd__mux2_1
XTAP_TAPCELL_ROW_44_1041 VGND VPWR sky130_fd_sc_hd__tapvpwrvgnd_1
X_09101_ _02804_ _02820_ _02858_ VGND VGND VPWR VPWR _02860_ sky130_fd_sc_hd__o21ai_1
XTAP_TAPCELL_ROW_102_1967 VGND VPWR sky130_fd_sc_hd__tapvpwrvgnd_1
XFILLER_31_671 VGND VGND VPWR VPWR sky130_fd_sc_hd__fill_1
X_07293_ net1124 net341 net248 VGND VGND VPWR VPWR _00323_ sky130_fd_sc_hd__mux2_1
XFILLER_149_879 VGND VGND VPWR VPWR sky130_fd_sc_hd__fill_2
XFILLER_30_181 VGND VGND VPWR VPWR sky130_fd_sc_hd__fill_1
X_09032_ _02742_ _02789_ _02790_ VGND VGND VPWR VPWR _02791_ sky130_fd_sc_hd__nand3_1
XFILLER_108_209 VPWR VGND VPWR VGND sky130_ef_sc_hd__decap_12
Xhold311 u_interface.fifo_data\[0\]\[16\] VGND VGND VPWR VPWR net1176 sky130_fd_sc_hd__dlygate4sd3_1
XTAP_TAPCELL_ROW_135_2499 VGND VPWR sky130_fd_sc_hd__tapvpwrvgnd_1
XTAP_TAPCELL_ROW_135_2488 VGND VPWR sky130_fd_sc_hd__tapvpwrvgnd_1
Xhold300 u_interface.fifo_data\[12\]\[29\] VGND VGND VPWR VPWR net1165 sky130_fd_sc_hd__dlygate4sd3_1
XPHY_EDGE_ROW_68_Left_224 VGND VGND VPWR VPWR sky130_fd_sc_hd__decap_3
Xhold322 u_interface.fifo_tlast\[9\] VGND VGND VPWR VPWR net1187 sky130_fd_sc_hd__dlygate4sd3_1
XFILLER_116_253 VGND VGND VPWR VPWR sky130_fd_sc_hd__decap_4
XFILLER_104_404 VPWR VGND VPWR VGND sky130_ef_sc_hd__decap_12
Xhold333 _00889_ VGND VGND VPWR VPWR net1198 sky130_fd_sc_hd__dlygate4sd3_1
Xhold344 u_interface.fifo_data\[4\]\[2\] VGND VGND VPWR VPWR net1209 sky130_fd_sc_hd__dlygate4sd3_1
Xhold377 u_interface.u_gelu_fp32.u_fp32_to_q16.s1_mant\[13\] VGND VGND VPWR VPWR net1242
+ sky130_fd_sc_hd__dlygate4sd3_1
XFILLER_131_223 VGND VGND VPWR VPWR sky130_fd_sc_hd__fill_1
Xhold355 u_interface.fifo_data\[2\]\[15\] VGND VGND VPWR VPWR net1220 sky130_fd_sc_hd__dlygate4sd3_1
Xhold366 u_interface.fifo_data\[5\]\[6\] VGND VGND VPWR VPWR net1231 sky130_fd_sc_hd__dlygate4sd3_1
Xhold388 u_interface.fifo_data\[6\]\[10\] VGND VGND VPWR VPWR net1253 sky130_fd_sc_hd__dlygate4sd3_1
XFILLER_131_234 VGND VGND VPWR VPWR sky130_fd_sc_hd__decap_3
Xfanout813 net814 VGND VGND VPWR VPWR net813 sky130_fd_sc_hd__buf_2
Xhold399 u_interface.fifo_data\[5\]\[29\] VGND VGND VPWR VPWR net1264 sky130_fd_sc_hd__dlygate4sd3_1
XFILLER_104_459 VPWR VGND VPWR VGND sky130_ef_sc_hd__decap_12
Xfanout824 net826 VGND VGND VPWR VPWR net824 sky130_fd_sc_hd__dlymetal6s2s_1
X_09934_ _03607_ _03609_ VGND VGND VPWR VPWR _03687_ sky130_fd_sc_hd__nand2b_1
Xfanout802 net804 VGND VGND VPWR VPWR net802 sky130_fd_sc_hd__clkbuf_4
X_09865_ _03564_ _03565_ _03616_ _03617_ VGND VGND VPWR VPWR _03619_ sky130_fd_sc_hd__nor4_1
XFILLER_86_822 VGND VGND VPWR VPWR sky130_fd_sc_hd__decap_4
X_08816_ _02516_ _02558_ _02557_ VGND VGND VPWR VPWR _02575_ sky130_fd_sc_hd__a21o_1
XFILLER_100_654 VGND VGND VPWR VPWR sky130_fd_sc_hd__decap_3
XFILLER_100_643 VGND VGND VPWR VPWR sky130_fd_sc_hd__fill_1
X_09796_ _03548_ _03549_ _03542_ VGND VGND VPWR VPWR _03550_ sky130_fd_sc_hd__a21o_1
XFILLER_73_527 VGND VGND VPWR VPWR sky130_fd_sc_hd__fill_2
XFILLER_45_218 VGND VGND VPWR VPWR sky130_fd_sc_hd__decap_6
XFILLER_39_771 VGND VGND VPWR VPWR sky130_fd_sc_hd__decap_4
X_08747_ _02503_ _02505_ VGND VGND VPWR VPWR _02506_ sky130_fd_sc_hd__and2b_1
XPHY_EDGE_ROW_77_Left_233 VGND VGND VPWR VPWR sky130_fd_sc_hd__decap_3
XFILLER_26_421 VPWR VGND VPWR VGND sky130_ef_sc_hd__decap_12
X_08678_ net152 _02438_ net798 VGND VGND VPWR VPWR _00806_ sky130_fd_sc_hd__a21oi_1
XFILLER_38_292 VPWR VGND VPWR VGND sky130_ef_sc_hd__decap_12
X_07629_ u_interface.u_gelu_fp32.u_q16_to_fp32.s2_mag\[6\] u_interface.u_gelu_fp32.u_q16_to_fp32.s2_mag\[5\]
+ net338 VGND VGND VPWR VPWR _01719_ sky130_fd_sc_hd__mux2_1
X_10640_ _04385_ _04386_ _04378_ VGND VGND VPWR VPWR _04387_ sky130_fd_sc_hd__a21o_1
XFILLER_13_137 VPWR VGND VPWR VGND sky130_ef_sc_hd__decap_12
XFILLER_41_435 VGND VGND VPWR VPWR sky130_fd_sc_hd__fill_1
XTAP_TAPCELL_ROW_155_2809 VGND VPWR sky130_fd_sc_hd__tapvpwrvgnd_1
XFILLER_10_811 VGND VGND VPWR VPWR sky130_fd_sc_hd__fill_1
XFILLER_139_334 VGND VGND VPWR VPWR sky130_fd_sc_hd__fill_2
X_10571_ net801 _04318_ VGND VGND VPWR VPWR _00819_ sky130_fd_sc_hd__nor2_1
XFILLER_22_693 VGND VGND VPWR VPWR sky130_fd_sc_hd__decap_6
X_13290_ clknet_leaf_29_clk _00300_ VGND VGND VPWR VPWR u_interface.meta_tlast_pipe\[0\]
+ sky130_fd_sc_hd__dfxtp_1
XFILLER_127_529 VPWR VGND VPWR VGND sky130_ef_sc_hd__decap_12
XPHY_EDGE_ROW_86_Left_242 VGND VGND VPWR VPWR sky130_fd_sc_hd__decap_3
XFILLER_6_837 VPWR VGND VPWR VGND sky130_ef_sc_hd__decap_12
X_12310_ _05952_ _05975_ _05974_ VGND VGND VPWR VPWR _06039_ sky130_fd_sc_hd__a21boi_1
XFILLER_108_754 VGND VGND VPWR VPWR sky130_fd_sc_hd__fill_2
X_12241_ _05968_ _05969_ VGND VGND VPWR VPWR _05971_ sky130_fd_sc_hd__xnor2_1
XFILLER_135_573 VGND VGND VPWR VPWR sky130_fd_sc_hd__fill_1
XTAP_TAPCELL_ROW_75_1535 VGND VPWR sky130_fd_sc_hd__tapvpwrvgnd_1
XFILLER_123_724 VGND VGND VPWR VPWR sky130_fd_sc_hd__decap_4
XFILLER_107_275 VGND VGND VPWR VPWR sky130_fd_sc_hd__decap_4
X_12172_ _05827_ _05836_ _05835_ VGND VGND VPWR VPWR _05903_ sky130_fd_sc_hd__a21oi_1
X_11123_ net624 net404 net400 net611 VGND VGND VPWR VPWR _04866_ sky130_fd_sc_hd__a22oi_1
XFILLER_1_553 VGND VGND VPWR VPWR sky130_fd_sc_hd__decap_6
XFILLER_3_27 VPWR VGND VPWR VGND sky130_ef_sc_hd__decap_12
XFILLER_150_576 VPWR VGND VPWR VGND sky130_ef_sc_hd__decap_12
XFILLER_89_671 VGND VGND VPWR VPWR sky130_fd_sc_hd__fill_1
X_11054_ _03658_ _04678_ _03655_ VGND VGND VPWR VPWR _04797_ sky130_fd_sc_hd__o21a_1
X_10005_ _03750_ _03756_ VGND VGND VPWR VPWR _03757_ sky130_fd_sc_hd__nor2_1
XFILLER_1_597 VPWR VGND VPWR VGND sky130_ef_sc_hd__decap_12
XPHY_EDGE_ROW_95_Left_251 VGND VGND VPWR VPWR sky130_fd_sc_hd__decap_3
XFILLER_76_365 VGND VGND VPWR VPWR sky130_fd_sc_hd__decap_4
XFILLER_64_516 VPWR VGND VPWR VGND sky130_ef_sc_hd__decap_12
XTAP_TAPCELL_ROW_106_2034 VGND VPWR sky130_fd_sc_hd__tapvpwrvgnd_1
XFILLER_92_869 VGND VGND VPWR VPWR sky130_fd_sc_hd__fill_1
XFILLER_92_847 VGND VGND VPWR VPWR sky130_fd_sc_hd__fill_1
XFILLER_29_281 VPWR VGND VPWR VGND sky130_ef_sc_hd__decap_12
XFILLER_17_432 VGND VGND VPWR VPWR sky130_fd_sc_hd__decap_8
X_11956_ _05688_ _05689_ VGND VGND VPWR VPWR _05690_ sky130_fd_sc_hd__and2_1
XFILLER_83_95 VGND VGND VPWR VPWR sky130_fd_sc_hd__decap_6
X_10907_ _04649_ _04650_ _04651_ VGND VGND VPWR VPWR _04652_ sky130_fd_sc_hd__a21o_1
XFILLER_32_413 VGND VGND VPWR VPWR sky130_fd_sc_hd__decap_6
X_11887_ _05510_ _05543_ _05542_ VGND VGND VPWR VPWR _05622_ sky130_fd_sc_hd__a21bo_1
X_13626_ clknet_leaf_71_clk _00636_ VGND VGND VPWR VPWR u_interface.fifo_data\[13\]\[9\]
+ sky130_fd_sc_hd__dfxtp_1
X_10838_ _04581_ _04582_ VGND VGND VPWR VPWR _04583_ sky130_fd_sc_hd__and2b_1
XFILLER_13_671 VGND VGND VPWR VPWR sky130_fd_sc_hd__fill_1
X_13557_ clknet_leaf_48_clk _00567_ VGND VGND VPWR VPWR u_interface.fifo_data\[4\]\[4\]
+ sky130_fd_sc_hd__dfxtp_1
X_10769_ _04511_ _04514_ VGND VGND VPWR VPWR _04515_ sky130_fd_sc_hd__xnor2_1
XFILLER_9_653 VPWR VGND VPWR VGND sky130_ef_sc_hd__decap_12
X_13488_ clknet_leaf_4_clk _00498_ VGND VGND VPWR VPWR u_interface.u_gelu_fp32.u_synth_top.s2_b\[5\]
+ sky130_fd_sc_hd__dfxtp_1
X_12508_ _06196_ _06198_ _06231_ VGND VGND VPWR VPWR _06233_ sky130_fd_sc_hd__a21o_1
XFILLER_8_141 VPWR VGND VPWR VGND sky130_ef_sc_hd__decap_12
XFILLER_145_359 VGND VGND VPWR VPWR sky130_fd_sc_hd__decap_8
XFILLER_145_337 VPWR VGND VPWR VGND sky130_ef_sc_hd__decap_12
XFILLER_9_697 VPWR VGND VPWR VGND sky130_ef_sc_hd__decap_12
X_12439_ net191 _06165_ VGND VGND VPWR VPWR _06166_ sky130_fd_sc_hd__or2_1
XFILLER_126_540 VPWR VGND VPWR VGND sky130_ef_sc_hd__decap_12
XFILLER_59_3 VPWR VGND VPWR VGND sky130_ef_sc_hd__decap_12
XFILLER_154_893 VPWR VGND VPWR VGND sky130_ef_sc_hd__decap_12
XFILLER_141_532 VPWR VGND VPWR VGND sky130_ef_sc_hd__decap_12
XFILLER_141_510 VGND VGND VPWR VPWR sky130_fd_sc_hd__decap_4
X_14109_ clknet_leaf_27_clk _01035_ VGND VGND VPWR VPWR u_interface.meta_tlast_pipe\[2\]
+ sky130_fd_sc_hd__dfxtp_1
X_07980_ net542 _01688_ net279 _01643_ net815 VGND VGND VPWR VPWR _01852_ sky130_fd_sc_hd__a221o_1
XFILLER_102_919 VGND VGND VPWR VPWR sky130_fd_sc_hd__fill_2
XFILLER_86_107 VGND VGND VPWR VPWR sky130_fd_sc_hd__fill_1
X_06931_ u_interface.u_gelu_fp32.u_synth_top.s1_x\[23\] net273 VGND VGND VPWR VPWR
+ _01466_ sky130_fd_sc_hd__xnor2_1
X_09650_ _03364_ net176 _03402_ _03403_ VGND VGND VPWR VPWR _03406_ sky130_fd_sc_hd__or4_1
X_06862_ u_interface.fifo_data\[12\]\[29\] u_interface.fifo_data\[13\]\[29\] u_interface.fifo_data\[14\]\[29\]
+ u_interface.fifo_data\[15\]\[29\] net766 net749 VGND VGND VPWR VPWR _01408_ sky130_fd_sc_hd__mux4_1
X_08601_ _02189_ _02190_ _02193_ _02229_ VGND VGND VPWR VPWR _02382_ sky130_fd_sc_hd__a211o_1
XFILLER_55_505 VPWR VGND VPWR VGND sky130_ef_sc_hd__decap_12
X_09581_ _03335_ _03336_ _03334_ VGND VGND VPWR VPWR _03337_ sky130_fd_sc_hd__a21o_1
X_06793_ u_interface.fifo_data\[0\]\[20\] u_interface.fifo_data\[1\]\[20\] u_interface.fifo_data\[2\]\[20\]
+ u_interface.fifo_data\[3\]\[20\] net758 net741 VGND VGND VPWR VPWR _01348_ sky130_fd_sc_hd__mux4_1
X_08532_ _02303_ _02322_ VGND VGND VPWR VPWR _02323_ sky130_fd_sc_hd__xor2_1
X_08463_ net526 u_interface.u_gelu_fp32.u_synth_top.s3_mult\[36\] VGND VGND VPWR VPWR
+ _02254_ sky130_fd_sc_hd__and2_1
XFILLER_35_262 VGND VGND VPWR VPWR sky130_fd_sc_hd__fill_2
X_07414_ u_interface.u_gelu_fp32.u_fp32_to_q16.s2_norm_mag\[24\] u_interface.u_gelu_fp32.u_fp32_to_q16.s2_norm_mag\[25\]
+ net560 VGND VGND VPWR VPWR _01550_ sky130_fd_sc_hd__mux2_1
XFILLER_50_221 VGND VGND VPWR VPWR sky130_fd_sc_hd__decap_8
X_08394_ u_interface.u_gelu_fp32.u_synth_top.s3_mult\[28\] u_interface.u_gelu_fp32.u_synth_top.s3_b\[12\]
+ VGND VGND VPWR VPWR _02185_ sky130_fd_sc_hd__or2_1
XFILLER_50_276 VPWR VGND VPWR VGND sky130_ef_sc_hd__decap_12
X_07345_ net364 net1574 net243 VGND VGND VPWR VPWR _00375_ sky130_fd_sc_hd__mux2_1
XTAP_TAPCELL_ROW_137_2528 VGND VPWR sky130_fd_sc_hd__tapvpwrvgnd_1
XFILLER_148_153 VGND VGND VPWR VPWR sky130_fd_sc_hd__decap_8
Xclkbuf_leaf_30_clk clknet_3_6__leaf_clk VGND VGND VPWR VPWR clknet_leaf_30_clk sky130_fd_sc_hd__clkbuf_8
X_07276_ net1354 net375 net246 VGND VGND VPWR VPWR _00306_ sky130_fd_sc_hd__mux2_1
XTAP_TAPCELL_ROW_21_669 VGND VPWR sky130_fd_sc_hd__tapvpwrvgnd_1
XTAP_TAPCELL_ROW_150_2728 VGND VPWR sky130_fd_sc_hd__tapvpwrvgnd_1
XFILLER_148_197 VGND VGND VPWR VPWR sky130_fd_sc_hd__decap_4
X_09015_ _02771_ _02773_ VGND VGND VPWR VPWR _02774_ sky130_fd_sc_hd__and2b_1
XFILLER_128_36 VGND VGND VPWR VPWR sky130_fd_sc_hd__fill_1
XFILLER_128_25 VGND VGND VPWR VPWR sky130_fd_sc_hd__decap_3
XTAP_TAPCELL_ROW_150_2739 VGND VPWR sky130_fd_sc_hd__tapvpwrvgnd_1
XFILLER_132_510 VPWR VGND VPWR VGND sky130_ef_sc_hd__decap_12
Xhold152 u_interface.fifo_data\[9\]\[14\] VGND VGND VPWR VPWR net1017 sky130_fd_sc_hd__dlygate4sd3_1
XFILLER_117_573 VPWR VGND VPWR VGND sky130_ef_sc_hd__decap_12
Xhold130 u_interface.fifo_data\[1\]\[14\] VGND VGND VPWR VPWR net995 sky130_fd_sc_hd__dlygate4sd3_1
Xhold141 u_interface.fifo_data\[1\]\[23\] VGND VGND VPWR VPWR net1006 sky130_fd_sc_hd__dlygate4sd3_1
XTAP_TAPCELL_ROW_57_1254 VGND VPWR sky130_fd_sc_hd__tapvpwrvgnd_1
XTAP_TAPCELL_ROW_57_1243 VGND VPWR sky130_fd_sc_hd__tapvpwrvgnd_1
Xhold174 u_interface.fifo_data\[10\]\[14\] VGND VGND VPWR VPWR net1039 sky130_fd_sc_hd__dlygate4sd3_1
Xhold185 u_interface.fifo_data\[15\]\[12\] VGND VGND VPWR VPWR net1050 sky130_fd_sc_hd__dlygate4sd3_1
Xhold163 u_interface.fifo_data\[5\]\[9\] VGND VGND VPWR VPWR net1028 sky130_fd_sc_hd__dlygate4sd3_1
XFILLER_132_587 VGND VGND VPWR VPWR sky130_fd_sc_hd__fill_1
Xfanout621 net623 VGND VGND VPWR VPWR net621 sky130_fd_sc_hd__buf_2
Xfanout632 u_interface.u_gelu_fp32.u_synth_top.s2_m\[6\] VGND VGND VPWR VPWR net632
+ sky130_fd_sc_hd__buf_2
X_09917_ net608 net616 net446 net441 VGND VGND VPWR VPWR _03670_ sky130_fd_sc_hd__and4_1
Xfanout610 net616 VGND VGND VPWR VPWR net610 sky130_fd_sc_hd__buf_1
Xhold196 u_interface.fifo_data\[8\]\[21\] VGND VGND VPWR VPWR net1061 sky130_fd_sc_hd__dlygate4sd3_1
Xfanout654 net656 VGND VGND VPWR VPWR net654 sky130_fd_sc_hd__clkbuf_4
Xfanout665 u_interface.u_gelu_fp32.u_synth_top.s2_m\[10\] VGND VGND VPWR VPWR net665
+ sky130_fd_sc_hd__clkbuf_2
XTAP_TAPCELL_ROW_70_1454 VGND VPWR sky130_fd_sc_hd__tapvpwrvgnd_1
XFILLER_58_321 VGND VGND VPWR VPWR sky130_fd_sc_hd__decap_8
Xfanout643 u_interface.u_gelu_fp32.u_synth_top.s2_m\[8\] VGND VGND VPWR VPWR net643
+ sky130_fd_sc_hd__buf_1
Xfanout676 net683 VGND VGND VPWR VPWR net676 sky130_fd_sc_hd__clkbuf_2
Xfanout698 net699 VGND VGND VPWR VPWR net698 sky130_fd_sc_hd__clkbuf_2
X_09848_ _03596_ _03599_ _03600_ VGND VGND VPWR VPWR _03602_ sky130_fd_sc_hd__nand3_1
Xfanout687 u_interface.u_gelu_fp32.u_synth_top.s2_m\[13\] VGND VGND VPWR VPWR net687
+ sky130_fd_sc_hd__clkbuf_2
XFILLER_58_365 VGND VGND VPWR VPWR sky130_fd_sc_hd__fill_2
XFILLER_37_33 VGND VGND VPWR VPWR sky130_fd_sc_hd__fill_1
X_09779_ net500 net505 net724 VGND VGND VPWR VPWR _03533_ sky130_fd_sc_hd__and3_1
XFILLER_46_549 VGND VGND VPWR VPWR sky130_fd_sc_hd__decap_4
X_12790_ net1661 _01785_ _06411_ VGND VGND VPWR VPWR _00955_ sky130_fd_sc_hd__a21oi_1
XTAP_TAPCELL_ROW_1_350 VGND VPWR sky130_fd_sc_hd__tapvpwrvgnd_1
XFILLER_27_741 VPWR VGND VPWR VGND sky130_ef_sc_hd__decap_12
X_11810_ _05544_ _05545_ VGND VGND VPWR VPWR _05546_ sky130_fd_sc_hd__nor2_1
XFILLER_54_560 VPWR VGND VPWR VGND sky130_ef_sc_hd__decap_12
X_11741_ _05476_ _05477_ VGND VGND VPWR VPWR _05478_ sky130_fd_sc_hd__or2_1
XFILLER_27_785 VPWR VGND VPWR VGND sky130_ef_sc_hd__decap_12
XFILLER_41_221 VGND VGND VPWR VPWR sky130_fd_sc_hd__decap_3
XFILLER_42_755 VGND VGND VPWR VPWR sky130_fd_sc_hd__fill_1
XFILLER_14_457 VPWR VGND VPWR VGND sky130_ef_sc_hd__decap_12
XFILLER_30_917 VGND VGND VPWR VPWR sky130_fd_sc_hd__fill_1
X_11672_ _05342_ _05344_ net201 VGND VGND VPWR VPWR _05409_ sky130_fd_sc_hd__nand3_1
X_13411_ clknet_leaf_46_clk _00421_ VGND VGND VPWR VPWR u_interface.fifo_data\[6\]\[24\]
+ sky130_fd_sc_hd__dfxtp_1
X_10623_ _04275_ _04277_ _04366_ net188 VGND VGND VPWR VPWR _04370_ sky130_fd_sc_hd__a211o_1
XFILLER_41_298 VPWR VGND VPWR VGND sky130_ef_sc_hd__decap_12
Xclkbuf_leaf_21_clk clknet_3_3__leaf_clk VGND VGND VPWR VPWR clknet_leaf_21_clk sky130_fd_sc_hd__clkbuf_8
XFILLER_154_101 VGND VGND VPWR VPWR sky130_fd_sc_hd__decap_4
XFILLER_139_142 VGND VGND VPWR VPWR sky130_fd_sc_hd__decap_4
X_13342_ clknet_leaf_34_clk _00352_ VGND VGND VPWR VPWR u_interface.fifo_data\[10\]\[19\]
+ sky130_fd_sc_hd__dfxtp_1
XFILLER_127_315 VGND VGND VPWR VPWR sky130_fd_sc_hd__decap_6
X_10554_ _04176_ _04178_ _04299_ _04300_ VGND VGND VPWR VPWR _04302_ sky130_fd_sc_hd__a211o_1
XFILLER_6_601 VPWR VGND VPWR VGND sky130_ef_sc_hd__decap_12
XTAP_TAPCELL_ROW_40_978 VGND VPWR sky130_fd_sc_hd__tapvpwrvgnd_1
XFILLER_155_657 VGND VGND VPWR VPWR sky130_fd_sc_hd__decap_4
XFILLER_127_337 VGND VGND VPWR VPWR sky130_fd_sc_hd__decap_6
XFILLER_6_645 VPWR VGND VPWR VGND sky130_ef_sc_hd__decap_12
XFILLER_5_111 VGND VGND VPWR VPWR sky130_fd_sc_hd__fill_1
XFILLER_142_307 VGND VGND VPWR VPWR sky130_fd_sc_hd__fill_1
X_13273_ clknet_leaf_48_clk _00283_ VGND VGND VPWR VPWR u_interface.fifo_data\[0\]\[15\]
+ sky130_fd_sc_hd__dfxtp_1
X_10485_ _04112_ _04114_ _04113_ VGND VGND VPWR VPWR _04233_ sky130_fd_sc_hd__a21bo_1
XFILLER_151_830 VGND VGND VPWR VPWR sky130_fd_sc_hd__fill_1
X_12224_ _05745_ _05953_ VGND VGND VPWR VPWR _05954_ sky130_fd_sc_hd__xor2_1
XFILLER_151_841 VGND VGND VPWR VPWR sky130_fd_sc_hd__fill_1
XFILLER_123_543 VGND VGND VPWR VPWR sky130_fd_sc_hd__fill_2
X_12155_ _05815_ _05885_ VGND VGND VPWR VPWR _05886_ sky130_fd_sc_hd__or2_1
XFILLER_151_874 VGND VGND VPWR VPWR sky130_fd_sc_hd__decap_4
XFILLER_123_598 VPWR VGND VPWR VGND sky130_ef_sc_hd__decap_12
X_11106_ _04732_ _04734_ _04845_ _04846_ VGND VGND VPWR VPWR _04849_ sky130_fd_sc_hd__a211o_1
XTAP_TAPCELL_ROW_9_483 VGND VPWR sky130_fd_sc_hd__tapvpwrvgnd_1
XTAP_TAPCELL_ROW_9_472 VGND VPWR sky130_fd_sc_hd__tapvpwrvgnd_1
XFILLER_1_361 VPWR VGND VPWR VGND sky130_ef_sc_hd__decap_12
Xclkbuf_leaf_88_clk clknet_3_1__leaf_clk VGND VGND VPWR VPWR clknet_leaf_88_clk sky130_fd_sc_hd__clkbuf_8
X_12086_ _05743_ _05744_ _05816_ VGND VGND VPWR VPWR _05818_ sky130_fd_sc_hd__a21o_1
X_11037_ _04779_ _04780_ VGND VGND VPWR VPWR _04781_ sky130_fd_sc_hd__and2b_1
XFILLER_37_505 VGND VGND VPWR VPWR sky130_fd_sc_hd__decap_6
XFILLER_37_516 VGND VGND VPWR VPWR sky130_fd_sc_hd__decap_6
XFILLER_92_622 VGND VGND VPWR VPWR sky130_fd_sc_hd__fill_2
XTAP_TAPCELL_ROW_88_1748 VGND VPWR sky130_fd_sc_hd__tapvpwrvgnd_1
XTAP_TAPCELL_ROW_88_1737 VGND VPWR sky130_fd_sc_hd__tapvpwrvgnd_1
XFILLER_49_376 VGND VGND VPWR VPWR sky130_fd_sc_hd__fill_2
XFILLER_37_538 VGND VGND VPWR VPWR sky130_fd_sc_hd__fill_1
X_12988_ net1543 net375 net222 VGND VGND VPWR VPWR _01071_ sky130_fd_sc_hd__mux2_1
XFILLER_52_519 VGND VGND VPWR VPWR sky130_fd_sc_hd__fill_2
X_11939_ _05592_ _05669_ _05671_ VGND VGND VPWR VPWR _05673_ sky130_fd_sc_hd__nand3_1
XTAP_TAPCELL_ROW_28_780 VGND VPWR sky130_fd_sc_hd__tapvpwrvgnd_1
XTAP_TAPCELL_ROW_28_791 VGND VPWR sky130_fd_sc_hd__tapvpwrvgnd_1
XFILLER_33_777 VGND VGND VPWR VPWR sky130_fd_sc_hd__decap_6
XTAP_TAPCELL_ROW_119_2236 VGND VPWR sky130_fd_sc_hd__tapvpwrvgnd_1
X_13609_ clknet_leaf_46_clk _00619_ VGND VGND VPWR VPWR u_interface.fifo_data\[3\]\[24\]
+ sky130_fd_sc_hd__dfxtp_1
XFILLER_20_416 VGND VGND VPWR VPWR sky130_fd_sc_hd__decap_4
Xclkbuf_leaf_12_clk clknet_3_2__leaf_clk VGND VGND VPWR VPWR clknet_leaf_12_clk sky130_fd_sc_hd__clkbuf_8
XTAP_TAPCELL_ROW_119_2247 VGND VPWR sky130_fd_sc_hd__tapvpwrvgnd_1
X_07130_ net1091 net380 net217 VGND VGND VPWR VPWR _00170_ sky130_fd_sc_hd__mux2_1
XFILLER_9_472 VGND VGND VPWR VPWR sky130_fd_sc_hd__fill_1
XTAP_TAPCELL_ROW_132_2447 VGND VPWR sky130_fd_sc_hd__tapvpwrvgnd_1
X_07061_ net1050 net360 net208 VGND VGND VPWR VPWR _00101_ sky130_fd_sc_hd__mux2_1
XFILLER_145_178 VGND VGND VPWR VPWR sky130_fd_sc_hd__decap_8
XFILLER_87_416 VPWR VGND VPWR VGND sky130_ef_sc_hd__decap_12
X_07963_ net1478 _01843_ net779 VGND VGND VPWR VPWR _00686_ sky130_fd_sc_hd__mux2_1
Xclkbuf_leaf_79_clk clknet_3_4__leaf_clk VGND VGND VPWR VPWR clknet_leaf_79_clk sky130_fd_sc_hd__clkbuf_8
X_07894_ net1267 net568 net267 VGND VGND VPWR VPWR _00655_ sky130_fd_sc_hd__mux2_1
X_09702_ _03351_ _03353_ _03456_ VGND VGND VPWR VPWR _03457_ sky130_fd_sc_hd__nor3_1
X_06914_ u_interface.u_gelu_fp32.u_synth_top.s1_x\[20\] net274 VGND VGND VPWR VPWR
+ _01452_ sky130_fd_sc_hd__xnor2_1
XTAP_TAPCELL_ROW_52_1173 VGND VPWR sky130_fd_sc_hd__tapvpwrvgnd_1
XTAP_TAPCELL_ROW_52_1162 VGND VPWR sky130_fd_sc_hd__tapvpwrvgnd_1
XTAP_TAPCELL_ROW_147_2690 VGND VPWR sky130_fd_sc_hd__tapvpwrvgnd_1
X_09633_ _03383_ _03386_ _03387_ VGND VGND VPWR VPWR _03389_ sky130_fd_sc_hd__nand3_2
X_06845_ u_interface.fifo_data\[8\]\[27\] u_interface.fifo_data\[9\]\[27\] u_interface.fifo_data\[10\]\[27\]
+ u_interface.fifo_data\[11\]\[27\] net760 net743 VGND VGND VPWR VPWR _01393_ sky130_fd_sc_hd__mux4_1
XFILLER_67_162 VGND VGND VPWR VPWR sky130_fd_sc_hd__decap_6
XFILLER_55_313 VGND VGND VPWR VPWR sky130_fd_sc_hd__decap_4
X_09564_ _02814_ _03221_ _03220_ VGND VGND VPWR VPWR _03321_ sky130_fd_sc_hd__a21o_1
XFILLER_83_655 VGND VGND VPWR VPWR sky130_fd_sc_hd__decap_6
XFILLER_82_121 VPWR VGND VPWR VGND sky130_ef_sc_hd__decap_12
XFILLER_55_335 VGND VGND VPWR VPWR sky130_fd_sc_hd__fill_1
XFILLER_130_26 VGND VGND VPWR VPWR sky130_fd_sc_hd__fill_2
X_06776_ net321 _01332_ net726 VGND VGND VPWR VPWR _01333_ sky130_fd_sc_hd__o21a_1
XFILLER_82_165 VPWR VGND VPWR VGND sky130_ef_sc_hd__decap_12
XFILLER_71_839 VGND VGND VPWR VPWR sky130_fd_sc_hd__fill_1
X_08515_ _02304_ _02305_ VGND VGND VPWR VPWR _02306_ sky130_fd_sc_hd__nand2_1
X_09495_ _03246_ _03249_ _03250_ VGND VGND VPWR VPWR _03252_ sky130_fd_sc_hd__nand3_2
XFILLER_64_891 VGND VGND VPWR VPWR sky130_fd_sc_hd__decap_4
XFILLER_24_755 VGND VGND VPWR VPWR sky130_fd_sc_hd__fill_1
X_08446_ _02181_ _02236_ VGND VGND VPWR VPWR _02237_ sky130_fd_sc_hd__nand2b_1
XFILLER_12_917 VGND VGND VPWR VPWR sky130_fd_sc_hd__fill_1
X_08377_ _02166_ _02167_ VGND VGND VPWR VPWR _02168_ sky130_fd_sc_hd__nand2_1
XFILLER_139_24 VGND VGND VPWR VPWR sky130_fd_sc_hd__decap_8
X_07328_ net1278 net574 net254 VGND VGND VPWR VPWR _00358_ sky130_fd_sc_hd__mux2_1
XFILLER_23_57 VPWR VGND VPWR VGND sky130_ef_sc_hd__decap_12
XFILLER_149_484 VGND VGND VPWR VPWR sky130_fd_sc_hd__fill_1
XFILLER_109_337 VPWR VGND VPWR VGND sky130_ef_sc_hd__decap_12
XFILLER_152_605 VGND VGND VPWR VPWR sky130_fd_sc_hd__fill_1
XFILLER_124_307 VGND VGND VPWR VPWR sky130_fd_sc_hd__fill_1
X_07259_ net1424 net578 net252 VGND VGND VPWR VPWR _00291_ sky130_fd_sc_hd__mux2_1
X_10270_ net460 net673 _04018_ _04019_ VGND VGND VPWR VPWR _04020_ sky130_fd_sc_hd__a22o_1
XFILLER_3_615 VGND VGND VPWR VPWR sky130_fd_sc_hd__fill_1
XFILLER_151_159 VGND VGND VPWR VPWR sky130_fd_sc_hd__fill_1
XFILLER_132_362 VGND VGND VPWR VPWR sky130_fd_sc_hd__fill_2
XFILLER_105_576 VPWR VGND VPWR VGND sky130_ef_sc_hd__decap_12
XFILLER_132_395 VPWR VGND VPWR VGND sky130_ef_sc_hd__decap_12
Xfanout440 net442 VGND VGND VPWR VPWR net440 sky130_fd_sc_hd__clkbuf_2
XFILLER_48_32 VGND VGND VPWR VPWR sky130_fd_sc_hd__fill_1
XTAP_TAPCELL_ROW_6_431 VGND VPWR sky130_fd_sc_hd__tapvpwrvgnd_1
Xfanout484 u_interface.u_gelu_fp32.u_synth_top.s2_dx\[8\] VGND VGND VPWR VPWR net484
+ sky130_fd_sc_hd__buf_2
Xfanout473 u_interface.u_gelu_fp32.u_synth_top.s2_dx\[11\] VGND VGND VPWR VPWR net473
+ sky130_fd_sc_hd__buf_2
Xfanout462 net463 VGND VGND VPWR VPWR net462 sky130_fd_sc_hd__buf_2
X_13960_ clknet_leaf_59_clk net1651 VGND VGND VPWR VPWR u_interface.u_gelu_fp32.u_q16_to_fp32.s2_mag\[5\]
+ sky130_fd_sc_hd__dfxtp_1
Xfanout451 u_interface.u_gelu_fp32.u_synth_top.s2_dx\[17\] VGND VGND VPWR VPWR net451
+ sky130_fd_sc_hd__clkbuf_2
X_12911_ _01100_ _01535_ VGND VGND VPWR VPWR _06439_ sky130_fd_sc_hd__or2_2
Xfanout495 u_interface.u_gelu_fp32.u_synth_top.s2_dx\[6\] VGND VGND VPWR VPWR net495
+ sky130_fd_sc_hd__clkbuf_2
XFILLER_101_771 VGND VGND VPWR VPWR sky130_fd_sc_hd__decap_4
XFILLER_47_847 VGND VGND VPWR VPWR sky130_fd_sc_hd__fill_1
XFILLER_100_281 VGND VGND VPWR VPWR sky130_fd_sc_hd__decap_6
XFILLER_73_132 VGND VGND VPWR VPWR sky130_fd_sc_hd__fill_2
X_13891_ clknet_leaf_90_clk _00027_ VGND VGND VPWR VPWR u_interface.u_gelu_fp32.u_synth_top.s2_dx\[27\]
+ sky130_fd_sc_hd__dfxtp_1
XFILLER_34_508 VGND VGND VPWR VPWR sky130_fd_sc_hd__decap_4
X_12842_ net61 net58 net63 net62 VGND VGND VPWR VPWR _06424_ sky130_fd_sc_hd__or4_1
XFILLER_34_519 VGND VGND VPWR VPWR sky130_fd_sc_hd__decap_4
XTAP_TAPCELL_ROW_83_1656 VGND VPWR sky130_fd_sc_hd__tapvpwrvgnd_1
X_12773_ u_interface.u_gelu_fp32.u_q16_to_fp32.s3_norm_mag\[14\] _01779_ u_interface.u_gelu_fp32.u_q16_to_fp32.s3_norm_mag\[15\]
+ VGND VGND VPWR VPWR _06403_ sky130_fd_sc_hd__a21o_1
XFILLER_61_349 VPWR VGND VPWR VGND sky130_ef_sc_hd__decap_12
XFILLER_14_210 VPWR VGND VPWR VGND sky130_ef_sc_hd__decap_12
XTAP_TAPCELL_ROW_83_1667 VGND VPWR sky130_fd_sc_hd__tapvpwrvgnd_1
XFILLER_9_15 VPWR VGND VPWR VGND sky130_ef_sc_hd__decap_12
XFILLER_15_777 VGND VGND VPWR VPWR sky130_fd_sc_hd__decap_6
X_11724_ _05345_ _05379_ _05378_ VGND VGND VPWR VPWR _05461_ sky130_fd_sc_hd__a21oi_1
X_11655_ _05216_ _05299_ _05298_ VGND VGND VPWR VPWR _05393_ sky130_fd_sc_hd__a21oi_1
XFILLER_14_276 VGND VGND VPWR VPWR sky130_fd_sc_hd__fill_1
XFILLER_30_725 VPWR VGND VPWR VGND sky130_ef_sc_hd__decap_12
XFILLER_80_74 VGND VGND VPWR VPWR sky130_fd_sc_hd__fill_2
XFILLER_30_769 VPWR VGND VPWR VGND sky130_ef_sc_hd__decap_12
XFILLER_155_421 VGND VGND VPWR VPWR sky130_fd_sc_hd__fill_2
XFILLER_80_85 VGND VGND VPWR VPWR sky130_fd_sc_hd__fill_2
X_10606_ net661 net449 _04261_ _04260_ VGND VGND VPWR VPWR _04353_ sky130_fd_sc_hd__a31o_1
X_11586_ _05224_ _05322_ _05323_ VGND VGND VPWR VPWR _05324_ sky130_fd_sc_hd__o21ai_1
XFILLER_155_454 VGND VGND VPWR VPWR sky130_fd_sc_hd__decap_4
XFILLER_116_808 VGND VGND VPWR VPWR sky130_fd_sc_hd__decap_4
X_10537_ _04283_ _04284_ VGND VGND VPWR VPWR _04285_ sky130_fd_sc_hd__nor2_1
XFILLER_10_493 VPWR VGND VPWR VGND sky130_ef_sc_hd__decap_12
X_13325_ clknet_leaf_72_clk _00335_ VGND VGND VPWR VPWR u_interface.fifo_data\[10\]\[2\]
+ sky130_fd_sc_hd__dfxtp_1
X_13256_ clknet_leaf_31_clk _00266_ VGND VGND VPWR VPWR _00002_ sky130_fd_sc_hd__dfxtp_1
XFILLER_142_126 VPWR VGND VPWR VGND sky130_ef_sc_hd__decap_12
XTAP_TAPCELL_ROW_114_2166 VGND VPWR sky130_fd_sc_hd__tapvpwrvgnd_1
XTAP_TAPCELL_ROW_114_2155 VGND VPWR sky130_fd_sc_hd__tapvpwrvgnd_1
XFILLER_109_871 VGND VGND VPWR VPWR sky130_fd_sc_hd__decap_8
X_10468_ _04203_ _04213_ _04214_ VGND VGND VPWR VPWR _04216_ sky130_fd_sc_hd__nand3_1
XFILLER_6_475 VGND VGND VPWR VPWR sky130_fd_sc_hd__fill_1
XPHY_EDGE_ROW_23_Left_179 VGND VGND VPWR VPWR sky130_fd_sc_hd__decap_3
X_12207_ _05931_ _05936_ _05937_ VGND VGND VPWR VPWR _00836_ sky130_fd_sc_hd__a21oi_1
X_13187_ clknet_leaf_45_clk _00197_ VGND VGND VPWR VPWR u_interface.fifo_data\[9\]\[29\]
+ sky130_fd_sc_hd__dfxtp_1
X_10399_ _04035_ _04038_ VGND VGND VPWR VPWR _04148_ sky130_fd_sc_hd__nor2_1
XFILLER_69_405 VGND VGND VPWR VPWR sky130_fd_sc_hd__decap_6
XFILLER_111_535 VPWR VGND VPWR VGND sky130_ef_sc_hd__decap_12
XFILLER_69_449 VPWR VGND VPWR VGND sky130_ef_sc_hd__decap_12
XFILLER_2_681 VPWR VGND VPWR VGND sky130_ef_sc_hd__decap_12
X_12138_ _05806_ _05809_ net178 VGND VGND VPWR VPWR _05869_ sky130_fd_sc_hd__o21a_1
Xclkbuf_leaf_1_clk clknet_3_0__leaf_clk VGND VGND VPWR VPWR clknet_leaf_1_clk sky130_fd_sc_hd__clkbuf_8
X_12069_ net178 _05730_ _05733_ VGND VGND VPWR VPWR _05801_ sky130_fd_sc_hd__nor3_1
XFILLER_64_121 VGND VGND VPWR VPWR sky130_fd_sc_hd__fill_1
X_06630_ net730 _01204_ VGND VGND VPWR VPWR _01205_ sky130_fd_sc_hd__or2_1
XFILLER_37_335 VGND VGND VPWR VPWR sky130_fd_sc_hd__fill_1
XFILLER_65_688 VGND VGND VPWR VPWR sky130_fd_sc_hd__fill_1
XFILLER_53_839 VGND VGND VPWR VPWR sky130_fd_sc_hd__fill_1
X_06561_ u_interface.u_gelu_fp32.s1_data\[14\] net287 _01146_ VGND VGND VPWR VPWR
+ _01155_ sky130_fd_sc_hd__nand3_1
XPHY_EDGE_ROW_32_Left_188 VGND VGND VPWR VPWR sky130_fd_sc_hd__decap_3
X_09280_ _02940_ _02941_ VGND VGND VPWR VPWR _03039_ sky130_fd_sc_hd__nand2_1
X_08300_ net531 _02107_ net1588 VGND VGND VPWR VPWR _02108_ sky130_fd_sc_hd__a21oi_1
XFILLER_61_850 VGND VGND VPWR VPWR sky130_fd_sc_hd__decap_3
XTAP_TAPCELL_ROW_23_709 VGND VPWR sky130_fd_sc_hd__tapvpwrvgnd_1
XFILLER_33_541 VGND VGND VPWR VPWR sky130_fd_sc_hd__decap_3
XFILLER_33_552 VGND VGND VPWR VPWR sky130_fd_sc_hd__decap_8
X_08231_ _02048_ _02052_ VGND VGND VPWR VPWR _02059_ sky130_fd_sc_hd__nand2_1
XFILLER_61_894 VGND VGND VPWR VPWR sky130_fd_sc_hd__fill_2
XFILLER_61_883 VGND VGND VPWR VPWR sky130_fd_sc_hd__fill_2
XFILLER_20_213 VPWR VGND VPWR VGND sky130_ef_sc_hd__decap_12
XFILLER_33_585 VPWR VGND VPWR VGND sky130_ef_sc_hd__decap_12
XFILLER_147_911 VGND VGND VPWR VPWR sky130_fd_sc_hd__fill_2
XFILLER_146_432 VGND VGND VPWR VPWR sky130_fd_sc_hd__fill_1
XFILLER_146_421 VGND VGND VPWR VPWR sky130_fd_sc_hd__decap_3
X_08162_ net167 _02000_ net162 VGND VGND VPWR VPWR _02001_ sky130_fd_sc_hd__a21oi_1
X_07113_ net1180 net325 net271 VGND VGND VPWR VPWR _00153_ sky130_fd_sc_hd__mux2_1
X_08093_ _01936_ _01937_ VGND VGND VPWR VPWR _01943_ sky130_fd_sc_hd__and2_1
XFILLER_134_649 VGND VGND VPWR VPWR sky130_fd_sc_hd__decap_4
XFILLER_106_307 VGND VGND VPWR VPWR sky130_fd_sc_hd__fill_1
X_07044_ net1216 net570 net270 VGND VGND VPWR VPWR _00084_ sky130_fd_sc_hd__mux2_1
Xclkload50 clknet_leaf_84_clk VGND VGND VPWR VPWR clkload50/X sky130_fd_sc_hd__clkbuf_4
Xclkload61 clknet_leaf_72_clk VGND VGND VPWR VPWR clkload61/X sky130_fd_sc_hd__clkbuf_8
XPHY_EDGE_ROW_41_Left_197 VGND VGND VPWR VPWR sky130_fd_sc_hd__decap_3
XFILLER_133_137 VGND VGND VPWR VPWR sky130_fd_sc_hd__decap_3
Xclkload72 clknet_leaf_53_clk VGND VGND VPWR VPWR clkload72/X sky130_fd_sc_hd__clkbuf_4
Xclkload83 clknet_leaf_48_clk VGND VGND VPWR VPWR clkload83/Y sky130_fd_sc_hd__inv_6
XTAP_TAPCELL_ROW_54_1202 VGND VPWR sky130_fd_sc_hd__tapvpwrvgnd_1
XFILLER_114_362 VGND VGND VPWR VPWR sky130_fd_sc_hd__fill_2
XFILLER_0_629 VPWR VGND VPWR VGND sky130_ef_sc_hd__decap_12
X_08995_ _02735_ _02752_ _02598_ _02711_ VGND VGND VPWR VPWR _02754_ sky130_fd_sc_hd__o211ai_2
XFILLER_130_855 VGND VGND VPWR VPWR sky130_fd_sc_hd__decap_4
XFILLER_102_524 VGND VGND VPWR VPWR sky130_fd_sc_hd__decap_8
XFILLER_88_736 VGND VGND VPWR VPWR sky130_fd_sc_hd__decap_3
X_07946_ net542 net814 VGND VGND VPWR VPWR _01835_ sky130_fd_sc_hd__and2_1
XFILLER_102_557 VGND VGND VPWR VPWR sky130_fd_sc_hd__decap_3
XFILLER_87_279 VGND VGND VPWR VPWR sky130_fd_sc_hd__fill_1
XTAP_TAPCELL_ROW_145_2649 VGND VPWR sky130_fd_sc_hd__tapvpwrvgnd_1
XFILLER_96_780 VGND VGND VPWR VPWR sky130_fd_sc_hd__fill_2
X_07877_ net1092 net363 net268 VGND VGND VPWR VPWR _00638_ sky130_fd_sc_hd__mux2_1
X_06828_ _01373_ _01375_ _01378_ net318 VGND VGND VPWR VPWR net125 sky130_fd_sc_hd__a22o_1
X_09616_ _03368_ _03369_ _03370_ VGND VGND VPWR VPWR _03372_ sky130_fd_sc_hd__nor3_1
XFILLER_71_614 VGND VGND VPWR VPWR sky130_fd_sc_hd__fill_2
XFILLER_16_519 VPWR VGND VPWR VGND sky130_ef_sc_hd__decap_12
XFILLER_43_305 VGND VGND VPWR VPWR sky130_fd_sc_hd__decap_4
X_06759_ net735 _01317_ VGND VGND VPWR VPWR _01318_ sky130_fd_sc_hd__or2_1
X_09547_ _03271_ _03302_ VGND VGND VPWR VPWR _03304_ sky130_fd_sc_hd__xnor2_1
XFILLER_43_349 VGND VGND VPWR VPWR sky130_fd_sc_hd__decap_8
XFILLER_71_669 VGND VGND VPWR VPWR sky130_fd_sc_hd__decap_3
XFILLER_70_157 VGND VGND VPWR VPWR sky130_fd_sc_hd__fill_1
XFILLER_24_541 VGND VGND VPWR VPWR sky130_fd_sc_hd__fill_2
X_09478_ _03231_ _03234_ VGND VGND VPWR VPWR _03235_ sky130_fd_sc_hd__xnor2_1
XTAP_TAPCELL_ROW_65_1375 VGND VPWR sky130_fd_sc_hd__tapvpwrvgnd_1
XFILLER_12_725 VPWR VGND VPWR VGND sky130_ef_sc_hd__decap_12
X_08429_ _02205_ _02206_ _02219_ VGND VGND VPWR VPWR _02220_ sky130_fd_sc_hd__and3_1
XFILLER_12_769 VPWR VGND VPWR VGND sky130_ef_sc_hd__decap_12
Xclkload0 clknet_3_0__leaf_clk VGND VGND VPWR VPWR clkload0/Y sky130_fd_sc_hd__inv_16
XFILLER_7_217 VGND VGND VPWR VPWR sky130_fd_sc_hd__decap_6
X_11440_ net617 net392 _05178_ VGND VGND VPWR VPWR _05180_ sky130_fd_sc_hd__and3_1
X_11371_ _05110_ _05111_ VGND VGND VPWR VPWR _05112_ sky130_fd_sc_hd__nor2_1
X_14090_ clknet_leaf_16_clk net1246 VGND VGND VPWR VPWR u_interface.u_gelu_fp32.u_fp32_to_q16.s2_norm_mag\[27\]
+ sky130_fd_sc_hd__dfxtp_1
XFILLER_137_487 VPWR VGND VPWR VGND sky130_ef_sc_hd__decap_12
X_10322_ _03884_ _03886_ _04069_ _04070_ VGND VGND VPWR VPWR _04072_ sky130_fd_sc_hd__a211o_1
X_13110_ clknet_leaf_75_clk _00120_ VGND VGND VPWR VPWR u_interface.fifo_data\[15\]\[31\]
+ sky130_fd_sc_hd__dfxtp_1
X_13041_ clknet_leaf_40_clk _00051_ VGND VGND VPWR VPWR u_interface.fifo_tuser\[4\]
+ sky130_fd_sc_hd__dfxtp_1
XFILLER_79_725 VGND VGND VPWR VPWR sky130_fd_sc_hd__decap_3
XFILLER_79_714 VGND VGND VPWR VPWR sky130_fd_sc_hd__fill_2
X_10253_ _04001_ _04002_ VGND VGND VPWR VPWR _04003_ sky130_fd_sc_hd__and2b_1
XFILLER_132_181 VGND VGND VPWR VPWR sky130_fd_sc_hd__fill_1
X_10184_ _03931_ _03934_ VGND VGND VPWR VPWR _03935_ sky130_fd_sc_hd__xnor2_1
XFILLER_79_769 VGND VGND VPWR VPWR sky130_fd_sc_hd__decap_6
XFILLER_66_419 VGND VGND VPWR VPWR sky130_fd_sc_hd__fill_1
Xfanout292 net293 VGND VGND VPWR VPWR net292 sky130_fd_sc_hd__dlymetal6s2s_1
Xfanout270 _01503_ VGND VGND VPWR VPWR net270 sky130_fd_sc_hd__buf_2
Xfanout281 _01696_ VGND VGND VPWR VPWR net281 sky130_fd_sc_hd__buf_2
XFILLER_59_460 VGND VGND VPWR VPWR sky130_fd_sc_hd__fill_1
XFILLER_47_600 VGND VGND VPWR VPWR sky130_fd_sc_hd__decap_8
X_13943_ clknet_leaf_5_clk _00010_ VGND VGND VPWR VPWR u_interface.u_gelu_fp32.u_synth_top.s1_hits\[15\]
+ sky130_fd_sc_hd__dfxtp_1
X_13874_ clknet_leaf_22_clk net879 VGND VGND VPWR VPWR u_interface.u_gelu_fp32.u_synth_top.s2_dx\[10\]
+ sky130_fd_sc_hd__dfxtp_1
XFILLER_75_96 VGND VGND VPWR VPWR sky130_fd_sc_hd__decap_3
XFILLER_75_74 VGND VGND VPWR VPWR sky130_fd_sc_hd__fill_2
XFILLER_74_452 VPWR VGND VPWR VGND sky130_ef_sc_hd__decap_12
XFILLER_35_839 VGND VGND VPWR VPWR sky130_fd_sc_hd__fill_1
X_12825_ net777 net84 VGND VGND VPWR VPWR _00983_ sky130_fd_sc_hd__and2_1
XFILLER_61_113 VGND VGND VPWR VPWR sky130_fd_sc_hd__decap_3
XFILLER_15_541 VPWR VGND VPWR VGND sky130_ef_sc_hd__decap_12
XFILLER_27_390 VGND VGND VPWR VPWR sky130_fd_sc_hd__fill_2
X_12756_ net1201 u_interface.u_gelu_fp32.u_q16_to_fp32.s3_sign net797 VGND VGND VPWR
+ VPWR _00938_ sky130_fd_sc_hd__mux2_1
XFILLER_15_585 VPWR VGND VPWR VGND sky130_ef_sc_hd__decap_12
XFILLER_30_500 VGND VGND VPWR VPWR sky130_fd_sc_hd__fill_1
XFILLER_147_207 VGND VGND VPWR VPWR sky130_fd_sc_hd__fill_1
X_12687_ net803 u_interface.u_gelu_fp32.u_q16_to_fp32.s3_norm_mag\[17\] _01703_ net288
+ VGND VGND VPWR VPWR _06348_ sky130_fd_sc_hd__a22o_1
X_11707_ net650 net394 VGND VGND VPWR VPWR _05444_ sky130_fd_sc_hd__nand2_1
XFILLER_128_421 VPWR VGND VPWR VGND sky130_ef_sc_hd__decap_12
X_11638_ _05357_ _05375_ VGND VGND VPWR VPWR _05376_ sky130_fd_sc_hd__xor2_1
XFILLER_155_251 VGND VGND VPWR VPWR sky130_fd_sc_hd__fill_1
Xhold707 u_interface.fifo_tuser\[7\] VGND VGND VPWR VPWR net1572 sky130_fd_sc_hd__dlygate4sd3_1
XFILLER_128_498 VPWR VGND VPWR VGND sky130_ef_sc_hd__decap_12
Xhold718 u_interface.u_gelu_fp32.u_fp32_to_q16.s3_frac\[8\] VGND VGND VPWR VPWR net1583
+ sky130_fd_sc_hd__dlygate4sd3_1
X_13308_ clknet_leaf_43_clk _00318_ VGND VGND VPWR VPWR u_interface.fifo_data\[8\]\[17\]
+ sky130_fd_sc_hd__dfxtp_1
XTAP_TAPCELL_ROW_96_1869 VGND VPWR sky130_fd_sc_hd__tapvpwrvgnd_1
X_11569_ _05116_ _05213_ VGND VGND VPWR VPWR _05308_ sky130_fd_sc_hd__or2_1
Xhold729 u_interface.u_gelu_fp32.u_fp32_to_q16.s1_mant\[7\] VGND VGND VPWR VPWR net1594
+ sky130_fd_sc_hd__dlygate4sd3_1
XFILLER_143_446 VGND VGND VPWR VPWR sky130_fd_sc_hd__fill_2
XFILLER_115_137 VGND VGND VPWR VPWR sky130_fd_sc_hd__decap_4
XFILLER_124_660 VGND VGND VPWR VPWR sky130_fd_sc_hd__fill_1
X_13239_ clknet_leaf_26_clk _00249_ VGND VGND VPWR VPWR u_interface.fifo_data\[11\]\[17\]
+ sky130_fd_sc_hd__dfxtp_1
XFILLER_41_3 VPWR VGND VPWR VGND sky130_ef_sc_hd__decap_12
XFILLER_69_213 VGND VGND VPWR VPWR sky130_fd_sc_hd__decap_4
X_08780_ net663 net498 _02537_ _02538_ VGND VGND VPWR VPWR _02539_ sky130_fd_sc_hd__a22o_1
X_07800_ net1345 net563 net233 VGND VGND VPWR VPWR _00561_ sky130_fd_sc_hd__mux2_1
XPHY_EDGE_ROW_127_Right_127 VGND VGND VPWR VPWR sky130_fd_sc_hd__decap_3
X_07731_ u_interface.u_gelu_fp32.u_q16_to_fp32.s3_norm_mag\[9\] u_interface.u_gelu_fp32.u_q16_to_fp32.s3_norm_mag\[7\]
+ u_interface.u_gelu_fp32.u_q16_to_fp32.s3_norm_mag\[8\] VGND VGND VPWR VPWR _01775_
+ sky130_fd_sc_hd__and3_1
XTAP_TAPCELL_ROW_127_2368 VGND VPWR sky130_fd_sc_hd__tapvpwrvgnd_1
X_07662_ net807 net1647 net299 _01744_ VGND VGND VPWR VPWR _00483_ sky130_fd_sc_hd__a22o_1
XFILLER_53_625 VGND VGND VPWR VPWR sky130_fd_sc_hd__decap_6
XFILLER_53_614 VGND VGND VPWR VPWR sky130_fd_sc_hd__fill_2
X_06613_ u_interface.fifo_tuser\[8\] u_interface.fifo_tuser\[9\] u_interface.fifo_tuser\[10\]
+ u_interface.fifo_tuser\[11\] net769 net752 VGND VGND VPWR VPWR _01190_ sky130_fd_sc_hd__mux4_1
X_07593_ net309 _01671_ VGND VGND VPWR VPWR _01692_ sky130_fd_sc_hd__and2_1
X_09401_ _02635_ _03158_ VGND VGND VPWR VPWR _03159_ sky130_fd_sc_hd__nand2_1
XFILLER_65_485 VGND VGND VPWR VPWR sky130_fd_sc_hd__decap_6
XFILLER_53_647 VGND VGND VPWR VPWR sky130_fd_sc_hd__decap_4
XFILLER_52_124 VGND VGND VPWR VPWR sky130_fd_sc_hd__decap_6
XFILLER_1_93 VPWR VGND VPWR VGND sky130_ef_sc_hd__decap_12
X_09332_ _03074_ _03084_ _03085_ VGND VGND VPWR VPWR _03091_ sky130_fd_sc_hd__a21bo_1
XTAP_TAPCELL_ROW_140_2579 VGND VPWR sky130_fd_sc_hd__tapvpwrvgnd_1
XTAP_TAPCELL_ROW_140_2568 VGND VPWR sky130_fd_sc_hd__tapvpwrvgnd_1
X_06544_ net537 _01138_ VGND VGND VPWR VPWR _01141_ sky130_fd_sc_hd__nand2b_1
XFILLER_80_477 VGND VGND VPWR VPWR sky130_fd_sc_hd__fill_2
XFILLER_80_455 VPWR VGND VPWR VGND sky130_ef_sc_hd__decap_12
XFILLER_34_861 VGND VGND VPWR VPWR sky130_fd_sc_hd__decap_6
XTAP_TAPCELL_ROW_47_1083 VGND VPWR sky130_fd_sc_hd__tapvpwrvgnd_1
X_09263_ _02971_ _03013_ _03018_ VGND VGND VPWR VPWR _03022_ sky130_fd_sc_hd__a21o_1
XTAP_TAPCELL_ROW_47_1094 VGND VPWR sky130_fd_sc_hd__tapvpwrvgnd_1
XTAP_TAPCELL_ROW_16_591 VGND VPWR sky130_fd_sc_hd__tapvpwrvgnd_1
XFILLER_21_533 VGND VGND VPWR VPWR sky130_fd_sc_hd__decap_3
XFILLER_21_555 VGND VGND VPWR VPWR sky130_fd_sc_hd__decap_4
X_09194_ _02947_ _02951_ _02952_ VGND VGND VPWR VPWR _02953_ sky130_fd_sc_hd__nor3_1
XFILLER_138_218 VGND VGND VPWR VPWR sky130_fd_sc_hd__decap_8
X_08214_ _02042_ _02044_ net290 VGND VGND VPWR VPWR _02045_ sky130_fd_sc_hd__a21oi_1
XFILLER_21_577 VPWR VGND VPWR VGND sky130_ef_sc_hd__decap_12
XFILLER_135_903 VGND VGND VPWR VPWR sky130_fd_sc_hd__fill_1
X_08145_ u_interface.u_gelu_fp32.u_fp32_to_q16.s3_mag\[15\] u_interface.u_gelu_fp32.u_fp32_to_q16.s3_mag\[14\]
+ _01882_ u_interface.u_gelu_fp32.u_fp32_to_q16.s3_mag\[16\] VGND VGND VPWR VPWR _01986_
+ sky130_fd_sc_hd__a31o_1
XTAP_TAPCELL_ROW_60_1294 VGND VPWR sky130_fd_sc_hd__tapvpwrvgnd_1
XFILLER_112_9 VGND VGND VPWR VPWR sky130_fd_sc_hd__fill_1
XFILLER_4_209 VPWR VGND VPWR VGND sky130_ef_sc_hd__decap_12
X_08076_ net314 _01927_ _01926_ VGND VGND VPWR VPWR _01929_ sky130_fd_sc_hd__o21ai_1
X_07027_ net1287 net364 net271 VGND VGND VPWR VPWR _00067_ sky130_fd_sc_hd__mux2_1
XFILLER_134_468 VGND VGND VPWR VPWR sky130_fd_sc_hd__decap_8
XFILLER_115_671 VGND VGND VPWR VPWR sky130_fd_sc_hd__fill_1
XFILLER_102_321 VPWR VGND VPWR VGND sky130_ef_sc_hd__decap_12
XFILLER_88_533 VGND VGND VPWR VPWR sky130_fd_sc_hd__decap_4
XFILLER_130_663 VGND VGND VPWR VPWR sky130_fd_sc_hd__decap_8
Xhold12 u_interface.u_gelu_fp32.u_synth_top.s1_x\[9\] VGND VGND VPWR VPWR net877 sky130_fd_sc_hd__dlygate4sd3_1
Xhold23 u_interface.u_gelu_fp32.s1_data\[10\] VGND VGND VPWR VPWR net888 sky130_fd_sc_hd__dlygate4sd3_1
XFILLER_103_877 VGND VGND VPWR VPWR sky130_fd_sc_hd__fill_2
XFILLER_88_577 VGND VGND VPWR VPWR sky130_fd_sc_hd__decap_3
Xhold45 u_interface.u_gelu_fp32.u_synth_top.v_pipe\[0\] VGND VGND VPWR VPWR net910
+ sky130_fd_sc_hd__dlygate4sd3_1
X_08978_ net670 net679 net516 net520 VGND VGND VPWR VPWR _02737_ sky130_fd_sc_hd__and4_1
Xhold56 u_interface.u_gelu_fp32.u_synth_top.v_pipe\[2\] VGND VGND VPWR VPWR net921
+ sky130_fd_sc_hd__dlygate4sd3_1
Xhold34 u_interface.u_gelu_fp32.s1_data\[26\] VGND VGND VPWR VPWR net899 sky130_fd_sc_hd__dlygate4sd3_1
X_07929_ _01817_ _01818_ _01821_ _01822_ VGND VGND VPWR VPWR _01823_ sky130_fd_sc_hd__or4_1
Xhold78 u_interface.u_gelu_fp32.u_fp32_to_q16.s1_valid VGND VGND VPWR VPWR net943
+ sky130_fd_sc_hd__dlygate4sd3_1
Xhold67 u_interface.u_gelu_fp32.u_fp32_to_q16.s2_valid VGND VGND VPWR VPWR net932
+ sky130_fd_sc_hd__dlygate4sd3_1
Xhold89 u_interface.u_gelu_fp32.s1_data\[16\] VGND VGND VPWR VPWR net954 sky130_fd_sc_hd__dlygate4sd3_1
XFILLER_83_260 VGND VGND VPWR VPWR sky130_fd_sc_hd__fill_1
XTAP_TAPCELL_ROW_67_1415 VGND VPWR sky130_fd_sc_hd__tapvpwrvgnd_1
XTAP_TAPCELL_ROW_67_1404 VGND VPWR sky130_fd_sc_hd__tapvpwrvgnd_1
X_10940_ _04561_ _04563_ VGND VGND VPWR VPWR _04684_ sky130_fd_sc_hd__nand2_1
XFILLER_17_839 VGND VGND VPWR VPWR sky130_fd_sc_hd__fill_1
XFILLER_28_165 VGND VGND VPWR VPWR sky130_fd_sc_hd__decap_8
XFILLER_83_293 VPWR VGND VPWR VGND sky130_ef_sc_hd__decap_12
XFILLER_45_55 VGND VGND VPWR VPWR sky130_fd_sc_hd__fill_1
XFILLER_43_113 VGND VGND VPWR VPWR sky130_fd_sc_hd__fill_2
X_12610_ _06312_ VGND VGND VPWR VPWR _06313_ sky130_fd_sc_hd__inv_2
XFILLER_71_466 VGND VGND VPWR VPWR sky130_fd_sc_hd__fill_1
X_10871_ _04597_ _04613_ _04614_ VGND VGND VPWR VPWR _04616_ sky130_fd_sc_hd__nand3_2
XFILLER_44_669 VGND VGND VPWR VPWR sky130_fd_sc_hd__fill_1
XFILLER_43_146 VGND VGND VPWR VPWR sky130_fd_sc_hd__fill_1
XTAP_TAPCELL_ROW_80_1615 VGND VPWR sky130_fd_sc_hd__tapvpwrvgnd_1
XFILLER_71_499 VGND VGND VPWR VPWR sky130_fd_sc_hd__decap_4
X_13590_ clknet_leaf_70_clk _00600_ VGND VGND VPWR VPWR u_interface.fifo_data\[3\]\[5\]
+ sky130_fd_sc_hd__dfxtp_1
X_12541_ _06263_ _06264_ VGND VGND VPWR VPWR _06265_ sky130_fd_sc_hd__xnor2_1
XFILLER_12_533 VPWR VGND VPWR VGND sky130_ef_sc_hd__decap_12
XFILLER_61_65 VGND VGND VPWR VPWR sky130_fd_sc_hd__fill_2
XFILLER_61_54 VGND VGND VPWR VPWR sky130_fd_sc_hd__fill_2
X_12472_ _06135_ _06197_ VGND VGND VPWR VPWR _06198_ sky130_fd_sc_hd__nand2_1
XFILLER_61_98 VGND VGND VPWR VPWR sky130_fd_sc_hd__decap_4
X_11423_ _05077_ _05079_ _05078_ VGND VGND VPWR VPWR _05163_ sky130_fd_sc_hd__o21bai_1
XFILLER_125_402 VGND VGND VPWR VPWR sky130_fd_sc_hd__fill_2
XANTENNA_9 net2 VGND VGND VPWR VPWR sky130_fd_sc_hd__diode_2
XFILLER_6_27 VGND VGND VPWR VPWR sky130_fd_sc_hd__fill_1
XFILLER_125_457 VGND VGND VPWR VPWR sky130_fd_sc_hd__fill_1
XTAP_TAPCELL_ROW_111_2114 VGND VPWR sky130_fd_sc_hd__tapvpwrvgnd_1
XTAP_TAPCELL_ROW_78_1588 VGND VPWR sky130_fd_sc_hd__tapvpwrvgnd_1
XTAP_TAPCELL_ROW_78_1577 VGND VPWR sky130_fd_sc_hd__tapvpwrvgnd_1
X_14142_ clknet_leaf_73_clk _01068_ VGND VGND VPWR VPWR u_interface.fifo_data\[1\]\[2\]
+ sky130_fd_sc_hd__dfxtp_1
X_11354_ _04975_ _04976_ _04995_ _04994_ _04993_ VGND VGND VPWR VPWR _05095_ sky130_fd_sc_hd__o32a_1
X_14073_ clknet_leaf_15_clk net1135 VGND VGND VPWR VPWR u_interface.u_gelu_fp32.u_fp32_to_q16.s2_norm_mag\[10\]
+ sky130_fd_sc_hd__dfxtp_1
X_10305_ _04052_ _04053_ VGND VGND VPWR VPWR _04055_ sky130_fd_sc_hd__xnor2_1
X_11285_ _04942_ _04944_ net180 VGND VGND VPWR VPWR _05026_ sky130_fd_sc_hd__o21a_1
X_10236_ _03978_ _03983_ _03984_ VGND VGND VPWR VPWR _03986_ sky130_fd_sc_hd__nand3_1
X_13024_ _06268_ _06274_ net161 net160 net151 VGND VGND VPWR VPWR _00851_ sky130_fd_sc_hd__o2111a_1
XFILLER_121_641 VGND VGND VPWR VPWR sky130_fd_sc_hd__fill_2
XTAP_TAPCELL_ROW_91_1799 VGND VPWR sky130_fd_sc_hd__tapvpwrvgnd_1
XTAP_TAPCELL_ROW_91_1788 VGND VPWR sky130_fd_sc_hd__tapvpwrvgnd_1
X_10167_ _03903_ _03915_ _03916_ VGND VGND VPWR VPWR _03918_ sky130_fd_sc_hd__or3_1
X_10098_ _03848_ _03849_ _03753_ VGND VGND VPWR VPWR _03850_ sky130_fd_sc_hd__o21ai_1
XFILLER_47_441 VGND VGND VPWR VPWR sky130_fd_sc_hd__fill_2
XTAP_TAPCELL_ROW_109_2087 VGND VPWR sky130_fd_sc_hd__tapvpwrvgnd_1
XTAP_TAPCELL_ROW_109_2076 VGND VPWR sky130_fd_sc_hd__tapvpwrvgnd_1
X_13926_ clknet_leaf_6_clk net904 VGND VGND VPWR VPWR u_interface.u_gelu_fp32.u_synth_top.s1_x\[30\]
+ sky130_fd_sc_hd__dfxtp_1
XFILLER_81_208 VPWR VGND VPWR VGND sky130_ef_sc_hd__decap_12
XFILLER_47_485 VGND VGND VPWR VPWR sky130_fd_sc_hd__fill_2
XFILLER_90_753 VGND VGND VPWR VPWR sky130_fd_sc_hd__decap_3
X_13857_ clknet_leaf_88_clk _00867_ VGND VGND VPWR VPWR u_interface.u_gelu_fp32.u_synth_top.s3_b\[13\]
+ sky130_fd_sc_hd__dfxtp_1
XFILLER_62_466 VGND VGND VPWR VPWR sky130_fd_sc_hd__decap_8
XFILLER_62_444 VGND VGND VPWR VPWR sky130_fd_sc_hd__decap_3
XFILLER_16_861 VGND VGND VPWR VPWR sky130_fd_sc_hd__decap_6
XFILLER_23_809 VPWR VGND VPWR VGND sky130_ef_sc_hd__decap_12
X_12808_ net776 net96 VGND VGND VPWR VPWR _00966_ sky130_fd_sc_hd__and2_1
XTAP_TAPCELL_ROW_122_2287 VGND VPWR sky130_fd_sc_hd__tapvpwrvgnd_1
XFILLER_62_477 VGND VGND VPWR VPWR sky130_fd_sc_hd__decap_3
X_13788_ clknet_leaf_81_clk _00798_ VGND VGND VPWR VPWR u_interface.u_gelu_fp32.s2_data\[22\]
+ sky130_fd_sc_hd__dfxtp_1
XPHY_EDGE_ROW_106_Left_262 VGND VGND VPWR VPWR sky130_fd_sc_hd__decap_3
X_12739_ u_interface.u_gelu_fp32.u_q16_to_fp32.s2_mag\[29\] u_interface.u_gelu_fp32.u_q16_to_fp32.s2_mag\[28\]
+ u_interface.u_gelu_fp32.u_q16_to_fp32.s2_mag\[27\] u_interface.u_gelu_fp32.u_q16_to_fp32.s2_mag\[26\]
+ net336 net332 VGND VGND VPWR VPWR _06388_ sky130_fd_sc_hd__mux4_1
XFILLER_31_853 VPWR VGND VPWR VGND sky130_ef_sc_hd__decap_12
XTAP_TAPCELL_ROW_33_859 VGND VPWR sky130_fd_sc_hd__tapvpwrvgnd_1
XTAP_TAPCELL_ROW_98_1909 VGND VPWR sky130_fd_sc_hd__tapvpwrvgnd_1
XFILLER_89_3 VGND VGND VPWR VPWR sky130_fd_sc_hd__decap_8
XTAP_TAPCELL_ROW_13_550 VGND VPWR sky130_fd_sc_hd__tapvpwrvgnd_1
XFILLER_30_363 VGND VGND VPWR VPWR sky130_fd_sc_hd__fill_1
XFILLER_31_897 VPWR VGND VPWR VGND sky130_ef_sc_hd__decap_12
XFILLER_129_774 VGND VGND VPWR VPWR sky130_fd_sc_hd__decap_3
XFILLER_116_413 VGND VGND VPWR VPWR sky130_fd_sc_hd__decap_3
XFILLER_144_755 VGND VGND VPWR VPWR sky130_fd_sc_hd__fill_1
Xhold526 u_interface.fifo_data\[8\]\[30\] VGND VGND VPWR VPWR net1391 sky130_fd_sc_hd__dlygate4sd3_1
Xhold515 u_interface.fifo_data\[0\]\[0\] VGND VGND VPWR VPWR net1380 sky130_fd_sc_hd__dlygate4sd3_1
Xhold504 u_interface.fifo_data\[14\]\[9\] VGND VGND VPWR VPWR net1369 sky130_fd_sc_hd__dlygate4sd3_1
Xhold537 u_interface.fifo_data\[6\]\[7\] VGND VGND VPWR VPWR net1402 sky130_fd_sc_hd__dlygate4sd3_1
Xhold548 u_interface.fifo_data\[4\]\[7\] VGND VGND VPWR VPWR net1413 sky130_fd_sc_hd__dlygate4sd3_1
Xhold559 u_interface.fifo_data\[0\]\[23\] VGND VGND VPWR VPWR net1424 sky130_fd_sc_hd__dlygate4sd3_1
X_09950_ _03692_ _03702_ VGND VGND VPWR VPWR _03703_ sky130_fd_sc_hd__xnor2_1
X_08901_ net515 net706 net519 net714 VGND VGND VPWR VPWR _02660_ sky130_fd_sc_hd__and4_1
XPHY_EDGE_ROW_115_Left_271 VGND VGND VPWR VPWR sky130_fd_sc_hd__decap_3
XFILLER_98_842 VGND VGND VPWR VPWR sky130_fd_sc_hd__fill_2
X_09881_ _03583_ _03591_ _03592_ VGND VGND VPWR VPWR _03634_ sky130_fd_sc_hd__a21o_1
XFILLER_97_341 VGND VGND VPWR VPWR sky130_fd_sc_hd__fill_1
X_08832_ _02587_ _02588_ VGND VGND VPWR VPWR _02591_ sky130_fd_sc_hd__xor2_1
XFILLER_112_696 VGND VGND VPWR VPWR sky130_fd_sc_hd__decap_4
XFILLER_97_374 VGND VGND VPWR VPWR sky130_fd_sc_hd__decap_4
XTAP_TAPCELL_ROW_142_2608 VGND VPWR sky130_fd_sc_hd__tapvpwrvgnd_1
X_08763_ net592 net467 net470 net599 VGND VGND VPWR VPWR _02522_ sky130_fd_sc_hd__a22o_1
XFILLER_73_709 VGND VGND VPWR VPWR sky130_fd_sc_hd__decap_6
X_07714_ net386 u_interface.u_gelu_fp32.u_synth_top.s1_hits\[1\] _01185_ _01768_ VGND
+ VGND VPWR VPWR _00511_ sky130_fd_sc_hd__or4_1
XFILLER_38_474 VGND VGND VPWR VPWR sky130_fd_sc_hd__fill_2
X_08694_ _02447_ _02451_ VGND VGND VPWR VPWR _02453_ sky130_fd_sc_hd__xnor2_1
XFILLER_93_591 VGND VGND VPWR VPWR sky130_fd_sc_hd__decap_4
XFILLER_65_293 VGND VGND VPWR VPWR sky130_fd_sc_hd__decap_8
XTAP_TAPCELL_ROW_49_1123 VGND VPWR sky130_fd_sc_hd__tapvpwrvgnd_1
XTAP_TAPCELL_ROW_49_1112 VGND VPWR sky130_fd_sc_hd__tapvpwrvgnd_1
XFILLER_25_113 VGND VGND VPWR VPWR sky130_fd_sc_hd__fill_2
XFILLER_26_625 VPWR VGND VPWR VGND sky130_ef_sc_hd__decap_12
X_07645_ net803 net1649 net298 _01731_ VGND VGND VPWR VPWR _00479_ sky130_fd_sc_hd__a22o_1
XFILLER_26_669 VPWR VGND VPWR VGND sky130_ef_sc_hd__decap_12
X_07576_ net311 _01607_ VGND VGND VPWR VPWR _01685_ sky130_fd_sc_hd__and2_1
XPHY_EDGE_ROW_124_Left_280 VGND VGND VPWR VPWR sky130_fd_sc_hd__decap_3
XFILLER_41_617 VPWR VGND VPWR VGND sky130_ef_sc_hd__decap_12
X_06527_ _01122_ _01125_ _01126_ u_interface.pipeline_enable VGND VGND VPWR VPWR _01127_
+ sky130_fd_sc_hd__or4b_1
X_09315_ net606 net615 net513 net517 VGND VGND VPWR VPWR _03074_ sky130_fd_sc_hd__and4_1
XFILLER_139_505 VGND VGND VPWR VPWR sky130_fd_sc_hd__fill_2
XTAP_TAPCELL_ROW_62_1334 VGND VPWR sky130_fd_sc_hd__tapvpwrvgnd_1
XTAP_TAPCELL_ROW_62_1323 VGND VPWR sky130_fd_sc_hd__tapvpwrvgnd_1
XFILLER_15_69 VPWR VGND VPWR VGND sky130_ef_sc_hd__decap_12
X_09246_ _02912_ _02914_ _03002_ _02866_ VGND VGND VPWR VPWR _03005_ sky130_fd_sc_hd__a211oi_1
XTAP_TAPCELL_ROW_11_509 VGND VPWR sky130_fd_sc_hd__tapvpwrvgnd_1
X_09177_ _02889_ _02927_ _02932_ VGND VGND VPWR VPWR _02936_ sky130_fd_sc_hd__a21o_1
XFILLER_119_251 VPWR VGND VPWR VGND sky130_ef_sc_hd__decap_12
XFILLER_5_529 VPWR VGND VPWR VGND sky130_ef_sc_hd__decap_12
XFILLER_31_57 VPWR VGND VPWR VGND sky130_ef_sc_hd__decap_12
XFILLER_147_57 VGND VGND VPWR VPWR sky130_fd_sc_hd__decap_4
XFILLER_134_232 VPWR VGND VPWR VGND sky130_ef_sc_hd__decap_12
X_08128_ _01966_ _01967_ VGND VGND VPWR VPWR _01972_ sky130_fd_sc_hd__and2_1
X_08059_ net541 _01914_ net169 VGND VGND VPWR VPWR _01915_ sky130_fd_sc_hd__mux2_1
X_11070_ _04702_ _04705_ VGND VGND VPWR VPWR _04813_ sky130_fd_sc_hd__nand2_1
Xinput102 s_axis_tdata[6] VGND VGND VPWR VPWR net102 sky130_fd_sc_hd__clkbuf_1
X_10021_ _03772_ VGND VGND VPWR VPWR _03773_ sky130_fd_sc_hd__inv_2
XFILLER_130_471 VGND VGND VPWR VPWR sky130_fd_sc_hd__decap_4
XTAP_TAPCELL_ROW_73_1496 VGND VPWR sky130_fd_sc_hd__tapvpwrvgnd_1
XFILLER_48_238 VGND VGND VPWR VPWR sky130_fd_sc_hd__decap_8
XFILLER_48_227 VGND VGND VPWR VPWR sky130_fd_sc_hd__fill_2
XFILLER_29_441 VGND VGND VPWR VPWR sky130_fd_sc_hd__decap_3
XFILLER_29_463 VPWR VGND VPWR VGND sky130_ef_sc_hd__decap_12
X_13711_ clknet_leaf_2_clk _00721_ VGND VGND VPWR VPWR u_interface.u_gelu_fp32.s1_data\[11\]
+ sky130_fd_sc_hd__dfxtp_1
XFILLER_57_794 VGND VGND VPWR VPWR sky130_fd_sc_hd__decap_6
XFILLER_57_783 VGND VGND VPWR VPWR sky130_fd_sc_hd__fill_1
XFILLER_44_411 VGND VGND VPWR VPWR sky130_fd_sc_hd__decap_6
X_11972_ _05576_ _05624_ _05623_ VGND VGND VPWR VPWR _05706_ sky130_fd_sc_hd__a21oi_1
XFILLER_112_60 VGND VGND VPWR VPWR sky130_fd_sc_hd__fill_1
X_10923_ _04664_ _04665_ VGND VGND VPWR VPWR _04668_ sky130_fd_sc_hd__xor2_1
XFILLER_44_444 VPWR VGND VPWR VGND sky130_ef_sc_hd__decap_12
XPHY_EDGE_ROW_19_Right_19 VGND VGND VPWR VPWR sky130_fd_sc_hd__decap_3
XFILLER_112_82 VGND VGND VPWR VPWR sky130_fd_sc_hd__fill_2
X_13642_ clknet_leaf_47_clk _00652_ VGND VGND VPWR VPWR u_interface.fifo_data\[13\]\[25\]
+ sky130_fd_sc_hd__dfxtp_1
X_10854_ net677 net443 net438 net668 VGND VGND VPWR VPWR _04599_ sky130_fd_sc_hd__a22o_1
XFILLER_16_179 VPWR VGND VPWR VGND sky130_ef_sc_hd__decap_12
X_13573_ clknet_leaf_68_clk _00583_ VGND VGND VPWR VPWR u_interface.fifo_data\[4\]\[20\]
+ sky130_fd_sc_hd__dfxtp_1
XFILLER_13_853 VPWR VGND VPWR VGND sky130_ef_sc_hd__decap_12
XFILLER_72_97 VGND VGND VPWR VPWR sky130_fd_sc_hd__decap_4
X_10785_ _04528_ _04529_ _04407_ VGND VGND VPWR VPWR _04531_ sky130_fd_sc_hd__o21bai_1
XFILLER_12_341 VPWR VGND VPWR VGND sky130_ef_sc_hd__decap_12
XFILLER_12_363 VGND VGND VPWR VPWR sky130_fd_sc_hd__fill_1
X_12524_ _06247_ _06248_ VGND VGND VPWR VPWR _06249_ sky130_fd_sc_hd__or2_1
XTAP_TAPCELL_ROW_30_818 VGND VPWR sky130_fd_sc_hd__tapvpwrvgnd_1
XFILLER_40_661 VGND VGND VPWR VPWR sky130_fd_sc_hd__fill_2
XFILLER_12_385 VGND VGND VPWR VPWR sky130_fd_sc_hd__fill_1
XFILLER_13_897 VPWR VGND VPWR VGND sky130_ef_sc_hd__decap_12
Xclkbuf_3_1__f_clk clknet_0_clk VGND VGND VPWR VPWR clknet_3_1__leaf_clk sky130_fd_sc_hd__clkbuf_16
X_12455_ net177 _06131_ _06134_ VGND VGND VPWR VPWR _06181_ sky130_fd_sc_hd__nor3_1
XTAP_TAPCELL_ROW_93_1817 VGND VPWR sky130_fd_sc_hd__tapvpwrvgnd_1
X_11406_ net719 net444 net438 VGND VGND VPWR VPWR _05146_ sky130_fd_sc_hd__and3_1
X_12386_ _06067_ _06112_ VGND VGND VPWR VPWR _06114_ sky130_fd_sc_hd__xor2_1
X_14125_ clknet_leaf_33_clk _01051_ VGND VGND VPWR VPWR u_interface.fifo_wr_ptr\[2\]
+ sky130_fd_sc_hd__dfxtp_1
XFILLER_99_617 VGND VGND VPWR VPWR sky130_fd_sc_hd__decap_4
XTAP_TAPCELL_ROW_93_1828 VGND VPWR sky130_fd_sc_hd__tapvpwrvgnd_1
XPHY_EDGE_ROW_28_Right_28 VGND VGND VPWR VPWR sky130_fd_sc_hd__decap_3
X_11337_ net625 net633 net403 net399 VGND VGND VPWR VPWR _05078_ sky130_fd_sc_hd__and4_1
XFILLER_141_725 VGND VGND VPWR VPWR sky130_fd_sc_hd__decap_3
XFILLER_126_799 VGND VGND VPWR VPWR sky130_fd_sc_hd__decap_3
X_14056_ clknet_leaf_16_clk _00982_ VGND VGND VPWR VPWR u_interface.u_gelu_fp32.u_fp32_to_q16.s1_mant\[18\]
+ sky130_fd_sc_hd__dfxtp_1
XFILLER_95_801 VGND VGND VPWR VPWR sky130_fd_sc_hd__fill_2
X_11268_ _04810_ _04892_ _04891_ VGND VGND VPWR VPWR _05010_ sky130_fd_sc_hd__o21a_1
X_13007_ net1234 net575 net224 VGND VGND VPWR VPWR _01090_ sky130_fd_sc_hd__mux2_1
X_10219_ _03524_ _03526_ _03742_ _03967_ VGND VGND VPWR VPWR _03970_ sky130_fd_sc_hd__a211o_1
XFILLER_95_812 VGND VGND VPWR VPWR sky130_fd_sc_hd__decap_6
XFILLER_67_525 VGND VGND VPWR VPWR sky130_fd_sc_hd__decap_6
X_11199_ _04847_ _04849_ _04940_ VGND VGND VPWR VPWR _04941_ sky130_fd_sc_hd__and3_1
XTAP_TAPCELL_ROW_124_2327 VGND VPWR sky130_fd_sc_hd__tapvpwrvgnd_1
XTAP_TAPCELL_ROW_124_2316 VGND VPWR sky130_fd_sc_hd__tapvpwrvgnd_1
XPHY_EDGE_ROW_37_Right_37 VGND VGND VPWR VPWR sky130_fd_sc_hd__decap_3
X_13909_ clknet_leaf_2_clk net890 VGND VGND VPWR VPWR u_interface.u_gelu_fp32.u_synth_top.s1_x\[13\]
+ sky130_fd_sc_hd__dfxtp_1
XTAP_TAPCELL_ROW_18_620 VGND VPWR sky130_fd_sc_hd__tapvpwrvgnd_1
XTAP_TAPCELL_ROW_18_631 VGND VPWR sky130_fd_sc_hd__tapvpwrvgnd_1
X_07430_ _01564_ _01565_ net556 VGND VGND VPWR VPWR _01566_ sky130_fd_sc_hd__mux2_1
XFILLER_23_617 VPWR VGND VPWR VGND sky130_ef_sc_hd__decap_12
X_07361_ net571 net1578 net243 VGND VGND VPWR VPWR _00391_ sky130_fd_sc_hd__mux2_1
XFILLER_149_825 VPWR VGND VPWR VGND sky130_ef_sc_hd__decap_12
X_09100_ _02804_ _02820_ _02858_ VGND VGND VPWR VPWR _02859_ sky130_fd_sc_hd__or3_1
XTAP_TAPCELL_ROW_102_1968 VGND VPWR sky130_fd_sc_hd__tapvpwrvgnd_1
XTAP_TAPCELL_ROW_44_1042 VGND VPWR sky130_fd_sc_hd__tapvpwrvgnd_1
X_09031_ _02739_ _02741_ _02740_ VGND VGND VPWR VPWR _02790_ sky130_fd_sc_hd__o21ai_1
X_07292_ net1061 net342 net245 VGND VGND VPWR VPWR _00322_ sky130_fd_sc_hd__mux2_1
XFILLER_117_700 VGND VGND VPWR VPWR sky130_fd_sc_hd__decap_4
XPHY_EDGE_ROW_46_Right_46 VGND VGND VPWR VPWR sky130_fd_sc_hd__decap_3
Xhold301 u_interface.fifo_tuser\[9\] VGND VGND VPWR VPWR net1166 sky130_fd_sc_hd__dlygate4sd3_1
XTAP_TAPCELL_ROW_152_2770 VGND VPWR sky130_fd_sc_hd__tapvpwrvgnd_1
XTAP_TAPCELL_ROW_135_2489 VGND VPWR sky130_fd_sc_hd__tapvpwrvgnd_1
XFILLER_129_593 VPWR VGND VPWR VGND sky130_ef_sc_hd__decap_12
XFILLER_7_81 VPWR VGND VPWR VGND sky130_ef_sc_hd__decap_12
Xhold312 u_interface.u_gelu_fp32.u_fp32_to_q16.s1_mant\[0\] VGND VGND VPWR VPWR net1177
+ sky130_fd_sc_hd__dlygate4sd3_1
Xhold323 u_interface.fifo_data\[5\]\[14\] VGND VGND VPWR VPWR net1188 sky130_fd_sc_hd__dlygate4sd3_1
XFILLER_117_777 VGND VGND VPWR VPWR sky130_fd_sc_hd__decap_6
XFILLER_116_232 VGND VGND VPWR VPWR sky130_fd_sc_hd__fill_1
Xhold334 u_interface.fifo_data\[2\]\[5\] VGND VGND VPWR VPWR net1199 sky130_fd_sc_hd__dlygate4sd3_1
Xhold378 _01010_ VGND VGND VPWR VPWR net1243 sky130_fd_sc_hd__dlygate4sd3_1
XFILLER_144_585 VGND VGND VPWR VPWR sky130_fd_sc_hd__decap_3
XFILLER_131_213 VGND VGND VPWR VPWR sky130_fd_sc_hd__fill_1
Xhold356 u_interface.fifo_data\[14\]\[7\] VGND VGND VPWR VPWR net1221 sky130_fd_sc_hd__dlygate4sd3_1
Xhold345 u_interface.fifo_data\[9\]\[17\] VGND VGND VPWR VPWR net1210 sky130_fd_sc_hd__dlygate4sd3_1
Xhold367 u_interface.fifo_data\[10\]\[11\] VGND VGND VPWR VPWR net1232 sky130_fd_sc_hd__dlygate4sd3_1
XFILLER_104_416 VGND VGND VPWR VPWR sky130_fd_sc_hd__decap_4
XFILLER_89_127 VPWR VGND VPWR VGND sky130_ef_sc_hd__decap_12
Xfanout814 net816 VGND VGND VPWR VPWR net814 sky130_fd_sc_hd__buf_2
XFILLER_131_246 VGND VGND VPWR VPWR sky130_fd_sc_hd__fill_2
Xfanout825 net826 VGND VGND VPWR VPWR net825 sky130_fd_sc_hd__buf_2
X_09933_ _03684_ _03685_ VGND VGND VPWR VPWR _03686_ sky130_fd_sc_hd__or2_1
Xfanout803 net804 VGND VGND VPWR VPWR net803 sky130_fd_sc_hd__buf_2
Xhold389 u_interface.fifo_data\[11\]\[21\] VGND VGND VPWR VPWR net1254 sky130_fd_sc_hd__dlygate4sd3_1
X_09864_ _03564_ _03565_ _03616_ _03617_ VGND VGND VPWR VPWR _03618_ sky130_fd_sc_hd__o22a_1
X_08815_ _02566_ _02573_ VGND VGND VPWR VPWR _02574_ sky130_fd_sc_hd__nand2_1
XFILLER_85_333 VGND VGND VPWR VPWR sky130_fd_sc_hd__decap_3
X_09795_ _03543_ _03546_ _03547_ VGND VGND VPWR VPWR _03549_ sky130_fd_sc_hd__nand3_2
XPHY_EDGE_ROW_55_Right_55 VGND VGND VPWR VPWR sky130_fd_sc_hd__decap_3
X_08746_ net598 net477 u_interface.u_gelu_fp32.u_synth_top.s2_dx\[9\] net604 VGND
+ VGND VPWR VPWR _02505_ sky130_fd_sc_hd__a22o_1
XFILLER_26_433 VGND VGND VPWR VPWR sky130_fd_sc_hd__decap_8
X_08677_ net156 _02437_ VGND VGND VPWR VPWR _02438_ sky130_fd_sc_hd__nand2_1
XFILLER_81_561 VGND VGND VPWR VPWR sky130_fd_sc_hd__decap_4
X_07628_ net306 net298 _01718_ net950 net803 VGND VGND VPWR VPWR _00475_ sky130_fd_sc_hd__a32o_1
XFILLER_13_105 VGND VGND VPWR VPWR sky130_fd_sc_hd__decap_6
XFILLER_13_149 VPWR VGND VPWR VGND sky130_ef_sc_hd__decap_12
XFILLER_41_447 VGND VGND VPWR VPWR sky130_fd_sc_hd__fill_1
X_07559_ net812 net1775 net304 _01673_ VGND VGND VPWR VPWR _00451_ sky130_fd_sc_hd__a22o_1
X_10570_ _04316_ _04317_ VGND VGND VPWR VPWR _04318_ sky130_fd_sc_hd__xnor2_1
XPHY_EDGE_ROW_64_Right_64 VGND VGND VPWR VPWR sky130_fd_sc_hd__decap_3
X_09229_ net582 net481 net485 net592 VGND VGND VPWR VPWR _02988_ sky130_fd_sc_hd__a22oi_1
XFILLER_10_867 VGND VGND VPWR VPWR sky130_fd_sc_hd__fill_1
XFILLER_6_805 VGND VGND VPWR VPWR sky130_fd_sc_hd__decap_6
XFILLER_135_530 VGND VGND VPWR VPWR sky130_fd_sc_hd__decap_8
X_12240_ _05968_ _05969_ VGND VGND VPWR VPWR _05970_ sky130_fd_sc_hd__nor2_1
XFILLER_6_849 VPWR VGND VPWR VGND sky130_ef_sc_hd__decap_12
XTAP_TAPCELL_ROW_75_1536 VGND VPWR sky130_fd_sc_hd__tapvpwrvgnd_1
X_12171_ _05892_ _05901_ VGND VGND VPWR VPWR _05902_ sky130_fd_sc_hd__xnor2_1
XFILLER_123_769 VGND VGND VPWR VPWR sky130_fd_sc_hd__fill_1
Xhold890 u_interface.u_gelu_fp32.s2_data\[1\] VGND VGND VPWR VPWR net1755 sky130_fd_sc_hd__dlygate4sd3_1
X_11122_ net611 net624 net404 net400 VGND VGND VPWR VPWR _04865_ sky130_fd_sc_hd__and4_1
XFILLER_110_419 VGND VGND VPWR VPWR sky130_fd_sc_hd__fill_1
X_11053_ net388 net215 _03171_ VGND VGND VPWR VPWR _04796_ sky130_fd_sc_hd__a21oi_2
XFILLER_3_39 VPWR VGND VPWR VGND sky130_ef_sc_hd__decap_12
XPHY_EDGE_ROW_73_Right_73 VGND VGND VPWR VPWR sky130_fd_sc_hd__decap_3
X_10004_ _03171_ _03749_ VGND VGND VPWR VPWR _03756_ sky130_fd_sc_hd__nor2_1
XFILLER_49_525 VGND VGND VPWR VPWR sky130_fd_sc_hd__fill_1
XFILLER_76_344 VGND VGND VPWR VPWR sky130_fd_sc_hd__decap_8
XTAP_TAPCELL_ROW_106_2035 VGND VPWR sky130_fd_sc_hd__tapvpwrvgnd_1
XTAP_TAPCELL_ROW_106_2024 VGND VPWR sky130_fd_sc_hd__tapvpwrvgnd_1
XFILLER_64_528 VGND VGND VPWR VPWR sky130_fd_sc_hd__decap_4
XTAP_TAPCELL_ROW_4_392 VGND VPWR sky130_fd_sc_hd__tapvpwrvgnd_1
XFILLER_123_81 VGND VGND VPWR VPWR sky130_fd_sc_hd__decap_8
XFILLER_17_455 VGND VGND VPWR VPWR sky130_fd_sc_hd__fill_1
X_11955_ net666 net393 _05609_ _05608_ VGND VGND VPWR VPWR _05689_ sky130_fd_sc_hd__a31o_1
XFILLER_29_293 VPWR VGND VPWR VGND sky130_ef_sc_hd__decap_12
X_10906_ _04537_ _04539_ VGND VGND VPWR VPWR _04651_ sky130_fd_sc_hd__or2_1
X_11886_ _05586_ _05620_ VGND VGND VPWR VPWR _05621_ sky130_fd_sc_hd__xnor2_1
X_13625_ clknet_leaf_72_clk _00635_ VGND VGND VPWR VPWR u_interface.fifo_data\[13\]\[8\]
+ sky130_fd_sc_hd__dfxtp_1
XPHY_EDGE_ROW_82_Right_82 VGND VGND VPWR VPWR sky130_fd_sc_hd__decap_3
X_10837_ net452 net695 net704 net456 VGND VGND VPWR VPWR _04582_ sky130_fd_sc_hd__a22o_1
X_10768_ _04512_ _04513_ VGND VGND VPWR VPWR _04514_ sky130_fd_sc_hd__nor2_1
X_13556_ clknet_leaf_69_clk _00566_ VGND VGND VPWR VPWR u_interface.fifo_data\[4\]\[3\]
+ sky130_fd_sc_hd__dfxtp_1
XFILLER_145_305 VGND VGND VPWR VPWR sky130_fd_sc_hd__decap_8
X_13487_ clknet_leaf_1_clk _00497_ VGND VGND VPWR VPWR u_interface.u_gelu_fp32.u_synth_top.s2_b\[6\]
+ sky130_fd_sc_hd__dfxtp_1
XFILLER_9_665 VGND VGND VPWR VPWR sky130_fd_sc_hd__decap_6
X_12507_ _06196_ _06198_ _06231_ VGND VGND VPWR VPWR _06232_ sky130_fd_sc_hd__nand3_1
XFILLER_8_153 VPWR VGND VPWR VGND sky130_ef_sc_hd__decap_12
X_10699_ _04325_ _04327_ VGND VGND VPWR VPWR _04445_ sky130_fd_sc_hd__nand2_1
X_12438_ _06124_ _06163_ VGND VGND VPWR VPWR _06165_ sky130_fd_sc_hd__xnor2_1
XFILLER_126_552 VGND VGND VPWR VPWR sky130_fd_sc_hd__decap_6
XFILLER_113_213 VGND VGND VPWR VPWR sky130_fd_sc_hd__fill_1
X_12369_ _06019_ _06032_ _06031_ VGND VGND VPWR VPWR _06097_ sky130_fd_sc_hd__o21a_1
X_14108_ clknet_leaf_29_clk _01034_ VGND VGND VPWR VPWR u_interface.meta_tlast_pipe\[1\]
+ sky130_fd_sc_hd__dfxtp_1
XFILLER_141_544 VGND VGND VPWR VPWR sky130_fd_sc_hd__decap_8
XFILLER_99_447 VGND VGND VPWR VPWR sky130_fd_sc_hd__fill_1
X_14039_ clknet_leaf_16_clk _00965_ VGND VGND VPWR VPWR u_interface.u_gelu_fp32.u_fp32_to_q16.s1_mant\[1\]
+ sky130_fd_sc_hd__dfxtp_1
XFILLER_141_588 VGND VGND VPWR VPWR sky130_fd_sc_hd__decap_4
XFILLER_101_408 VGND VGND VPWR VPWR sky130_fd_sc_hd__fill_2
XPHY_EDGE_ROW_91_Right_91 VGND VGND VPWR VPWR sky130_fd_sc_hd__decap_3
X_06930_ _01461_ _01464_ VGND VGND VPWR VPWR _00039_ sky130_fd_sc_hd__xor2_1
X_06861_ u_interface.fifo_data\[8\]\[29\] u_interface.fifo_data\[9\]\[29\] u_interface.fifo_data\[10\]\[29\]
+ u_interface.fifo_data\[11\]\[29\] net766 net749 VGND VGND VPWR VPWR _01407_ sky130_fd_sc_hd__mux4_1
XFILLER_94_141 VGND VGND VPWR VPWR sky130_fd_sc_hd__decap_4
X_08600_ net154 _02381_ net801 VGND VGND VPWR VPWR _00785_ sky130_fd_sc_hd__a21oi_1
XFILLER_55_517 VPWR VGND VPWR VGND sky130_ef_sc_hd__decap_12
X_09580_ net466 net631 net640 net471 VGND VGND VPWR VPWR _03336_ sky130_fd_sc_hd__a22o_1
X_06792_ net729 _01344_ net725 VGND VGND VPWR VPWR _01347_ sky130_fd_sc_hd__o21a_1
XFILLER_36_720 VGND VGND VPWR VPWR sky130_fd_sc_hd__decap_6
XFILLER_70_509 VGND VGND VPWR VPWR sky130_fd_sc_hd__decap_3
X_08531_ _02302_ _02321_ _02300_ VGND VGND VPWR VPWR _02322_ sky130_fd_sc_hd__o21ai_1
XFILLER_91_892 VGND VGND VPWR VPWR sky130_fd_sc_hd__decap_4
XFILLER_63_561 VGND VGND VPWR VPWR sky130_fd_sc_hd__fill_1
X_08462_ _02250_ _02252_ VGND VGND VPWR VPWR _02253_ sky130_fd_sc_hd__nand2_1
X_07413_ _01545_ _01548_ net550 VGND VGND VPWR VPWR _01549_ sky130_fd_sc_hd__mux2_1
XFILLER_23_425 VGND VGND VPWR VPWR sky130_fd_sc_hd__fill_2
X_08393_ u_interface.u_gelu_fp32.u_synth_top.s3_mult\[28\] u_interface.u_gelu_fp32.u_synth_top.s3_b\[12\]
+ VGND VGND VPWR VPWR _02184_ sky130_fd_sc_hd__nand2_1
XFILLER_11_609 VGND VGND VPWR VPWR sky130_fd_sc_hd__decap_6
XTAP_TAPCELL_ROW_137_2529 VGND VPWR sky130_fd_sc_hd__tapvpwrvgnd_1
X_07344_ net366 net1563 net241 VGND VGND VPWR VPWR _00374_ sky130_fd_sc_hd__mux2_1
XFILLER_50_288 VGND VGND VPWR VPWR sky130_fd_sc_hd__decap_3
X_07275_ net1434 net376 net246 VGND VGND VPWR VPWR _00305_ sky130_fd_sc_hd__mux2_1
XFILLER_12_15 VPWR VGND VPWR VGND sky130_ef_sc_hd__decap_12
XTAP_TAPCELL_ROW_150_2729 VGND VPWR sky130_fd_sc_hd__tapvpwrvgnd_1
X_09014_ net598 net487 net492 net604 VGND VGND VPWR VPWR _02773_ sky130_fd_sc_hd__a22o_1
XFILLER_132_522 VGND VGND VPWR VPWR sky130_fd_sc_hd__decap_8
Xhold153 u_interface.fifo_data\[13\]\[7\] VGND VGND VPWR VPWR net1018 sky130_fd_sc_hd__dlygate4sd3_1
Xhold142 u_interface.fifo_data\[8\]\[13\] VGND VGND VPWR VPWR net1007 sky130_fd_sc_hd__dlygate4sd3_1
XFILLER_117_585 VPWR VGND VPWR VGND sky130_ef_sc_hd__decap_12
Xhold131 u_interface.fifo_data\[6\]\[11\] VGND VGND VPWR VPWR net996 sky130_fd_sc_hd__dlygate4sd3_1
Xhold120 u_interface.u_gelu_fp32.u_q16_to_fp32.s2_exp\[5\] VGND VGND VPWR VPWR net985
+ sky130_fd_sc_hd__dlygate4sd3_1
XTAP_TAPCELL_ROW_57_1255 VGND VPWR sky130_fd_sc_hd__tapvpwrvgnd_1
XTAP_TAPCELL_ROW_57_1244 VGND VPWR sky130_fd_sc_hd__tapvpwrvgnd_1
XFILLER_2_307 VGND VGND VPWR VPWR sky130_fd_sc_hd__fill_1
Xhold164 u_interface.fifo_data\[5\]\[10\] VGND VGND VPWR VPWR net1029 sky130_fd_sc_hd__dlygate4sd3_1
XFILLER_132_533 VGND VGND VPWR VPWR sky130_fd_sc_hd__fill_2
Xhold186 u_interface.fifo_data\[8\]\[20\] VGND VGND VPWR VPWR net1051 sky130_fd_sc_hd__dlygate4sd3_1
Xhold175 u_interface.fifo_data\[1\]\[21\] VGND VGND VPWR VPWR net1040 sky130_fd_sc_hd__dlygate4sd3_1
Xfanout622 net623 VGND VGND VPWR VPWR net622 sky130_fd_sc_hd__dlymetal6s2s_1
Xfanout600 u_interface.u_gelu_fp32.u_synth_top.s2_m\[2\] VGND VGND VPWR VPWR net600
+ sky130_fd_sc_hd__dlymetal6s2s_1
XFILLER_104_268 VPWR VGND VPWR VGND sky130_ef_sc_hd__decap_12
X_09916_ net620 net450 VGND VGND VPWR VPWR _03669_ sky130_fd_sc_hd__nand2_1
Xfanout611 net616 VGND VGND VPWR VPWR net611 sky130_fd_sc_hd__buf_2
Xhold197 u_interface.fifo_data\[14\]\[8\] VGND VGND VPWR VPWR net1062 sky130_fd_sc_hd__dlygate4sd3_1
Xfanout633 net636 VGND VGND VPWR VPWR net633 sky130_fd_sc_hd__buf_2
Xfanout655 net657 VGND VGND VPWR VPWR net655 sky130_fd_sc_hd__clkbuf_2
Xfanout644 net645 VGND VGND VPWR VPWR net644 sky130_fd_sc_hd__buf_2
XTAP_TAPCELL_ROW_70_1455 VGND VPWR sky130_fd_sc_hd__tapvpwrvgnd_1
XFILLER_59_834 VGND VGND VPWR VPWR sky130_fd_sc_hd__decap_6
XFILLER_58_333 VGND VGND VPWR VPWR sky130_fd_sc_hd__decap_6
Xfanout666 net674 VGND VGND VPWR VPWR net666 sky130_fd_sc_hd__buf_2
Xfanout699 net700 VGND VGND VPWR VPWR net699 sky130_fd_sc_hd__buf_2
X_09847_ _03599_ _03600_ _03596_ VGND VGND VPWR VPWR _03601_ sky130_fd_sc_hd__a21o_1
Xfanout688 net691 VGND VGND VPWR VPWR net688 sky130_fd_sc_hd__clkbuf_4
Xfanout677 net683 VGND VGND VPWR VPWR net677 sky130_fd_sc_hd__buf_2
XFILLER_19_709 VPWR VGND VPWR VGND sky130_ef_sc_hd__decap_12
X_09778_ net500 net505 net724 VGND VGND VPWR VPWR _03532_ sky130_fd_sc_hd__o21ai_1
XFILLER_46_528 VGND VGND VPWR VPWR sky130_fd_sc_hd__decap_4
XFILLER_18_208 VGND VGND VPWR VPWR sky130_fd_sc_hd__fill_2
X_08729_ net646 net496 VGND VGND VPWR VPWR _02488_ sky130_fd_sc_hd__nand2_1
XFILLER_85_196 VPWR VGND VPWR VGND sky130_ef_sc_hd__decap_12
XTAP_TAPCELL_ROW_1_351 VGND VPWR sky130_fd_sc_hd__tapvpwrvgnd_1
XFILLER_27_753 VPWR VGND VPWR VGND sky130_ef_sc_hd__decap_12
X_11740_ net193 _05395_ _05394_ VGND VGND VPWR VPWR _05477_ sky130_fd_sc_hd__a21oi_1
XFILLER_27_797 VPWR VGND VPWR VGND sky130_ef_sc_hd__decap_12
XFILLER_53_77 VPWR VGND VPWR VGND sky130_ef_sc_hd__decap_12
XFILLER_53_55 VGND VGND VPWR VPWR sky130_fd_sc_hd__fill_1
XFILLER_14_469 VGND VGND VPWR VPWR sky130_fd_sc_hd__decap_6
X_11671_ net205 _05407_ VGND VGND VPWR VPWR _05408_ sky130_fd_sc_hd__xnor2_2
XFILLER_139_132 VGND VGND VPWR VPWR sky130_fd_sc_hd__fill_1
X_13410_ clknet_leaf_44_clk _00420_ VGND VGND VPWR VPWR u_interface.fifo_data\[6\]\[23\]
+ sky130_fd_sc_hd__dfxtp_1
X_10622_ _04366_ net188 _04275_ _04277_ VGND VGND VPWR VPWR _04369_ sky130_fd_sc_hd__o211ai_1
X_13341_ clknet_leaf_50_clk _00351_ VGND VGND VPWR VPWR u_interface.fifo_data\[10\]\[18\]
+ sky130_fd_sc_hd__dfxtp_1
X_10553_ _04299_ _04300_ _04176_ _04178_ VGND VGND VPWR VPWR _04301_ sky130_fd_sc_hd__o211ai_2
XTAP_TAPCELL_ROW_40_968 VGND VPWR sky130_fd_sc_hd__tapvpwrvgnd_1
XTAP_TAPCELL_ROW_40_979 VGND VPWR sky130_fd_sc_hd__tapvpwrvgnd_1
XFILLER_155_636 VGND VGND VPWR VPWR sky130_fd_sc_hd__decap_4
XFILLER_6_613 VPWR VGND VPWR VGND sky130_ef_sc_hd__decap_12
X_13272_ clknet_leaf_43_clk _00282_ VGND VGND VPWR VPWR u_interface.fifo_data\[0\]\[14\]
+ sky130_fd_sc_hd__dfxtp_1
X_10484_ _04227_ _04228_ _04229_ VGND VGND VPWR VPWR _04232_ sky130_fd_sc_hd__o21ai_1
XFILLER_6_657 VPWR VGND VPWR VGND sky130_ef_sc_hd__decap_12
XFILLER_123_511 VGND VGND VPWR VPWR sky130_fd_sc_hd__fill_1
X_12223_ net709 _05890_ _05891_ _05826_ VGND VGND VPWR VPWR _05953_ sky130_fd_sc_hd__o2bb2ai_1
XFILLER_5_167 VGND VGND VPWR VPWR sky130_fd_sc_hd__fill_1
XFILLER_135_393 VGND VGND VPWR VPWR sky130_fd_sc_hd__decap_8
XFILLER_123_555 VGND VGND VPWR VPWR sky130_fd_sc_hd__decap_4
XFILLER_97_918 VGND VGND VPWR VPWR sky130_fd_sc_hd__decap_3
X_12154_ _05745_ _05883_ VGND VGND VPWR VPWR _05885_ sky130_fd_sc_hd__xor2_1
XFILLER_150_363 VGND VGND VPWR VPWR sky130_fd_sc_hd__fill_1
X_11105_ _04845_ _04846_ _04732_ _04734_ VGND VGND VPWR VPWR _04848_ sky130_fd_sc_hd__o211a_1
XTAP_TAPCELL_ROW_9_484 VGND VPWR sky130_fd_sc_hd__tapvpwrvgnd_1
XTAP_TAPCELL_ROW_9_473 VGND VPWR sky130_fd_sc_hd__tapvpwrvgnd_1
XFILLER_89_480 VGND VGND VPWR VPWR sky130_fd_sc_hd__fill_1
XFILLER_49_300 VPWR VGND VPWR VGND sky130_ef_sc_hd__decap_12
XFILLER_1_373 VPWR VGND VPWR VGND sky130_ef_sc_hd__decap_12
X_12085_ _05743_ _05744_ _05816_ VGND VGND VPWR VPWR _05817_ sky130_fd_sc_hd__a21oi_1
XFILLER_76_141 VPWR VGND VPWR VGND sky130_ef_sc_hd__decap_12
XFILLER_65_804 VGND VGND VPWR VPWR sky130_fd_sc_hd__decap_4
X_11036_ _04653_ _04655_ VGND VGND VPWR VPWR _04780_ sky130_fd_sc_hd__nand2_1
XFILLER_91_100 VPWR VGND VPWR VGND sky130_ef_sc_hd__decap_12
XTAP_TAPCELL_ROW_88_1749 VGND VPWR sky130_fd_sc_hd__tapvpwrvgnd_1
XTAP_TAPCELL_ROW_88_1738 VGND VPWR sky130_fd_sc_hd__tapvpwrvgnd_1
XFILLER_77_697 VGND VGND VPWR VPWR sky130_fd_sc_hd__fill_2
XFILLER_76_185 VGND VGND VPWR VPWR sky130_fd_sc_hd__fill_1
X_12987_ net1259 net376 net222 VGND VGND VPWR VPWR _01070_ sky130_fd_sc_hd__mux2_1
XFILLER_80_829 VGND VGND VPWR VPWR sky130_fd_sc_hd__decap_6
XFILLER_45_550 VGND VGND VPWR VPWR sky130_fd_sc_hd__decap_3
XFILLER_17_285 VGND VGND VPWR VPWR sky130_fd_sc_hd__decap_8
X_11938_ _05669_ _05671_ _05592_ VGND VGND VPWR VPWR _05672_ sky130_fd_sc_hd__a21o_1
XTAP_TAPCELL_ROW_28_781 VGND VPWR sky130_fd_sc_hd__tapvpwrvgnd_1
X_11869_ _05600_ _05603_ VGND VGND VPWR VPWR _05604_ sky130_fd_sc_hd__xnor2_1
X_13608_ clknet_leaf_43_clk _00618_ VGND VGND VPWR VPWR u_interface.fifo_data\[3\]\[23\]
+ sky130_fd_sc_hd__dfxtp_1
XFILLER_20_428 VPWR VGND VPWR VGND sky130_ef_sc_hd__decap_12
XFILLER_32_288 VGND VGND VPWR VPWR sky130_fd_sc_hd__decap_8
XTAP_TAPCELL_ROW_119_2237 VGND VPWR sky130_fd_sc_hd__tapvpwrvgnd_1
X_13539_ clknet_leaf_49_clk _00549_ VGND VGND VPWR VPWR u_interface.fifo_data\[5\]\[18\]
+ sky130_fd_sc_hd__dfxtp_1
XFILLER_145_113 VGND VGND VPWR VPWR sky130_fd_sc_hd__decap_3
X_07060_ net1325 net362 net210 VGND VGND VPWR VPWR _00100_ sky130_fd_sc_hd__mux2_1
XFILLER_71_3 VPWR VGND VPWR VGND sky130_ef_sc_hd__decap_12
XFILLER_145_157 VGND VGND VPWR VPWR sky130_fd_sc_hd__decap_8
XTAP_TAPCELL_ROW_132_2448 VGND VPWR sky130_fd_sc_hd__tapvpwrvgnd_1
XFILLER_114_566 VPWR VGND VPWR VGND sky130_ef_sc_hd__decap_12
XFILLER_87_428 VGND VGND VPWR VPWR sky130_fd_sc_hd__decap_8
X_07962_ net548 _01634_ _01838_ _01673_ net542 VGND VGND VPWR VPWR _01843_ sky130_fd_sc_hd__a32o_1
X_09701_ _03446_ _03455_ VGND VGND VPWR VPWR _03456_ sky130_fd_sc_hd__xor2_1
X_06913_ _01450_ _01451_ VGND VGND VPWR VPWR _00036_ sky130_fd_sc_hd__xnor2_1
X_07893_ net1030 net570 net266 VGND VGND VPWR VPWR _00654_ sky130_fd_sc_hd__mux2_1
XTAP_TAPCELL_ROW_52_1174 VGND VPWR sky130_fd_sc_hd__tapvpwrvgnd_1
XTAP_TAPCELL_ROW_52_1163 VGND VPWR sky130_fd_sc_hd__tapvpwrvgnd_1
XTAP_TAPCELL_ROW_147_2691 VGND VPWR sky130_fd_sc_hd__tapvpwrvgnd_1
XTAP_TAPCELL_ROW_147_2680 VGND VPWR sky130_fd_sc_hd__tapvpwrvgnd_1
X_06844_ _01388_ _01389_ _01392_ net319 VGND VGND VPWR VPWR net127 sky130_fd_sc_hd__a22o_1
X_09632_ _03386_ _03387_ _03383_ VGND VGND VPWR VPWR _03388_ sky130_fd_sc_hd__a21o_1
XFILLER_83_623 VGND VGND VPWR VPWR sky130_fd_sc_hd__decap_8
X_09563_ _03318_ _03319_ VGND VGND VPWR VPWR _03320_ sky130_fd_sc_hd__or2_1
XFILLER_82_133 VGND VGND VPWR VPWR sky130_fd_sc_hd__decap_6
XFILLER_55_347 VGND VGND VPWR VPWR sky130_fd_sc_hd__fill_1
X_06775_ u_interface.fifo_data\[12\]\[18\] u_interface.fifo_data\[13\]\[18\] u_interface.fifo_data\[14\]\[18\]
+ u_interface.fifo_data\[15\]\[18\] net761 net744 VGND VGND VPWR VPWR _01332_ sky130_fd_sc_hd__mux4_1
XFILLER_82_177 VGND VGND VPWR VPWR sky130_fd_sc_hd__decap_6
XFILLER_64_881 VGND VGND VPWR VPWR sky130_fd_sc_hd__fill_1
XFILLER_55_369 VPWR VGND VPWR VGND sky130_ef_sc_hd__decap_12
X_08514_ net521 u_interface.u_gelu_fp32.u_synth_top.s3_mult\[52\] VGND VGND VPWR VPWR
+ _02305_ sky130_fd_sc_hd__or2_1
XFILLER_24_701 VPWR VGND VPWR VGND sky130_ef_sc_hd__decap_12
X_09494_ _03249_ _03250_ _03246_ VGND VGND VPWR VPWR _03251_ sky130_fd_sc_hd__a21o_1
XFILLER_63_391 VGND VGND VPWR VPWR sky130_fd_sc_hd__fill_1
X_08445_ _02183_ _02234_ _02182_ VGND VGND VPWR VPWR _02236_ sky130_fd_sc_hd__a21oi_1
XFILLER_23_244 VPWR VGND VPWR VGND sky130_ef_sc_hd__decap_12
XFILLER_23_288 VGND VGND VPWR VPWR sky130_fd_sc_hd__decap_8
X_08376_ net521 u_interface.u_gelu_fp32.u_synth_top.s3_mult\[49\] VGND VGND VPWR VPWR
+ _02167_ sky130_fd_sc_hd__or2_1
XFILLER_109_305 VPWR VGND VPWR VGND sky130_ef_sc_hd__decap_12
X_07327_ net1365 net576 net255 VGND VGND VPWR VPWR _00357_ sky130_fd_sc_hd__mux2_1
XFILLER_23_69 VPWR VGND VPWR VGND sky130_ef_sc_hd__decap_12
X_07258_ net1214 net340 net251 VGND VGND VPWR VPWR _00290_ sky130_fd_sc_hd__mux2_1
XFILLER_109_349 VPWR VGND VPWR VGND sky130_ef_sc_hd__decap_12
X_07189_ net1165 net566 net264 VGND VGND VPWR VPWR _00229_ sky130_fd_sc_hd__mux2_1
XFILLER_155_57 VGND VGND VPWR VPWR sky130_fd_sc_hd__fill_2
XFILLER_155_35 VGND VGND VPWR VPWR sky130_fd_sc_hd__decap_3
XFILLER_144_190 VGND VGND VPWR VPWR sky130_fd_sc_hd__decap_6
XFILLER_117_393 VGND VGND VPWR VPWR sky130_fd_sc_hd__fill_1
XFILLER_155_79 VGND VGND VPWR VPWR sky130_fd_sc_hd__fill_1
XFILLER_105_588 VPWR VGND VPWR VGND sky130_ef_sc_hd__decap_12
XFILLER_132_374 VGND VGND VPWR VPWR sky130_fd_sc_hd__decap_6
XFILLER_120_536 VPWR VGND VPWR VGND sky130_ef_sc_hd__decap_12
Xfanout441 net442 VGND VGND VPWR VPWR net441 sky130_fd_sc_hd__buf_2
Xfanout430 net431 VGND VGND VPWR VPWR net430 sky130_fd_sc_hd__clkbuf_2
XTAP_TAPCELL_ROW_6_432 VGND VPWR sky130_fd_sc_hd__tapvpwrvgnd_1
Xfanout463 u_interface.u_gelu_fp32.u_synth_top.s2_dx\[14\] VGND VGND VPWR VPWR net463
+ sky130_fd_sc_hd__clkbuf_2
Xfanout474 u_interface.u_gelu_fp32.u_synth_top.s2_dx\[10\] VGND VGND VPWR VPWR net474
+ sky130_fd_sc_hd__clkbuf_2
XFILLER_93_409 VGND VGND VPWR VPWR sky130_fd_sc_hd__fill_2
XFILLER_86_450 VGND VGND VPWR VPWR sky130_fd_sc_hd__fill_2
Xfanout452 net453 VGND VGND VPWR VPWR net452 sky130_fd_sc_hd__buf_2
X_12910_ _01100_ _01535_ VGND VGND VPWR VPWR _06438_ sky130_fd_sc_hd__nor2_2
Xfanout496 net498 VGND VGND VPWR VPWR net496 sky130_fd_sc_hd__buf_2
Xfanout485 u_interface.u_gelu_fp32.u_synth_top.s2_dx\[8\] VGND VGND VPWR VPWR net485
+ sky130_fd_sc_hd__buf_2
X_13890_ clknet_leaf_90_clk _00026_ VGND VGND VPWR VPWR u_interface.u_gelu_fp32.u_synth_top.s2_dx\[26\]
+ sky130_fd_sc_hd__dfxtp_1
XFILLER_46_314 VGND VGND VPWR VPWR sky130_fd_sc_hd__fill_2
XFILLER_19_539 VGND VGND VPWR VPWR sky130_fd_sc_hd__fill_1
X_12841_ _06419_ _06420_ _06421_ _06422_ VGND VGND VPWR VPWR _06423_ sky130_fd_sc_hd__or4_2
XFILLER_74_645 VGND VGND VPWR VPWR sky130_fd_sc_hd__fill_2
XFILLER_73_111 VGND VGND VPWR VPWR sky130_fd_sc_hd__fill_1
XFILLER_0_29 VPWR VGND VPWR VGND sky130_ef_sc_hd__decap_12
XFILLER_73_177 VGND VGND VPWR VPWR sky130_fd_sc_hd__decap_8
XFILLER_27_550 VGND VGND VPWR VPWR sky130_fd_sc_hd__decap_8
XFILLER_27_561 VPWR VGND VPWR VGND sky130_ef_sc_hd__decap_12
X_12772_ net1765 _01779_ _06402_ VGND VGND VPWR VPWR _00946_ sky130_fd_sc_hd__a21oi_1
XFILLER_14_222 VPWR VGND VPWR VGND sky130_ef_sc_hd__decap_12
XFILLER_42_531 VGND VGND VPWR VPWR sky130_fd_sc_hd__fill_1
XTAP_TAPCELL_ROW_83_1668 VGND VPWR sky130_fd_sc_hd__tapvpwrvgnd_1
XTAP_TAPCELL_ROW_83_1657 VGND VPWR sky130_fd_sc_hd__tapvpwrvgnd_1
XFILLER_9_27 VPWR VGND VPWR VGND sky130_ef_sc_hd__decap_12
XTAP_TAPCELL_ROW_25_740 VGND VPWR sky130_fd_sc_hd__tapvpwrvgnd_1
X_11723_ _05427_ _05459_ VGND VGND VPWR VPWR _05460_ sky130_fd_sc_hd__xnor2_1
XFILLER_120_82 VGND VGND VPWR VPWR sky130_fd_sc_hd__fill_2
X_11654_ _05315_ _05391_ VGND VGND VPWR VPWR _05392_ sky130_fd_sc_hd__xnor2_1
XFILLER_30_737 VPWR VGND VPWR VGND sky130_ef_sc_hd__decap_12
X_10605_ _04241_ _04244_ VGND VGND VPWR VPWR _04352_ sky130_fd_sc_hd__nand2_1
XFILLER_155_433 VGND VGND VPWR VPWR sky130_fd_sc_hd__decap_4
XFILLER_127_113 VGND VGND VPWR VPWR sky130_fd_sc_hd__decap_4
X_11585_ _05225_ _05226_ _05322_ _05224_ VGND VGND VPWR VPWR _05323_ sky130_fd_sc_hd__o211ai_1
X_13324_ clknet_leaf_54_clk _00334_ VGND VGND VPWR VPWR u_interface.fifo_data\[10\]\[1\]
+ sky130_fd_sc_hd__dfxtp_1
X_10536_ net603 net417 net414 net594 VGND VGND VPWR VPWR _04284_ sky130_fd_sc_hd__a22oi_1
XFILLER_6_432 VGND VGND VPWR VPWR sky130_fd_sc_hd__decap_3
XFILLER_155_499 VGND VGND VPWR VPWR sky130_fd_sc_hd__fill_1
XFILLER_155_477 VGND VGND VPWR VPWR sky130_fd_sc_hd__fill_2
X_13255_ clknet_leaf_31_clk _00265_ VGND VGND VPWR VPWR _00001_ sky130_fd_sc_hd__dfxtp_2
XFILLER_142_105 VGND VGND VPWR VPWR sky130_fd_sc_hd__fill_1
XTAP_TAPCELL_ROW_114_2156 VGND VPWR sky130_fd_sc_hd__tapvpwrvgnd_1
XPHY_EDGE_ROW_108_Right_108 VGND VGND VPWR VPWR sky130_fd_sc_hd__decap_3
XFILLER_89_40 VPWR VGND VPWR VGND sky130_ef_sc_hd__decap_12
X_10467_ _04213_ _04214_ _04203_ VGND VGND VPWR VPWR _04215_ sky130_fd_sc_hd__a21o_1
XFILLER_142_138 VGND VGND VPWR VPWR sky130_fd_sc_hd__fill_2
XTAP_TAPCELL_ROW_114_2167 VGND VPWR sky130_fd_sc_hd__tapvpwrvgnd_1
X_12206_ _05931_ _05936_ net772 VGND VGND VPWR VPWR _05937_ sky130_fd_sc_hd__o21ai_1
X_13186_ clknet_leaf_39_clk _00196_ VGND VGND VPWR VPWR u_interface.fifo_data\[9\]\[28\]
+ sky130_fd_sc_hd__dfxtp_1
X_10398_ _04143_ _04146_ VGND VGND VPWR VPWR _04147_ sky130_fd_sc_hd__xnor2_1
XFILLER_111_547 VPWR VGND VPWR VGND sky130_ef_sc_hd__decap_12
XFILLER_2_693 VGND VGND VPWR VPWR sky130_fd_sc_hd__decap_6
X_12137_ net178 _05806_ _05809_ VGND VGND VPWR VPWR _05868_ sky130_fd_sc_hd__nor3_1
XFILLER_150_193 VGND VGND VPWR VPWR sky130_fd_sc_hd__decap_3
XFILLER_1_181 VPWR VGND VPWR VGND sky130_ef_sc_hd__decap_12
X_12068_ net183 _05727_ _05726_ VGND VGND VPWR VPWR _05800_ sky130_fd_sc_hd__a21o_1
X_11019_ _04635_ _04761_ VGND VGND VPWR VPWR _04763_ sky130_fd_sc_hd__xor2_1
X_06560_ net538 u_interface.u_gelu_fp32.s1_data\[14\] VGND VGND VPWR VPWR _01154_
+ sky130_fd_sc_hd__nor2_1
XFILLER_80_637 VGND VGND VPWR VPWR sky130_fd_sc_hd__decap_6
XFILLER_45_380 VPWR VGND VPWR VGND sky130_ef_sc_hd__decap_12
XFILLER_18_572 VPWR VGND VPWR VGND sky130_ef_sc_hd__decap_12
X_08230_ net166 _02057_ VGND VGND VPWR VPWR _02058_ sky130_fd_sc_hd__nand2_1
XFILLER_60_383 VGND VGND VPWR VPWR sky130_fd_sc_hd__fill_1
XFILLER_33_597 VPWR VGND VPWR VGND sky130_ef_sc_hd__decap_12
XFILLER_147_901 VGND VGND VPWR VPWR sky130_fd_sc_hd__fill_1
XFILLER_60_394 VGND VGND VPWR VPWR sky130_fd_sc_hd__fill_1
X_08161_ _01998_ _01999_ VGND VGND VPWR VPWR _02000_ sky130_fd_sc_hd__xnor2_1
XFILLER_146_455 VGND VGND VPWR VPWR sky130_fd_sc_hd__fill_1
X_08092_ _01877_ _01941_ VGND VGND VPWR VPWR _01942_ sky130_fd_sc_hd__or2_1
XFILLER_118_135 VGND VGND VPWR VPWR sky130_fd_sc_hd__decap_4
X_07112_ net1043 net562 net225 VGND VGND VPWR VPWR _00152_ sky130_fd_sc_hd__mux2_1
XFILLER_9_281 VPWR VGND VPWR VGND sky130_ef_sc_hd__decap_12
XFILLER_146_477 VPWR VGND VPWR VGND sky130_ef_sc_hd__decap_12
X_07043_ net1313 net572 net271 VGND VGND VPWR VPWR _00083_ sky130_fd_sc_hd__mux2_1
Xclkload40 clknet_leaf_59_clk VGND VGND VPWR VPWR clkload40/Y sky130_fd_sc_hd__clkinv_4
Xclkload51 clknet_leaf_85_clk VGND VGND VPWR VPWR clkload51/Y sky130_fd_sc_hd__inv_8
Xclkload62 clknet_leaf_73_clk VGND VGND VPWR VPWR clkload62/Y sky130_fd_sc_hd__clkinv_4
Xclkload84 clknet_leaf_49_clk VGND VGND VPWR VPWR clkload84/Y sky130_fd_sc_hd__clkinvlp_4
Xclkload73 clknet_leaf_55_clk VGND VGND VPWR VPWR clkload73/Y sky130_fd_sc_hd__clkinv_2
XTAP_TAPCELL_ROW_54_1203 VGND VPWR sky130_fd_sc_hd__tapvpwrvgnd_1
XTAP_TAPCELL_ROW_149_2720 VGND VPWR sky130_fd_sc_hd__tapvpwrvgnd_1
X_08994_ _02735_ _02736_ _02751_ VGND VGND VPWR VPWR _02753_ sky130_fd_sc_hd__or3_1
XFILLER_125_27 VGND VGND VPWR VPWR sky130_fd_sc_hd__fill_2
XFILLER_87_225 VGND VGND VPWR VPWR sky130_fd_sc_hd__fill_1
X_07945_ net814 u_interface.u_gelu_fp32.u_fp32_to_q16.s2_shift\[4\] _01825_ _01834_
+ VGND VGND VPWR VPWR _00677_ sky130_fd_sc_hd__a22o_1
XFILLER_130_878 VGND VGND VPWR VPWR sky130_fd_sc_hd__fill_2
XFILLER_68_483 VGND VGND VPWR VPWR sky130_fd_sc_hd__fill_1
X_07876_ net1310 net365 net267 VGND VGND VPWR VPWR _00637_ sky130_fd_sc_hd__mux2_1
X_09615_ _03369_ _03370_ _03368_ VGND VGND VPWR VPWR _03371_ sky130_fd_sc_hd__o21a_1
XFILLER_55_111 VGND VGND VPWR VPWR sky130_fd_sc_hd__fill_1
X_06827_ _01376_ _01377_ net734 VGND VGND VPWR VPWR _01378_ sky130_fd_sc_hd__mux2_1
XFILLER_71_626 VGND VGND VPWR VPWR sky130_fd_sc_hd__decap_8
X_06758_ u_interface.fifo_data\[8\]\[16\] u_interface.fifo_data\[9\]\[16\] u_interface.fifo_data\[10\]\[16\]
+ u_interface.fifo_data\[11\]\[16\] net768 net751 VGND VGND VPWR VPWR _01317_ sky130_fd_sc_hd__mux4_1
X_09546_ _03271_ _03302_ VGND VGND VPWR VPWR _03303_ sky130_fd_sc_hd__nand2_1
X_09477_ _03232_ _03233_ VGND VGND VPWR VPWR _03234_ sky130_fd_sc_hd__and2b_1
XFILLER_140_6 VGND VGND VPWR VPWR sky130_fd_sc_hd__decap_6
X_06689_ u_interface.fifo_data\[0\]\[7\] u_interface.fifo_data\[1\]\[7\] u_interface.fifo_data\[2\]\[7\]
+ u_interface.fifo_data\[3\]\[7\] net766 net749 VGND VGND VPWR VPWR _01257_ sky130_fd_sc_hd__mux4_1
X_08428_ _02208_ _02217_ _02207_ VGND VGND VPWR VPWR _02219_ sky130_fd_sc_hd__a21bo_1
XTAP_TAPCELL_ROW_65_1376 VGND VPWR sky130_fd_sc_hd__tapvpwrvgnd_1
XFILLER_51_361 VGND VGND VPWR VPWR sky130_fd_sc_hd__fill_1
XFILLER_12_737 VPWR VGND VPWR VGND sky130_ef_sc_hd__decap_12
XFILLER_109_113 VPWR VGND VPWR VGND sky130_ef_sc_hd__decap_12
Xclkload1 clknet_3_1__leaf_clk VGND VGND VPWR VPWR clkload1/Y sky130_fd_sc_hd__inv_12
X_08359_ u_interface.u_gelu_fp32.s2_data\[29\] _02149_ VGND VGND VPWR VPWR _02152_
+ sky130_fd_sc_hd__or2_1
XFILLER_149_293 VGND VGND VPWR VPWR sky130_fd_sc_hd__fill_1
XFILLER_125_606 VGND VGND VPWR VPWR sky130_fd_sc_hd__fill_2
X_11370_ _04916_ _05012_ _05011_ VGND VGND VPWR VPWR _05111_ sky130_fd_sc_hd__a21boi_1
XFILLER_20_781 VPWR VGND VPWR VGND sky130_ef_sc_hd__decap_12
XFILLER_137_499 VGND VGND VPWR VPWR sky130_fd_sc_hd__decap_4
XFILLER_125_617 VPWR VGND VPWR VGND sky130_ef_sc_hd__decap_12
XFILLER_119_3 VPWR VGND VPWR VGND sky130_ef_sc_hd__decap_12
X_10321_ _04069_ _04070_ _03884_ _03886_ VGND VGND VPWR VPWR _04071_ sky130_fd_sc_hd__o211ai_1
X_13040_ clknet_leaf_37_clk _00050_ VGND VGND VPWR VPWR u_interface.fifo_tuser\[5\]
+ sky130_fd_sc_hd__dfxtp_1
X_10252_ net474 net707 net715 net478 VGND VGND VPWR VPWR _04002_ sky130_fd_sc_hd__a22o_1
XFILLER_1_3 VPWR VGND VPWR VGND sky130_ef_sc_hd__decap_12
XFILLER_120_322 VGND VGND VPWR VPWR sky130_fd_sc_hd__decap_4
X_10183_ _03932_ _03933_ VGND VGND VPWR VPWR _03934_ sky130_fd_sc_hd__and2b_1
XFILLER_78_203 VGND VGND VPWR VPWR sky130_fd_sc_hd__fill_1
Xfanout260 _01510_ VGND VGND VPWR VPWR net260 sky130_fd_sc_hd__clkbuf_4
Xfanout271 net272 VGND VGND VPWR VPWR net271 sky130_fd_sc_hd__buf_4
X_13942_ clknet_leaf_5_clk _00009_ VGND VGND VPWR VPWR u_interface.u_gelu_fp32.u_synth_top.s1_hits\[14\]
+ sky130_fd_sc_hd__dfxtp_1
XFILLER_94_729 VPWR VGND VPWR VGND sky130_ef_sc_hd__decap_12
XFILLER_93_206 VGND VGND VPWR VPWR sky130_fd_sc_hd__fill_1
Xfanout282 net283 VGND VGND VPWR VPWR net282 sky130_fd_sc_hd__buf_4
Xfanout293 _01872_ VGND VGND VPWR VPWR net293 sky130_fd_sc_hd__clkbuf_2
X_13873_ clknet_leaf_22_clk net877 VGND VGND VPWR VPWR u_interface.u_gelu_fp32.u_synth_top.s2_dx\[9\]
+ sky130_fd_sc_hd__dfxtp_1
XFILLER_74_464 VPWR VGND VPWR VGND sky130_ef_sc_hd__decap_12
XFILLER_47_689 VGND VGND VPWR VPWR sky130_fd_sc_hd__decap_4
X_12824_ net777 net83 VGND VGND VPWR VPWR _00982_ sky130_fd_sc_hd__and2_1
XFILLER_28_881 VPWR VGND VPWR VGND sky130_ef_sc_hd__decap_12
X_12755_ net781 net909 VGND VGND VPWR VPWR _00937_ sky130_fd_sc_hd__and2_1
XFILLER_61_169 VGND VGND VPWR VPWR sky130_fd_sc_hd__fill_2
XFILLER_15_553 VGND VGND VPWR VPWR sky130_fd_sc_hd__decap_6
XFILLER_15_597 VPWR VGND VPWR VGND sky130_ef_sc_hd__decap_12
X_11706_ _05439_ _05442_ VGND VGND VPWR VPWR _05443_ sky130_fd_sc_hd__xnor2_1
X_12686_ _06346_ _01742_ net329 VGND VGND VPWR VPWR _06347_ sky130_fd_sc_hd__mux2_1
XFILLER_30_589 VPWR VGND VPWR VGND sky130_ef_sc_hd__decap_12
X_11637_ _05372_ _05373_ VGND VGND VPWR VPWR _05375_ sky130_fd_sc_hd__xnor2_1
XFILLER_128_444 VGND VGND VPWR VPWR sky130_fd_sc_hd__decap_4
XFILLER_128_433 VGND VGND VPWR VPWR sky130_fd_sc_hd__fill_1
X_11568_ _05304_ _05305_ VGND VGND VPWR VPWR _05307_ sky130_fd_sc_hd__xor2_1
XFILLER_7_741 VPWR VGND VPWR VGND sky130_ef_sc_hd__decap_12
X_13307_ clknet_leaf_31_clk _00317_ VGND VGND VPWR VPWR u_interface.fifo_data\[8\]\[16\]
+ sky130_fd_sc_hd__dfxtp_1
Xhold719 u_interface.u_gelu_fp32.u_q16_to_fp32.s2_exp\[4\] VGND VGND VPWR VPWR net1584
+ sky130_fd_sc_hd__dlygate4sd3_1
X_10519_ _04265_ _04266_ _04264_ VGND VGND VPWR VPWR _04267_ sky130_fd_sc_hd__a21o_1
Xhold708 u_interface.fifo_data\[7\]\[0\] VGND VGND VPWR VPWR net1573 sky130_fd_sc_hd__dlygate4sd3_1
XFILLER_7_785 VPWR VGND VPWR VGND sky130_ef_sc_hd__decap_12
XFILLER_6_251 VGND VGND VPWR VPWR sky130_fd_sc_hd__fill_1
X_11499_ net444 net439 net719 VGND VGND VPWR VPWR _05238_ sky130_fd_sc_hd__o21ai_1
X_13238_ clknet_leaf_31_clk _00248_ VGND VGND VPWR VPWR u_interface.fifo_data\[11\]\[16\]
+ sky130_fd_sc_hd__dfxtp_1
XFILLER_108_190 VGND VGND VPWR VPWR sky130_fd_sc_hd__decap_6
X_13169_ clknet_leaf_52_clk _00179_ VGND VGND VPWR VPWR u_interface.fifo_data\[9\]\[11\]
+ sky130_fd_sc_hd__dfxtp_1
XFILLER_69_203 VGND VGND VPWR VPWR sky130_fd_sc_hd__fill_1
XFILLER_34_3 VPWR VGND VPWR VGND sky130_ef_sc_hd__decap_12
X_07730_ net1759 u_interface.u_gelu_fp32.u_q16_to_fp32.s3_norm_mag\[8\] VGND VGND
+ VPWR VPWR _01774_ sky130_fd_sc_hd__nand2_1
XFILLER_38_601 VPWR VGND VPWR VGND sky130_ef_sc_hd__decap_12
XTAP_TAPCELL_ROW_127_2369 VGND VPWR sky130_fd_sc_hd__tapvpwrvgnd_1
XFILLER_37_100 VPWR VGND VPWR VGND sky130_ef_sc_hd__decap_12
XFILLER_38_645 VGND VGND VPWR VPWR sky130_fd_sc_hd__decap_4
X_07661_ _01718_ _01743_ net307 VGND VGND VPWR VPWR _01744_ sky130_fd_sc_hd__mux2_1
X_07592_ net308 net302 _01668_ net1729 net810 VGND VGND VPWR VPWR _00466_ sky130_fd_sc_hd__a32o_1
X_09400_ _03155_ _03156_ VGND VGND VPWR VPWR _03158_ sky130_fd_sc_hd__xnor2_1
XFILLER_92_294 VPWR VGND VPWR VGND sky130_ef_sc_hd__decap_12
X_06612_ net274 VGND VGND VPWR VPWR u_interface.u_gelu_fp32.u_synth_top.comb_b\[18\]
+ sky130_fd_sc_hd__inv_2
X_09331_ _03070_ _03089_ VGND VGND VPWR VPWR _03090_ sky130_fd_sc_hd__or2_1
XTAP_TAPCELL_ROW_140_2569 VGND VPWR sky130_fd_sc_hd__tapvpwrvgnd_1
X_06543_ net535 _01139_ VGND VGND VPWR VPWR _01140_ sky130_fd_sc_hd__nor2_1
XFILLER_80_467 VGND VGND VPWR VPWR sky130_fd_sc_hd__decap_8
XTAP_TAPCELL_ROW_47_1084 VGND VPWR sky130_fd_sc_hd__tapvpwrvgnd_1
X_09262_ _03011_ _03020_ VGND VGND VPWR VPWR _03021_ sky130_fd_sc_hd__nor2_1
XTAP_TAPCELL_ROW_47_1095 VGND VPWR sky130_fd_sc_hd__tapvpwrvgnd_1
XTAP_TAPCELL_ROW_16_592 VGND VPWR sky130_fd_sc_hd__tapvpwrvgnd_1
X_09193_ _02907_ _02950_ _02949_ VGND VGND VPWR VPWR _02952_ sky130_fd_sc_hd__a21oi_1
XFILLER_119_400 VGND VGND VPWR VPWR sky130_fd_sc_hd__decap_3
X_08213_ u_interface.u_gelu_fp32.u_fp32_to_q16.s3_overflow _02043_ net539 VGND VGND
+ VPWR VPWR _02044_ sky130_fd_sc_hd__o21a_1
XFILLER_21_589 VPWR VGND VPWR VGND sky130_ef_sc_hd__decap_12
X_08144_ net291 _01985_ VGND VGND VPWR VPWR _00725_ sky130_fd_sc_hd__nor2_1
XTAP_TAPCELL_ROW_60_1295 VGND VPWR sky130_fd_sc_hd__tapvpwrvgnd_1
XFILLER_107_617 VPWR VGND VPWR VGND sky130_ef_sc_hd__decap_12
XFILLER_20_15 VPWR VGND VPWR VGND sky130_ef_sc_hd__decap_12
X_08075_ net314 _01926_ _01927_ VGND VGND VPWR VPWR _01928_ sky130_fd_sc_hd__or3_1
X_07026_ net1369 net367 net269 VGND VGND VPWR VPWR _00066_ sky130_fd_sc_hd__mux2_1
XFILLER_103_812 VPWR VGND VPWR VGND sky130_ef_sc_hd__decap_12
XFILLER_0_405 VPWR VGND VPWR VGND sky130_ef_sc_hd__decap_12
XFILLER_130_642 VGND VGND VPWR VPWR sky130_fd_sc_hd__fill_2
Xhold13 u_interface.u_gelu_fp32.u_synth_top.s1_x\[12\] VGND VGND VPWR VPWR net878
+ sky130_fd_sc_hd__dlygate4sd3_1
XFILLER_102_333 VGND VGND VPWR VPWR sky130_fd_sc_hd__decap_6
XFILLER_88_545 VPWR VGND VPWR VGND sky130_ef_sc_hd__decap_12
XFILLER_0_449 VPWR VGND VPWR VGND sky130_ef_sc_hd__decap_12
Xhold46 u_interface.u_gelu_fp32.u_q16_to_fp32.s3_valid VGND VGND VPWR VPWR net911
+ sky130_fd_sc_hd__dlygate4sd3_1
X_08977_ _02576_ _02734_ _02733_ _02716_ VGND VGND VPWR VPWR _02736_ sky130_fd_sc_hd__a211oi_1
Xhold24 u_interface.u_gelu_fp32.s1_data\[1\] VGND VGND VPWR VPWR net889 sky130_fd_sc_hd__dlygate4sd3_1
XFILLER_130_697 VGND VGND VPWR VPWR sky130_fd_sc_hd__decap_3
XFILLER_102_388 VGND VGND VPWR VPWR sky130_fd_sc_hd__fill_1
Xhold35 u_interface.u_gelu_fp32.s1_data\[19\] VGND VGND VPWR VPWR net900 sky130_fd_sc_hd__dlygate4sd3_1
XFILLER_29_57 VPWR VGND VPWR VGND sky130_ef_sc_hd__decap_12
X_07928_ u_interface.u_gelu_fp32.u_fp32_to_q16.s1_mant\[17\] u_interface.u_gelu_fp32.u_fp32_to_q16.s1_mant\[16\]
+ u_interface.u_gelu_fp32.u_fp32_to_q16.s1_mant\[19\] u_interface.u_gelu_fp32.u_fp32_to_q16.s1_mant\[18\]
+ VGND VGND VPWR VPWR _01822_ sky130_fd_sc_hd__or4_1
Xhold57 u_interface.meta_tuser_pipe\[1\] VGND VGND VPWR VPWR net922 sky130_fd_sc_hd__dlygate4sd3_1
Xhold68 u_interface.meta_tlast_pipe\[2\] VGND VGND VPWR VPWR net933 sky130_fd_sc_hd__dlygate4sd3_1
Xhold79 u_interface.meta_tuser_pipe\[7\] VGND VGND VPWR VPWR net944 sky130_fd_sc_hd__dlygate4sd3_1
XFILLER_84_740 VPWR VGND VPWR VGND sky130_ef_sc_hd__decap_12
XFILLER_68_280 VGND VGND VPWR VPWR sky130_fd_sc_hd__decap_6
XFILLER_28_122 VGND VGND VPWR VPWR sky130_fd_sc_hd__decap_3
X_07859_ net573 net1537 net285 VGND VGND VPWR VPWR _00620_ sky130_fd_sc_hd__mux2_1
XTAP_TAPCELL_ROW_67_1405 VGND VPWR sky130_fd_sc_hd__tapvpwrvgnd_1
X_10870_ _04613_ _04614_ _04597_ VGND VGND VPWR VPWR _04615_ sky130_fd_sc_hd__a21o_1
X_09529_ _03282_ _03285_ VGND VGND VPWR VPWR _03286_ sky130_fd_sc_hd__xnor2_1
XTAP_TAPCELL_ROW_80_1616 VGND VPWR sky130_fd_sc_hd__tapvpwrvgnd_1
XFILLER_25_895 VGND VGND VPWR VPWR sky130_fd_sc_hd__fill_1
XFILLER_43_169 VPWR VGND VPWR VGND sky130_ef_sc_hd__decap_12
X_12540_ _06185_ _06256_ _06254_ VGND VGND VPWR VPWR _06264_ sky130_fd_sc_hd__a21o_1
XFILLER_12_545 VPWR VGND VPWR VGND sky130_ef_sc_hd__decap_12
XTAP_TAPCELL_ROW_35_890 VGND VPWR sky130_fd_sc_hd__tapvpwrvgnd_1
XFILLER_40_832 VGND VGND VPWR VPWR sky130_fd_sc_hd__decap_6
XFILLER_129_219 VGND VGND VPWR VPWR sky130_fd_sc_hd__decap_4
X_12471_ _06195_ _06196_ VGND VGND VPWR VPWR _06197_ sky130_fd_sc_hd__and2b_1
XFILLER_12_589 VPWR VGND VPWR VGND sky130_ef_sc_hd__decap_12
XFILLER_138_753 VGND VGND VPWR VPWR sky130_fd_sc_hd__decap_3
XFILLER_138_742 VGND VGND VPWR VPWR sky130_fd_sc_hd__decap_3
X_11422_ net667 net421 _05068_ _05067_ VGND VGND VPWR VPWR _05162_ sky130_fd_sc_hd__a31o_1
X_14141_ clknet_leaf_54_clk _01067_ VGND VGND VPWR VPWR u_interface.fifo_data\[1\]\[1\]
+ sky130_fd_sc_hd__dfxtp_1
XFILLER_125_447 VGND VGND VPWR VPWR sky130_fd_sc_hd__fill_1
XTAP_TAPCELL_ROW_111_2104 VGND VPWR sky130_fd_sc_hd__tapvpwrvgnd_1
XTAP_TAPCELL_ROW_78_1578 VGND VPWR sky130_fd_sc_hd__tapvpwrvgnd_1
X_11353_ _05076_ _05093_ VGND VGND VPWR VPWR _05094_ sky130_fd_sc_hd__xnor2_2
X_14072_ clknet_leaf_16_clk net1463 VGND VGND VPWR VPWR u_interface.u_gelu_fp32.u_fp32_to_q16.s2_norm_mag\[9\]
+ sky130_fd_sc_hd__dfxtp_1
XTAP_TAPCELL_ROW_111_2115 VGND VPWR sky130_fd_sc_hd__tapvpwrvgnd_1
X_10304_ _04053_ _04052_ VGND VGND VPWR VPWR _04054_ sky130_fd_sc_hd__and2b_1
XTAP_TAPCELL_ROW_78_1589 VGND VPWR sky130_fd_sc_hd__tapvpwrvgnd_1
X_11284_ net180 _04942_ _04944_ VGND VGND VPWR VPWR _05025_ sky130_fd_sc_hd__nor3_1
XFILLER_4_755 VGND VGND VPWR VPWR sky130_fd_sc_hd__fill_1
X_10235_ _03983_ _03984_ _03978_ VGND VGND VPWR VPWR _03985_ sky130_fd_sc_hd__a21o_1
X_13023_ net170 net165 net161 net160 net151 VGND VGND VPWR VPWR _00850_ sky130_fd_sc_hd__o2111a_1
XTAP_TAPCELL_ROW_91_1789 VGND VPWR sky130_fd_sc_hd__tapvpwrvgnd_1
XFILLER_86_41 VPWR VGND VPWR VGND sky130_ef_sc_hd__decap_12
X_10166_ _03915_ _03916_ _03903_ VGND VGND VPWR VPWR _03917_ sky130_fd_sc_hd__o21ai_1
X_10097_ _03726_ _03728_ _03845_ _03846_ VGND VGND VPWR VPWR _03849_ sky130_fd_sc_hd__a211oi_2
XFILLER_19_111 VGND VGND VPWR VPWR sky130_fd_sc_hd__fill_1
XTAP_TAPCELL_ROW_109_2077 VGND VPWR sky130_fd_sc_hd__tapvpwrvgnd_1
X_13925_ clknet_leaf_6_clk net894 VGND VGND VPWR VPWR u_interface.u_gelu_fp32.u_synth_top.s1_x\[29\]
+ sky130_fd_sc_hd__dfxtp_1
XFILLER_142_80 VGND VGND VPWR VPWR sky130_fd_sc_hd__decap_4
X_13856_ clknet_leaf_88_clk _00866_ VGND VGND VPWR VPWR u_interface.u_gelu_fp32.u_synth_top.s3_b\[12\]
+ sky130_fd_sc_hd__dfxtp_1
XFILLER_19_166 VGND VGND VPWR VPWR sky130_fd_sc_hd__fill_2
XFILLER_34_103 VPWR VGND VPWR VGND sky130_ef_sc_hd__decap_12
X_12807_ net776 net85 VGND VGND VPWR VPWR _00965_ sky130_fd_sc_hd__and2_1
XFILLER_62_434 VGND VGND VPWR VPWR sky130_fd_sc_hd__fill_2
XTAP_TAPCELL_ROW_122_2288 VGND VPWR sky130_fd_sc_hd__tapvpwrvgnd_1
X_10999_ net644 net422 VGND VGND VPWR VPWR _04743_ sky130_fd_sc_hd__nand2_1
X_13787_ clknet_leaf_85_clk _00797_ VGND VGND VPWR VPWR u_interface.u_gelu_fp32.s2_data\[21\]
+ sky130_fd_sc_hd__dfxtp_1
XFILLER_43_681 VPWR VGND VPWR VGND sky130_ef_sc_hd__decap_12
XFILLER_22_309 VGND VGND VPWR VPWR sky130_fd_sc_hd__decap_4
XFILLER_31_821 VPWR VGND VPWR VGND sky130_ef_sc_hd__decap_12
X_12738_ net808 net1737 _01741_ net288 _06387_ VGND VGND VPWR VPWR _00927_ sky130_fd_sc_hd__a221o_1
XFILLER_15_383 VGND VGND VPWR VPWR sky130_fd_sc_hd__fill_1
X_12669_ net1500 u_interface.u_gelu_fp32.u_q16_to_fp32.s2_mag\[24\] net796 VGND VGND
+ VPWR VPWR _00905_ sky130_fd_sc_hd__mux2_1
XTAP_TAPCELL_ROW_13_540 VGND VPWR sky130_fd_sc_hd__tapvpwrvgnd_1
XTAP_TAPCELL_ROW_13_551 VGND VPWR sky130_fd_sc_hd__tapvpwrvgnd_1
XFILLER_31_865 VPWR VGND VPWR VGND sky130_ef_sc_hd__decap_12
XFILLER_128_241 VGND VGND VPWR VPWR sky130_fd_sc_hd__fill_2
Xhold527 u_interface.fifo_tuser\[11\] VGND VGND VPWR VPWR net1392 sky130_fd_sc_hd__dlygate4sd3_1
Xhold516 u_interface.u_gelu_fp32.u_fp32_to_q16.s3_frac\[11\] VGND VGND VPWR VPWR net1381
+ sky130_fd_sc_hd__dlygate4sd3_1
Xhold505 u_interface.fifo_data\[2\]\[1\] VGND VGND VPWR VPWR net1370 sky130_fd_sc_hd__dlygate4sd3_1
XFILLER_143_233 VPWR VGND VPWR VGND sky130_ef_sc_hd__decap_12
XFILLER_116_458 VGND VGND VPWR VPWR sky130_fd_sc_hd__fill_1
XFILLER_104_609 VPWR VGND VPWR VGND sky130_ef_sc_hd__decap_12
Xhold538 u_interface.fifo_data\[6\]\[4\] VGND VGND VPWR VPWR net1403 sky130_fd_sc_hd__dlygate4sd3_1
Xhold549 u_interface.fifo_data\[7\]\[12\] VGND VGND VPWR VPWR net1414 sky130_fd_sc_hd__dlygate4sd3_1
X_08900_ _02550_ _02553_ VGND VGND VPWR VPWR _02659_ sky130_fd_sc_hd__nand2b_1
X_09880_ _03563_ _03565_ VGND VGND VPWR VPWR _03633_ sky130_fd_sc_hd__nor2_1
X_08831_ _02580_ _02589_ VGND VGND VPWR VPWR _02590_ sky130_fd_sc_hd__nor2_1
XFILLER_106_29 VGND VGND VPWR VPWR sky130_fd_sc_hd__decap_4
XTAP_TAPCELL_ROW_142_2609 VGND VPWR sky130_fd_sc_hd__tapvpwrvgnd_1
X_08762_ net592 net599 net467 u_interface.u_gelu_fp32.u_synth_top.s2_dx\[12\] VGND
+ VGND VPWR VPWR _02521_ sky130_fd_sc_hd__nand4_1
XFILLER_111_196 VGND VGND VPWR VPWR sky130_fd_sc_hd__decap_4
XFILLER_38_431 VPWR VGND VPWR VGND sky130_ef_sc_hd__decap_12
X_08693_ _02451_ _02447_ VGND VGND VPWR VPWR _02452_ sky130_fd_sc_hd__and2b_1
X_07713_ u_interface.u_gelu_fp32.u_synth_top.s1_hits\[4\] _01753_ VGND VGND VPWR VPWR
+ _01768_ sky130_fd_sc_hd__or2_1
X_07644_ _01702_ _01730_ net306 VGND VGND VPWR VPWR _01731_ sky130_fd_sc_hd__mux2_1
XFILLER_65_272 VGND VGND VPWR VPWR sky130_fd_sc_hd__decap_8
XTAP_TAPCELL_ROW_49_1124 VGND VPWR sky130_fd_sc_hd__tapvpwrvgnd_1
XTAP_TAPCELL_ROW_49_1113 VGND VPWR sky130_fd_sc_hd__tapvpwrvgnd_1
XFILLER_26_637 VGND VGND VPWR VPWR sky130_fd_sc_hd__decap_6
XFILLER_53_445 VGND VGND VPWR VPWR sky130_fd_sc_hd__decap_3
XFILLER_25_125 VGND VGND VPWR VPWR sky130_fd_sc_hd__fill_1
X_07575_ net811 net1732 net302 _01684_ VGND VGND VPWR VPWR _00456_ sky130_fd_sc_hd__a22o_1
XFILLER_80_253 VGND VGND VPWR VPWR sky130_fd_sc_hd__decap_4
XFILLER_15_15 VPWR VGND VPWR VGND sky130_ef_sc_hd__decap_12
XFILLER_25_169 VGND VGND VPWR VPWR sky130_fd_sc_hd__decap_6
XFILLER_40_117 VGND VGND VPWR VPWR sky130_fd_sc_hd__fill_2
XFILLER_41_629 VGND VGND VPWR VPWR sky130_fd_sc_hd__decap_6
X_06526_ _01116_ _01121_ VGND VGND VPWR VPWR _01126_ sky130_fd_sc_hd__nor2_1
X_09314_ _03063_ _03072_ VGND VGND VPWR VPWR _03073_ sky130_fd_sc_hd__nor2_1
XTAP_TAPCELL_ROW_62_1335 VGND VPWR sky130_fd_sc_hd__tapvpwrvgnd_1
XTAP_TAPCELL_ROW_62_1324 VGND VPWR sky130_fd_sc_hd__tapvpwrvgnd_1
XFILLER_34_681 VPWR VGND VPWR VGND sky130_ef_sc_hd__decap_12
XFILLER_40_139 VGND VGND VPWR VPWR sky130_fd_sc_hd__fill_1
X_09245_ _02960_ _02999_ _03001_ _03003_ VGND VGND VPWR VPWR _03004_ sky130_fd_sc_hd__a211o_1
XFILLER_139_517 VGND VGND VPWR VPWR sky130_fd_sc_hd__fill_2
XFILLER_21_331 VGND VGND VPWR VPWR sky130_fd_sc_hd__fill_2
XFILLER_33_191 VGND VGND VPWR VPWR sky130_fd_sc_hd__decap_6
XFILLER_147_561 VGND VGND VPWR VPWR sky130_fd_sc_hd__decap_4
X_09176_ _02925_ _02934_ VGND VGND VPWR VPWR _02935_ sky130_fd_sc_hd__nor2_1
XFILLER_119_263 VGND VGND VPWR VPWR sky130_fd_sc_hd__fill_1
X_08127_ u_interface.u_gelu_fp32.u_fp32_to_q16.s3_mag\[13\] _01881_ VGND VGND VPWR
+ VPWR _01971_ sky130_fd_sc_hd__xor2_1
XFILLER_110_7 VGND VGND VPWR VPWR sky130_fd_sc_hd__fill_1
XFILLER_31_69 VPWR VGND VPWR VGND sky130_ef_sc_hd__decap_12
XFILLER_150_715 VGND VGND VPWR VPWR sky130_fd_sc_hd__fill_1
XFILLER_134_244 VGND VGND VPWR VPWR sky130_fd_sc_hd__decap_8
X_08058_ _01913_ u_interface.u_gelu_fp32.u_fp32_to_q16.s3_mag\[1\] _01911_ VGND VGND
+ VPWR VPWR _01914_ sky130_fd_sc_hd__mux2_1
X_07009_ _01504_ _01512_ VGND VGND VPWR VPWR _01522_ sky130_fd_sc_hd__nor2_2
XFILLER_134_288 VGND VGND VPWR VPWR sky130_fd_sc_hd__fill_1
XFILLER_103_653 VGND VGND VPWR VPWR sky130_fd_sc_hd__decap_4
X_10020_ _03759_ _03769_ _03770_ VGND VGND VPWR VPWR _03772_ sky130_fd_sc_hd__and3_1
Xinput103 s_axis_tdata[7] VGND VGND VPWR VPWR net103 sky130_fd_sc_hd__clkbuf_1
XFILLER_102_141 VGND VGND VPWR VPWR sky130_fd_sc_hd__decap_6
XFILLER_76_515 VPWR VGND VPWR VGND sky130_ef_sc_hd__decap_12
XTAP_TAPCELL_ROW_73_1497 VGND VPWR sky130_fd_sc_hd__tapvpwrvgnd_1
XFILLER_130_494 VPWR VGND VPWR VGND sky130_ef_sc_hd__decap_12
XFILLER_56_66 VGND VGND VPWR VPWR sky130_fd_sc_hd__fill_1
X_11971_ _05660_ _05704_ VGND VGND VPWR VPWR _05705_ sky130_fd_sc_hd__xnor2_1
X_13710_ clknet_leaf_2_clk _00720_ VGND VGND VPWR VPWR u_interface.u_gelu_fp32.s1_data\[10\]
+ sky130_fd_sc_hd__dfxtp_1
XFILLER_91_529 VGND VGND VPWR VPWR sky130_fd_sc_hd__fill_1
X_10922_ _04664_ _04665_ VGND VGND VPWR VPWR _04667_ sky130_fd_sc_hd__xnor2_1
XFILLER_17_615 VGND VGND VPWR VPWR sky130_fd_sc_hd__fill_1
XFILLER_29_475 VGND VGND VPWR VPWR sky130_fd_sc_hd__decap_4
XFILLER_44_456 VGND VGND VPWR VPWR sky130_fd_sc_hd__decap_3
X_13641_ clknet_leaf_46_clk _00651_ VGND VGND VPWR VPWR u_interface.fifo_data\[13\]\[24\]
+ sky130_fd_sc_hd__dfxtp_1
X_10853_ net668 net677 net443 net438 VGND VGND VPWR VPWR _04598_ sky130_fd_sc_hd__and4_1
X_13572_ clknet_leaf_42_clk _00582_ VGND VGND VPWR VPWR u_interface.fifo_data\[4\]\[19\]
+ sky130_fd_sc_hd__dfxtp_1
X_10784_ _04528_ _04529_ VGND VGND VPWR VPWR _04530_ sky130_fd_sc_hd__nor2_1
XFILLER_13_821 VPWR VGND VPWR VGND sky130_ef_sc_hd__decap_12
XFILLER_12_353 VGND VGND VPWR VPWR sky130_fd_sc_hd__decap_4
XFILLER_13_865 VPWR VGND VPWR VGND sky130_ef_sc_hd__decap_12
X_12523_ _06215_ _06219_ _06217_ VGND VGND VPWR VPWR _06248_ sky130_fd_sc_hd__o21ai_1
XTAP_TAPCELL_ROW_30_808 VGND VPWR sky130_fd_sc_hd__tapvpwrvgnd_1
XTAP_TAPCELL_ROW_30_819 VGND VPWR sky130_fd_sc_hd__tapvpwrvgnd_1
XFILLER_126_712 VGND VGND VPWR VPWR sky130_fd_sc_hd__decap_6
X_12454_ net182 _06128_ _06127_ VGND VGND VPWR VPWR _06180_ sky130_fd_sc_hd__a21o_1
XFILLER_125_200 VGND VGND VPWR VPWR sky130_fd_sc_hd__fill_2
X_11405_ net720 net444 net439 net711 VGND VGND VPWR VPWR _05145_ sky130_fd_sc_hd__a22o_1
X_12385_ _06112_ _06067_ VGND VGND VPWR VPWR _06113_ sky130_fd_sc_hd__nand2b_1
X_14124_ clknet_leaf_32_clk _01050_ VGND VGND VPWR VPWR u_interface.fifo_wr_ptr\[1\]
+ sky130_fd_sc_hd__dfxtp_1
XTAP_TAPCELL_ROW_93_1829 VGND VPWR sky130_fd_sc_hd__tapvpwrvgnd_1
XTAP_TAPCELL_ROW_93_1818 VGND VPWR sky130_fd_sc_hd__tapvpwrvgnd_1
X_11336_ net642 net406 VGND VGND VPWR VPWR _05077_ sky130_fd_sc_hd__nand2_1
X_14055_ clknet_leaf_16_clk _00981_ VGND VGND VPWR VPWR u_interface.u_gelu_fp32.u_fp32_to_q16.s1_mant\[17\]
+ sky130_fd_sc_hd__dfxtp_1
XFILLER_125_266 VGND VGND VPWR VPWR sky130_fd_sc_hd__fill_1
XFILLER_98_117 VGND VGND VPWR VPWR sky130_fd_sc_hd__fill_1
X_13006_ net1006 net578 net224 VGND VGND VPWR VPWR _01089_ sky130_fd_sc_hd__mux2_1
XFILLER_97_73 VGND VGND VPWR VPWR sky130_fd_sc_hd__fill_1
X_11267_ _04925_ _05008_ VGND VGND VPWR VPWR _05009_ sky130_fd_sc_hd__xnor2_1
X_10218_ _03741_ _03745_ _03859_ _03968_ VGND VGND VPWR VPWR _03969_ sky130_fd_sc_hd__a31oi_4
X_11198_ net206 _04938_ VGND VGND VPWR VPWR _04940_ sky130_fd_sc_hd__xor2_1
XFILLER_95_835 VGND VGND VPWR VPWR sky130_fd_sc_hd__decap_4
X_10149_ _03896_ _03897_ _03898_ VGND VGND VPWR VPWR _03900_ sky130_fd_sc_hd__a21o_1
XFILLER_79_397 VPWR VGND VPWR VGND sky130_ef_sc_hd__decap_12
XFILLER_67_559 VGND VGND VPWR VPWR sky130_fd_sc_hd__fill_1
XTAP_TAPCELL_ROW_124_2317 VGND VPWR sky130_fd_sc_hd__tapvpwrvgnd_1
XFILLER_48_773 VGND VGND VPWR VPWR sky130_fd_sc_hd__fill_1
XFILLER_36_902 VGND VGND VPWR VPWR sky130_fd_sc_hd__decap_8
X_13908_ clknet_leaf_2_clk net893 VGND VGND VPWR VPWR u_interface.u_gelu_fp32.u_synth_top.s1_x\[12\]
+ sky130_fd_sc_hd__dfxtp_1
XTAP_TAPCELL_ROW_18_621 VGND VPWR sky130_fd_sc_hd__tapvpwrvgnd_1
XFILLER_35_445 VGND VGND VPWR VPWR sky130_fd_sc_hd__decap_3
XFILLER_90_562 VGND VGND VPWR VPWR sky130_fd_sc_hd__fill_1
XFILLER_62_253 VPWR VGND VPWR VGND sky130_ef_sc_hd__decap_12
X_13839_ clknet_leaf_78_clk _00849_ VGND VGND VPWR VPWR u_interface.u_gelu_fp32.u_synth_top.s3_mult\[57\]
+ sky130_fd_sc_hd__dfxtp_1
XFILLER_23_629 VPWR VGND VPWR VGND sky130_ef_sc_hd__decap_12
X_07360_ net573 net1601 net244 VGND VGND VPWR VPWR _00390_ sky130_fd_sc_hd__mux2_1
XTAP_TAPCELL_ROW_44_1032 VGND VPWR sky130_fd_sc_hd__tapvpwrvgnd_1
XFILLER_16_681 VPWR VGND VPWR VGND sky130_ef_sc_hd__decap_12
XFILLER_22_139 VGND VGND VPWR VPWR sky130_fd_sc_hd__fill_1
XFILLER_149_837 VGND VGND VPWR VPWR sky130_fd_sc_hd__decap_3
XTAP_TAPCELL_ROW_102_1969 VGND VPWR sky130_fd_sc_hd__tapvpwrvgnd_1
XTAP_TAPCELL_ROW_44_1043 VGND VPWR sky130_fd_sc_hd__tapvpwrvgnd_1
X_09030_ _02786_ _02787_ _02785_ VGND VGND VPWR VPWR _02789_ sky130_fd_sc_hd__o21bai_1
XTAP_TAPCELL_ROW_139_2560 VGND VPWR sky130_fd_sc_hd__tapvpwrvgnd_1
X_07291_ net1051 net345 net245 VGND VGND VPWR VPWR _00321_ sky130_fd_sc_hd__mux2_1
XFILLER_31_673 VPWR VGND VPWR VGND sky130_ef_sc_hd__decap_12
XFILLER_136_509 VGND VGND VPWR VPWR sky130_fd_sc_hd__decap_8
XFILLER_129_561 VGND VGND VPWR VPWR sky130_fd_sc_hd__fill_1
XTAP_TAPCELL_ROW_152_2760 VGND VPWR sky130_fd_sc_hd__tapvpwrvgnd_1
XFILLER_144_531 VGND VGND VPWR VPWR sky130_fd_sc_hd__fill_1
Xhold302 u_interface.fifo_data\[15\]\[17\] VGND VGND VPWR VPWR net1167 sky130_fd_sc_hd__dlygate4sd3_1
XTAP_TAPCELL_ROW_152_2771 VGND VPWR sky130_fd_sc_hd__tapvpwrvgnd_1
Xhold313 _00997_ VGND VGND VPWR VPWR net1178 sky130_fd_sc_hd__dlygate4sd3_1
Xhold324 u_interface.fifo_tlast\[15\] VGND VGND VPWR VPWR net1189 sky130_fd_sc_hd__dlygate4sd3_1
XFILLER_144_564 VGND VGND VPWR VPWR sky130_fd_sc_hd__decap_8
XFILLER_105_918 VGND VGND VPWR VPWR sky130_fd_sc_hd__decap_3
Xhold335 u_interface.fifo_data\[5\]\[20\] VGND VGND VPWR VPWR net1200 sky130_fd_sc_hd__dlygate4sd3_1
XFILLER_7_93 VPWR VGND VPWR VGND sky130_ef_sc_hd__decap_12
XFILLER_132_726 VGND VGND VPWR VPWR sky130_fd_sc_hd__decap_8
XFILLER_131_203 VGND VGND VPWR VPWR sky130_fd_sc_hd__fill_1
Xhold357 u_interface.fifo_data\[7\]\[18\] VGND VGND VPWR VPWR net1222 sky130_fd_sc_hd__dlygate4sd3_1
X_09932_ _03574_ _03683_ VGND VGND VPWR VPWR _03685_ sky130_fd_sc_hd__and2_1
Xhold368 u_interface.fifo_data\[2\]\[12\] VGND VGND VPWR VPWR net1233 sky130_fd_sc_hd__dlygate4sd3_1
Xhold346 u_interface.fifo_data\[10\]\[20\] VGND VGND VPWR VPWR net1211 sky130_fd_sc_hd__dlygate4sd3_1
XFILLER_131_225 VGND VGND VPWR VPWR sky130_fd_sc_hd__fill_2
Xfanout815 net816 VGND VGND VPWR VPWR net815 sky130_fd_sc_hd__buf_2
XFILLER_98_640 VGND VGND VPWR VPWR sky130_fd_sc_hd__decap_4
XFILLER_89_139 VGND VGND VPWR VPWR sky130_fd_sc_hd__decap_8
Xfanout804 net809 VGND VGND VPWR VPWR net804 sky130_fd_sc_hd__clkbuf_2
Xhold379 u_interface.fifo_data\[4\]\[9\] VGND VGND VPWR VPWR net1244 sky130_fd_sc_hd__dlygate4sd3_1
Xfanout826 net830 VGND VGND VPWR VPWR net826 sky130_fd_sc_hd__clkbuf_2
X_09863_ _03464_ _03614_ _03615_ VGND VGND VPWR VPWR _03617_ sky130_fd_sc_hd__and3_1
XFILLER_98_662 VGND VGND VPWR VPWR sky130_fd_sc_hd__decap_3
X_08814_ _02566_ _02571_ _02572_ VGND VGND VPWR VPWR _02573_ sky130_fd_sc_hd__nand3_1
X_09794_ _03546_ _03547_ _03543_ VGND VGND VPWR VPWR _03548_ sky130_fd_sc_hd__a21o_1
X_08745_ net613 net485 VGND VGND VPWR VPWR _02504_ sky130_fd_sc_hd__nand2_1
XFILLER_85_345 VGND VGND VPWR VPWR sky130_fd_sc_hd__fill_1
XFILLER_38_250 VGND VGND VPWR VPWR sky130_fd_sc_hd__fill_2
XFILLER_26_445 VPWR VGND VPWR VGND sky130_ef_sc_hd__decap_12
X_08676_ _02335_ _02436_ VGND VGND VPWR VPWR _02437_ sky130_fd_sc_hd__nor2_1
XTAP_TAPCELL_ROW_37_930 VGND VPWR sky130_fd_sc_hd__tapvpwrvgnd_1
X_07627_ _01717_ VGND VGND VPWR VPWR _01718_ sky130_fd_sc_hd__inv_2
X_07558_ _01671_ _01672_ net309 VGND VGND VPWR VPWR _01673_ sky130_fd_sc_hd__mux2_1
X_06509_ net541 VGND VGND VPWR VPWR _01109_ sky130_fd_sc_hd__inv_2
X_07489_ _01592_ _01570_ net555 VGND VGND VPWR VPWR _01622_ sky130_fd_sc_hd__mux2_1
XFILLER_10_813 VPWR VGND VPWR VGND sky130_ef_sc_hd__decap_12
XFILLER_155_818 VGND VGND VPWR VPWR sky130_fd_sc_hd__decap_4
XFILLER_154_317 VGND VGND VPWR VPWR sky130_fd_sc_hd__fill_2
X_09228_ _02945_ _02964_ _02985_ VGND VGND VPWR VPWR _02987_ sky130_fd_sc_hd__a21o_1
X_09159_ _02899_ _02900_ _02902_ VGND VGND VPWR VPWR _02918_ sky130_fd_sc_hd__a21o_1
XFILLER_147_380 VGND VGND VPWR VPWR sky130_fd_sc_hd__decap_6
XFILLER_135_520 VGND VGND VPWR VPWR sky130_fd_sc_hd__decap_3
XFILLER_5_305 VPWR VGND VPWR VGND sky130_ef_sc_hd__decap_12
XFILLER_107_222 VGND VGND VPWR VPWR sky130_fd_sc_hd__fill_2
X_12170_ _05898_ _05899_ VGND VGND VPWR VPWR _05901_ sky130_fd_sc_hd__xor2_1
XFILLER_101_3 VGND VGND VPWR VPWR sky130_fd_sc_hd__decap_4
XTAP_TAPCELL_ROW_75_1537 VGND VPWR sky130_fd_sc_hd__tapvpwrvgnd_1
X_11121_ net625 net408 VGND VGND VPWR VPWR _04864_ sky130_fd_sc_hd__nand2_1
Xhold880 u_interface.u_gelu_fp32.u_fp32_to_q16.s3_frac\[27\] VGND VGND VPWR VPWR net1745
+ sky130_fd_sc_hd__dlygate4sd3_1
Xhold891 u_interface.u_gelu_fp32.s1_data\[31\] VGND VGND VPWR VPWR net1756 sky130_fd_sc_hd__dlygate4sd3_1
XFILLER_150_589 VGND VGND VPWR VPWR sky130_fd_sc_hd__decap_8
X_11052_ _04681_ _04682_ _04692_ _04691_ VGND VGND VPWR VPWR _04795_ sky130_fd_sc_hd__a31o_1
XFILLER_103_483 VPWR VGND VPWR VGND sky130_ef_sc_hd__decap_12
X_10003_ _03687_ _03719_ _03720_ VGND VGND VPWR VPWR _03755_ sky130_fd_sc_hd__a21bo_1
XFILLER_49_548 VGND VGND VPWR VPWR sky130_fd_sc_hd__fill_1
XFILLER_130_291 VPWR VGND VPWR VGND sky130_ef_sc_hd__decap_12
XFILLER_77_868 VGND VGND VPWR VPWR sky130_fd_sc_hd__fill_1
XFILLER_123_71 VGND VGND VPWR VPWR sky130_fd_sc_hd__decap_3
XTAP_TAPCELL_ROW_106_2036 VGND VPWR sky130_fd_sc_hd__tapvpwrvgnd_1
XTAP_TAPCELL_ROW_106_2025 VGND VPWR sky130_fd_sc_hd__tapvpwrvgnd_1
XTAP_TAPCELL_ROW_4_393 VGND VPWR sky130_fd_sc_hd__tapvpwrvgnd_1
XFILLER_91_337 VGND VGND VPWR VPWR sky130_fd_sc_hd__fill_2
X_11954_ _05683_ _05687_ VGND VGND VPWR VPWR _05688_ sky130_fd_sc_hd__xnor2_1
X_10905_ _04595_ _04596_ _04647_ _04648_ VGND VGND VPWR VPWR _04650_ sky130_fd_sc_hd__or4bb_1
XFILLER_44_253 VGND VGND VPWR VPWR sky130_fd_sc_hd__fill_2
X_11885_ _05617_ _05618_ VGND VGND VPWR VPWR _05620_ sky130_fd_sc_hd__xnor2_1
X_13624_ clknet_leaf_41_clk _00634_ VGND VGND VPWR VPWR u_interface.fifo_data\[13\]\[7\]
+ sky130_fd_sc_hd__dfxtp_1
XFILLER_60_757 VGND VGND VPWR VPWR sky130_fd_sc_hd__fill_1
X_10836_ net452 net456 net695 net704 VGND VGND VPWR VPWR _04581_ sky130_fd_sc_hd__and4_1
XFILLER_44_297 VGND VGND VPWR VPWR sky130_fd_sc_hd__decap_4
X_10767_ net595 net404 net400 net586 VGND VGND VPWR VPWR _04513_ sky130_fd_sc_hd__a22oi_1
X_13555_ clknet_leaf_69_clk _00565_ VGND VGND VPWR VPWR u_interface.fifo_data\[4\]\[2\]
+ sky130_fd_sc_hd__dfxtp_1
XFILLER_8_121 VPWR VGND VPWR VGND sky130_ef_sc_hd__decap_12
XFILLER_13_673 VPWR VGND VPWR VGND sky130_ef_sc_hd__decap_12
XPHY_EDGE_ROW_143_Left_299 VGND VGND VPWR VPWR sky130_fd_sc_hd__decap_3
X_13486_ clknet_leaf_4_clk _00496_ VGND VGND VPWR VPWR u_interface.u_gelu_fp32.u_synth_top.s2_b\[7\]
+ sky130_fd_sc_hd__dfxtp_1
X_10698_ _04342_ _04369_ _04370_ VGND VGND VPWR VPWR _04444_ sky130_fd_sc_hd__a21bo_1
X_12506_ _06229_ _06230_ VGND VGND VPWR VPWR _06231_ sky130_fd_sc_hd__or2_1
XFILLER_8_165 VPWR VGND VPWR VGND sky130_ef_sc_hd__decap_12
X_12437_ _06163_ _06124_ VGND VGND VPWR VPWR _06164_ sky130_fd_sc_hd__nand2b_1
X_14107_ clknet_leaf_29_clk _01033_ VGND VGND VPWR VPWR u_interface.meta_tuser_pipe\[0\]
+ sky130_fd_sc_hd__dfxtp_1
XFILLER_126_564 VPWR VGND VPWR VGND sky130_ef_sc_hd__decap_12
X_12368_ _06019_ _06094_ VGND VGND VPWR VPWR _06096_ sky130_fd_sc_hd__xor2_1
X_11319_ _04973_ _04977_ _05059_ VGND VGND VPWR VPWR _05060_ sky130_fd_sc_hd__and3_1
X_12299_ _06025_ _06026_ VGND VGND VPWR VPWR _06028_ sky130_fd_sc_hd__xor2_1
X_14038_ clknet_leaf_15_clk _00964_ VGND VGND VPWR VPWR u_interface.u_gelu_fp32.u_fp32_to_q16.s1_mant\[0\]
+ sky130_fd_sc_hd__dfxtp_1
X_06860_ _01402_ _01403_ _01406_ net319 VGND VGND VPWR VPWR net129 sky130_fd_sc_hd__a22o_1
XFILLER_95_632 VGND VGND VPWR VPWR sky130_fd_sc_hd__fill_1
X_06791_ net320 _01345_ VGND VGND VPWR VPWR _01346_ sky130_fd_sc_hd__or2_1
XFILLER_55_529 VPWR VGND VPWR VGND sky130_ef_sc_hd__decap_12
XFILLER_94_197 VGND VGND VPWR VPWR sky130_fd_sc_hd__decap_3
X_08530_ _02299_ _02320_ _02304_ _02297_ VGND VGND VPWR VPWR _02321_ sky130_fd_sc_hd__o211a_1
X_08461_ _02249_ _02251_ _02242_ _02246_ VGND VGND VPWR VPWR _02252_ sky130_fd_sc_hd__o211a_1
XFILLER_24_905 VPWR VGND VPWR VGND sky130_ef_sc_hd__decap_12
X_07412_ _01546_ _01547_ net554 VGND VGND VPWR VPWR _01548_ sky130_fd_sc_hd__mux2_1
XFILLER_51_724 VGND VGND VPWR VPWR sky130_fd_sc_hd__decap_4
XFILLER_23_437 VGND VGND VPWR VPWR sky130_fd_sc_hd__decap_8
X_08392_ u_interface.u_gelu_fp32.u_synth_top.s3_mult\[29\] u_interface.u_gelu_fp32.u_synth_top.s3_b\[13\]
+ VGND VGND VPWR VPWR _02183_ sky130_fd_sc_hd__nand2_1
XTAP_TAPCELL_ROW_154_2800 VGND VPWR sky130_fd_sc_hd__tapvpwrvgnd_1
X_07343_ net369 net1547 net241 VGND VGND VPWR VPWR _00373_ sky130_fd_sc_hd__mux2_1
XFILLER_10_109 VPWR VGND VPWR VGND sky130_ef_sc_hd__decap_12
X_07274_ net1164 net378 net245 VGND VGND VPWR VPWR _00304_ sky130_fd_sc_hd__mux2_1
XFILLER_12_27 VGND VGND VPWR VPWR sky130_fd_sc_hd__fill_1
X_09013_ net613 net497 VGND VGND VPWR VPWR _02772_ sky130_fd_sc_hd__nand2_1
XFILLER_117_520 VGND VGND VPWR VPWR sky130_fd_sc_hd__decap_8
XFILLER_151_309 VGND VGND VPWR VPWR sky130_fd_sc_hd__fill_1
XFILLER_129_391 VGND VGND VPWR VPWR sky130_fd_sc_hd__fill_1
Xhold110 u_interface.u_gelu_fp32.u_fp32_to_q16.s3_frac\[24\] VGND VGND VPWR VPWR net975
+ sky130_fd_sc_hd__dlygate4sd3_1
XFILLER_3_809 VPWR VGND VPWR VGND sky130_ef_sc_hd__decap_12
Xhold143 u_interface.fifo_data\[1\]\[28\] VGND VGND VPWR VPWR net1008 sky130_fd_sc_hd__dlygate4sd3_1
XFILLER_144_372 VGND VGND VPWR VPWR sky130_fd_sc_hd__decap_8
XFILLER_144_361 VGND VGND VPWR VPWR sky130_fd_sc_hd__decap_3
Xhold132 u_interface.fifo_data\[5\]\[17\] VGND VGND VPWR VPWR net997 sky130_fd_sc_hd__dlygate4sd3_1
XFILLER_117_597 VPWR VGND VPWR VGND sky130_ef_sc_hd__decap_12
Xhold121 u_interface.fifo_data\[15\]\[5\] VGND VGND VPWR VPWR net986 sky130_fd_sc_hd__dlygate4sd3_1
XTAP_TAPCELL_ROW_57_1245 VGND VPWR sky130_fd_sc_hd__tapvpwrvgnd_1
Xhold176 u_interface.fifo_data\[6\]\[14\] VGND VGND VPWR VPWR net1041 sky130_fd_sc_hd__dlygate4sd3_1
Xhold154 u_interface.fifo_data\[9\]\[24\] VGND VGND VPWR VPWR net1019 sky130_fd_sc_hd__dlygate4sd3_1
Xhold165 u_interface.fifo_data\[13\]\[27\] VGND VGND VPWR VPWR net1030 sky130_fd_sc_hd__dlygate4sd3_1
Xhold198 u_interface.fifo_data\[5\]\[26\] VGND VGND VPWR VPWR net1063 sky130_fd_sc_hd__dlygate4sd3_1
Xhold187 u_interface.fifo_data\[12\]\[26\] VGND VGND VPWR VPWR net1052 sky130_fd_sc_hd__dlygate4sd3_1
Xfanout623 net624 VGND VGND VPWR VPWR net623 sky130_fd_sc_hd__buf_2
XFILLER_120_729 VGND VGND VPWR VPWR sky130_fd_sc_hd__decap_3
Xfanout612 net616 VGND VGND VPWR VPWR net612 sky130_fd_sc_hd__clkbuf_4
Xfanout601 u_interface.u_gelu_fp32.u_synth_top.s2_m\[2\] VGND VGND VPWR VPWR net601
+ sky130_fd_sc_hd__buf_2
X_09915_ _03559_ _03561_ _03665_ _03666_ VGND VGND VPWR VPWR _03668_ sky130_fd_sc_hd__a211oi_1
X_09846_ net463 net641 _03597_ _03598_ VGND VGND VPWR VPWR _03600_ sky130_fd_sc_hd__nand4_1
Xfanout656 net657 VGND VGND VPWR VPWR net656 sky130_fd_sc_hd__buf_2
XFILLER_86_610 VGND VGND VPWR VPWR sky130_fd_sc_hd__decap_3
Xfanout645 u_interface.u_gelu_fp32.u_synth_top.s2_m\[8\] VGND VGND VPWR VPWR net645
+ sky130_fd_sc_hd__dlymetal6s2s_1
XTAP_TAPCELL_ROW_70_1456 VGND VPWR sky130_fd_sc_hd__tapvpwrvgnd_1
Xfanout634 net636 VGND VGND VPWR VPWR net634 sky130_fd_sc_hd__buf_1
Xfanout667 net674 VGND VGND VPWR VPWR net667 sky130_fd_sc_hd__clkbuf_2
Xfanout689 net691 VGND VGND VPWR VPWR net689 sky130_fd_sc_hd__clkbuf_4
XFILLER_86_654 VGND VGND VPWR VPWR sky130_fd_sc_hd__fill_1
XFILLER_85_131 VGND VGND VPWR VPWR sky130_fd_sc_hd__fill_1
XFILLER_74_805 VGND VGND VPWR VPWR sky130_fd_sc_hd__decap_6
Xfanout678 net683 VGND VGND VPWR VPWR net678 sky130_fd_sc_hd__clkbuf_2
X_06989_ _01501_ _01509_ VGND VGND VPWR VPWR _01511_ sky130_fd_sc_hd__nor2_2
X_09777_ net216 _03477_ _03476_ VGND VGND VPWR VPWR _03531_ sky130_fd_sc_hd__a21oi_1
XFILLER_73_326 VGND VGND VPWR VPWR sky130_fd_sc_hd__decap_6
XFILLER_27_721 VGND VGND VPWR VPWR sky130_fd_sc_hd__decap_6
XFILLER_37_57 VGND VGND VPWR VPWR sky130_fd_sc_hd__decap_4
X_08728_ net629 net638 net488 net493 VGND VGND VPWR VPWR _02487_ sky130_fd_sc_hd__and4_1
XFILLER_73_337 VGND VGND VPWR VPWR sky130_fd_sc_hd__fill_1
XTAP_TAPCELL_ROW_1_352 VGND VPWR sky130_fd_sc_hd__tapvpwrvgnd_1
X_08659_ net152 _02424_ net793 VGND VGND VPWR VPWR _00801_ sky130_fd_sc_hd__a21oi_1
XFILLER_26_253 VGND VGND VPWR VPWR sky130_fd_sc_hd__fill_2
XFILLER_27_765 VPWR VGND VPWR VGND sky130_ef_sc_hd__decap_12
XFILLER_26_297 VGND VGND VPWR VPWR sky130_fd_sc_hd__decap_8
X_11670_ _05224_ _05322_ _05405_ VGND VGND VPWR VPWR _05407_ sky130_fd_sc_hd__o21ai_2
XFILLER_139_111 VGND VGND VPWR VPWR sky130_fd_sc_hd__fill_1
X_10621_ _04367_ VGND VGND VPWR VPWR _04368_ sky130_fd_sc_hd__inv_2
XFILLER_53_89 VPWR VGND VPWR VGND sky130_ef_sc_hd__decap_12
XFILLER_22_470 VGND VGND VPWR VPWR sky130_fd_sc_hd__decap_6
XFILLER_41_278 VGND VGND VPWR VPWR sky130_fd_sc_hd__fill_2
XFILLER_155_615 VGND VGND VPWR VPWR sky130_fd_sc_hd__fill_1
XFILLER_128_807 VGND VGND VPWR VPWR sky130_fd_sc_hd__decap_4
X_13340_ clknet_leaf_53_clk _00350_ VGND VGND VPWR VPWR u_interface.fifo_data\[10\]\[17\]
+ sky130_fd_sc_hd__dfxtp_1
X_10552_ _04256_ _04257_ _04296_ _04297_ VGND VGND VPWR VPWR _04300_ sky130_fd_sc_hd__and4_2
XFILLER_10_643 VGND VGND VPWR VPWR sky130_fd_sc_hd__fill_1
XTAP_TAPCELL_ROW_40_969 VGND VPWR sky130_fd_sc_hd__tapvpwrvgnd_1
X_13271_ clknet_leaf_26_clk _00281_ VGND VGND VPWR VPWR u_interface.fifo_data\[0\]\[13\]
+ sky130_fd_sc_hd__dfxtp_1
XFILLER_6_625 VPWR VGND VPWR VGND sky130_ef_sc_hd__decap_12
XFILLER_5_113 VPWR VGND VPWR VGND sky130_ef_sc_hd__decap_12
XTAP_TAPCELL_ROW_20_660 VGND VPWR sky130_fd_sc_hd__tapvpwrvgnd_1
XFILLER_108_553 VPWR VGND VPWR VGND sky130_ef_sc_hd__decap_12
X_10483_ _04227_ _04228_ _04229_ VGND VGND VPWR VPWR _04231_ sky130_fd_sc_hd__or3_1
XFILLER_6_669 VPWR VGND VPWR VGND sky130_ef_sc_hd__decap_12
X_12222_ _05662_ _05951_ VGND VGND VPWR VPWR _05952_ sky130_fd_sc_hd__xnor2_1
XFILLER_142_309 VPWR VGND VPWR VGND sky130_ef_sc_hd__decap_12
X_12153_ _05745_ _05883_ VGND VGND VPWR VPWR _05884_ sky130_fd_sc_hd__nand2_1
X_11104_ _04846_ VGND VGND VPWR VPWR _04847_ sky130_fd_sc_hd__inv_2
XTAP_TAPCELL_ROW_9_485 VGND VPWR sky130_fd_sc_hd__tapvpwrvgnd_1
XTAP_TAPCELL_ROW_9_474 VGND VPWR sky130_fd_sc_hd__tapvpwrvgnd_1
X_12084_ _05752_ _05754_ _05751_ VGND VGND VPWR VPWR _05816_ sky130_fd_sc_hd__o21bai_1
X_11035_ _04696_ _04778_ VGND VGND VPWR VPWR _04779_ sky130_fd_sc_hd__xnor2_1
XFILLER_49_312 VPWR VGND VPWR VGND sky130_ef_sc_hd__decap_12
XFILLER_1_385 VGND VGND VPWR VPWR sky130_fd_sc_hd__decap_6
XFILLER_49_356 VPWR VGND VPWR VGND sky130_ef_sc_hd__decap_12
XTAP_TAPCELL_ROW_88_1739 VGND VPWR sky130_fd_sc_hd__tapvpwrvgnd_1
XFILLER_76_153 VGND VGND VPWR VPWR sky130_fd_sc_hd__decap_8
XFILLER_64_326 VGND VGND VPWR VPWR sky130_fd_sc_hd__decap_4
XFILLER_94_85 VGND VGND VPWR VPWR sky130_fd_sc_hd__fill_2
XFILLER_64_359 VGND VGND VPWR VPWR sky130_fd_sc_hd__decap_4
X_12986_ net1237 net379 net221 VGND VGND VPWR VPWR _01069_ sky130_fd_sc_hd__mux2_1
XFILLER_91_167 VGND VGND VPWR VPWR sky130_fd_sc_hd__fill_1
X_11937_ net709 net721 net415 net411 VGND VGND VPWR VPWR _05671_ sky130_fd_sc_hd__nand4_1
XTAP_TAPCELL_ROW_28_782 VGND VPWR sky130_fd_sc_hd__tapvpwrvgnd_1
X_11868_ _05601_ _05602_ VGND VGND VPWR VPWR _05603_ sky130_fd_sc_hd__nor2_1
XPHY_EDGE_ROW_151_Left_307 VGND VGND VPWR VPWR sky130_fd_sc_hd__decap_3
X_13607_ clknet_leaf_35_clk _00617_ VGND VGND VPWR VPWR u_interface.fifo_data\[3\]\[22\]
+ sky130_fd_sc_hd__dfxtp_1
X_10819_ _04445_ _04562_ VGND VGND VPWR VPWR _04564_ sky130_fd_sc_hd__xor2_1
X_11799_ _05533_ _05534_ VGND VGND VPWR VPWR _05535_ sky130_fd_sc_hd__nand2_1
XTAP_TAPCELL_ROW_119_2238 VGND VPWR sky130_fd_sc_hd__tapvpwrvgnd_1
X_13538_ clknet_leaf_26_clk _00548_ VGND VGND VPWR VPWR u_interface.fifo_data\[5\]\[17\]
+ sky130_fd_sc_hd__dfxtp_1
XFILLER_145_125 VGND VGND VPWR VPWR sky130_fd_sc_hd__decap_3
XFILLER_9_485 VPWR VGND VPWR VGND sky130_ef_sc_hd__decap_12
X_13469_ clknet_leaf_63_clk _00479_ VGND VGND VPWR VPWR u_interface.u_gelu_fp32.u_q16_to_fp32.s3_norm_mag\[9\]
+ sky130_fd_sc_hd__dfxtp_1
XFILLER_64_3 VPWR VGND VPWR VGND sky130_ef_sc_hd__decap_12
XFILLER_142_810 VGND VGND VPWR VPWR sky130_fd_sc_hd__fill_2
XTAP_TAPCELL_ROW_132_2449 VGND VPWR sky130_fd_sc_hd__tapvpwrvgnd_1
XFILLER_127_895 VGND VGND VPWR VPWR sky130_fd_sc_hd__fill_1
XFILLER_141_331 VGND VGND VPWR VPWR sky130_fd_sc_hd__decap_4
XFILLER_99_223 VGND VGND VPWR VPWR sky130_fd_sc_hd__fill_1
XFILLER_142_865 VGND VGND VPWR VPWR sky130_fd_sc_hd__decap_3
X_07961_ net1381 _01842_ net774 VGND VGND VPWR VPWR _00685_ sky130_fd_sc_hd__mux2_1
XFILLER_114_578 VGND VGND VPWR VPWR sky130_fd_sc_hd__decap_8
XFILLER_141_386 VGND VGND VPWR VPWR sky130_fd_sc_hd__decap_6
XFILLER_114_589 VPWR VGND VPWR VGND sky130_ef_sc_hd__decap_12
X_09700_ _03452_ _03454_ VGND VGND VPWR VPWR _03455_ sky130_fd_sc_hd__nor2_1
XFILLER_99_289 VGND VGND VPWR VPWR sky130_fd_sc_hd__fill_2
X_06912_ u_interface.u_gelu_fp32.u_synth_top.s1_x\[18\] net274 _01449_ VGND VGND VPWR
+ VPWR _01451_ sky130_fd_sc_hd__a21oi_1
XFILLER_4_83 VGND VGND VPWR VPWR sky130_fd_sc_hd__fill_1
X_07892_ net1316 net572 net267 VGND VGND VPWR VPWR _00653_ sky130_fd_sc_hd__mux2_1
XFILLER_114_29 VGND VGND VPWR VPWR sky130_fd_sc_hd__decap_4
XFILLER_110_740 VGND VGND VPWR VPWR sky130_fd_sc_hd__decap_4
XFILLER_68_643 VGND VGND VPWR VPWR sky130_fd_sc_hd__fill_1
XFILLER_67_131 VGND VGND VPWR VPWR sky130_fd_sc_hd__fill_1
XTAP_TAPCELL_ROW_52_1175 VGND VPWR sky130_fd_sc_hd__tapvpwrvgnd_1
XTAP_TAPCELL_ROW_52_1164 VGND VPWR sky130_fd_sc_hd__tapvpwrvgnd_1
XTAP_TAPCELL_ROW_147_2692 VGND VPWR sky130_fd_sc_hd__tapvpwrvgnd_1
XTAP_TAPCELL_ROW_147_2681 VGND VPWR sky130_fd_sc_hd__tapvpwrvgnd_1
X_06843_ _01390_ _01391_ net736 VGND VGND VPWR VPWR _01392_ sky130_fd_sc_hd__mux2_1
X_09631_ net499 net696 _03384_ _03385_ VGND VGND VPWR VPWR _03387_ sky130_fd_sc_hd__nand4_2
XFILLER_95_473 VGND VGND VPWR VPWR sky130_fd_sc_hd__decap_8
X_09562_ _03316_ _03317_ _03217_ _03219_ VGND VGND VPWR VPWR _03319_ sky130_fd_sc_hd__a211oi_1
X_06774_ net731 _01330_ VGND VGND VPWR VPWR _01331_ sky130_fd_sc_hd__or2_1
XFILLER_67_186 VGND VGND VPWR VPWR sky130_fd_sc_hd__fill_1
X_08513_ net521 u_interface.u_gelu_fp32.u_synth_top.s3_mult\[52\] VGND VGND VPWR VPWR
+ _02304_ sky130_fd_sc_hd__nand2_1
XFILLER_24_713 VPWR VGND VPWR VGND sky130_ef_sc_hd__decap_12
X_09493_ net499 net689 _03247_ _03248_ VGND VGND VPWR VPWR _03250_ sky130_fd_sc_hd__nand4_2
XFILLER_82_189 VGND VGND VPWR VPWR sky130_fd_sc_hd__fill_1
XFILLER_36_573 VPWR VGND VPWR VGND sky130_ef_sc_hd__decap_12
X_08444_ _02182_ _02183_ VGND VGND VPWR VPWR _02235_ sky130_fd_sc_hd__and2b_1
XFILLER_51_543 VGND VGND VPWR VPWR sky130_fd_sc_hd__decap_3
XFILLER_23_256 VPWR VGND VPWR VGND sky130_ef_sc_hd__decap_12
XFILLER_24_757 VPWR VGND VPWR VGND sky130_ef_sc_hd__decap_12
XFILLER_23_15 VPWR VGND VPWR VGND sky130_ef_sc_hd__decap_12
X_08375_ net521 u_interface.u_gelu_fp32.u_synth_top.s3_mult\[49\] VGND VGND VPWR VPWR
+ _02166_ sky130_fd_sc_hd__nand2_1
X_07326_ net1181 net577 net255 VGND VGND VPWR VPWR _00356_ sky130_fd_sc_hd__mux2_1
XFILLER_137_615 VGND VGND VPWR VPWR sky130_fd_sc_hd__fill_1
XFILLER_136_114 VPWR VGND VPWR VGND sky130_ef_sc_hd__decap_12
XFILLER_109_317 VPWR VGND VPWR VGND sky130_ef_sc_hd__decap_12
XFILLER_99_19 VGND VGND VPWR VPWR sky130_fd_sc_hd__fill_1
X_07257_ net1263 net343 net249 VGND VGND VPWR VPWR _00289_ sky130_fd_sc_hd__mux2_1
X_07188_ net1306 net568 net263 VGND VGND VPWR VPWR _00228_ sky130_fd_sc_hd__mux2_1
XFILLER_3_617 VPWR VGND VPWR VGND sky130_ef_sc_hd__decap_12
XFILLER_132_342 VPWR VGND VPWR VGND sky130_ef_sc_hd__decap_12
XFILLER_120_504 VGND VGND VPWR VPWR sky130_fd_sc_hd__fill_1
XFILLER_79_919 VGND VGND VPWR VPWR sky130_fd_sc_hd__fill_2
XFILLER_78_407 VPWR VGND VPWR VGND sky130_ef_sc_hd__decap_12
Xfanout431 u_interface.u_gelu_fp32.u_synth_top.s2_dx\[21\] VGND VGND VPWR VPWR net431
+ sky130_fd_sc_hd__clkbuf_2
Xfanout420 u_interface.u_gelu_fp32.u_synth_top.s2_dx\[23\] VGND VGND VPWR VPWR net420
+ sky130_fd_sc_hd__clkbuf_4
XTAP_TAPCELL_ROW_6_433 VGND VPWR sky130_fd_sc_hd__tapvpwrvgnd_1
XFILLER_120_548 VPWR VGND VPWR VGND sky130_ef_sc_hd__decap_12
Xfanout475 u_interface.u_gelu_fp32.u_synth_top.s2_dx\[10\] VGND VGND VPWR VPWR net475
+ sky130_fd_sc_hd__buf_1
Xfanout453 u_interface.u_gelu_fp32.u_synth_top.s2_dx\[16\] VGND VGND VPWR VPWR net453
+ sky130_fd_sc_hd__clkbuf_4
Xfanout442 u_interface.u_gelu_fp32.u_synth_top.s2_dx\[19\] VGND VGND VPWR VPWR net442
+ sky130_fd_sc_hd__clkbuf_2
Xfanout464 net465 VGND VGND VPWR VPWR net464 sky130_fd_sc_hd__buf_2
Xfanout497 net498 VGND VGND VPWR VPWR net497 sky130_fd_sc_hd__clkbuf_2
Xfanout486 net490 VGND VGND VPWR VPWR net486 sky130_fd_sc_hd__buf_2
X_09829_ _03579_ _03582_ VGND VGND VPWR VPWR _03583_ sky130_fd_sc_hd__xnor2_1
XFILLER_86_484 VGND VGND VPWR VPWR sky130_fd_sc_hd__fill_1
X_12840_ net68 net145 net73 VGND VGND VPWR VPWR _06422_ sky130_fd_sc_hd__nand3_1
XFILLER_104_51 VGND VGND VPWR VPWR sky130_fd_sc_hd__fill_1
XFILLER_58_197 VGND VGND VPWR VPWR sky130_fd_sc_hd__fill_2
XFILLER_46_337 VGND VGND VPWR VPWR sky130_fd_sc_hd__fill_1
XFILLER_73_167 VGND VGND VPWR VPWR sky130_fd_sc_hd__fill_1
XFILLER_61_307 VGND VGND VPWR VPWR sky130_fd_sc_hd__fill_2
XFILLER_46_359 VGND VGND VPWR VPWR sky130_fd_sc_hd__decap_4
X_12771_ u_interface.u_gelu_fp32.u_q16_to_fp32.s3_norm_mag\[14\] _01779_ net296 VGND
+ VGND VPWR VPWR _06402_ sky130_fd_sc_hd__o21ai_1
XFILLER_70_830 VGND VGND VPWR VPWR sky130_fd_sc_hd__fill_2
XFILLER_27_573 VPWR VGND VPWR VGND sky130_ef_sc_hd__decap_12
XFILLER_42_510 VPWR VGND VPWR VGND sky130_ef_sc_hd__decap_12
XTAP_TAPCELL_ROW_83_1669 VGND VPWR sky130_fd_sc_hd__tapvpwrvgnd_1
XTAP_TAPCELL_ROW_83_1658 VGND VPWR sky130_fd_sc_hd__tapvpwrvgnd_1
XFILLER_14_234 VPWR VGND VPWR VGND sky130_ef_sc_hd__decap_12
XTAP_TAPCELL_ROW_25_730 VGND VPWR sky130_fd_sc_hd__tapvpwrvgnd_1
XTAP_TAPCELL_ROW_25_741 VGND VPWR sky130_fd_sc_hd__tapvpwrvgnd_1
X_11722_ _05456_ _05457_ VGND VGND VPWR VPWR _05459_ sky130_fd_sc_hd__xnor2_1
XFILLER_70_896 VGND VGND VPWR VPWR sky130_fd_sc_hd__fill_2
X_11653_ _05388_ _05389_ VGND VGND VPWR VPWR _05391_ sky130_fd_sc_hd__xor2_1
XFILLER_9_39 VPWR VGND VPWR VGND sky130_ef_sc_hd__decap_12
XFILLER_42_587 VGND VGND VPWR VPWR sky130_fd_sc_hd__fill_1
X_10604_ _04226_ _04350_ VGND VGND VPWR VPWR _04351_ sky130_fd_sc_hd__xnor2_1
XFILLER_30_749 VGND VGND VPWR VPWR sky130_fd_sc_hd__decap_6
XFILLER_155_412 VGND VGND VPWR VPWR sky130_fd_sc_hd__decap_4
X_13323_ clknet_leaf_62_clk _00333_ VGND VGND VPWR VPWR u_interface.fifo_data\[10\]\[0\]
+ sky130_fd_sc_hd__dfxtp_1
X_11584_ _05046_ _05238_ _05146_ VGND VGND VPWR VPWR _05322_ sky130_fd_sc_hd__o21bai_2
X_10535_ net594 net603 net417 net413 VGND VGND VPWR VPWR _04283_ sky130_fd_sc_hd__and4_1
XFILLER_10_473 VGND VGND VPWR VPWR sky130_fd_sc_hd__decap_3
XFILLER_13_81 VPWR VGND VPWR VGND sky130_ef_sc_hd__decap_12
X_13254_ clknet_leaf_31_clk _00264_ VGND VGND VPWR VPWR _00000_ sky130_fd_sc_hd__dfxtp_2
XFILLER_124_810 VGND VGND VPWR VPWR sky130_fd_sc_hd__fill_2
XTAP_TAPCELL_ROW_114_2157 VGND VPWR sky130_fd_sc_hd__tapvpwrvgnd_1
XFILLER_109_862 VGND VGND VPWR VPWR sky130_fd_sc_hd__fill_1
XFILLER_89_52 VGND VGND VPWR VPWR sky130_fd_sc_hd__decap_4
X_10466_ _04204_ _04211_ _04212_ VGND VGND VPWR VPWR _04214_ sky130_fd_sc_hd__nand3_1
XFILLER_6_477 VPWR VGND VPWR VGND sky130_ef_sc_hd__decap_12
XFILLER_6_455 VPWR VGND VPWR VGND sky130_ef_sc_hd__decap_12
X_13185_ clknet_leaf_67_clk _00195_ VGND VGND VPWR VPWR u_interface.fifo_data\[9\]\[27\]
+ sky130_fd_sc_hd__dfxtp_1
X_12205_ _05646_ _05935_ _05934_ VGND VGND VPWR VPWR _05936_ sky130_fd_sc_hd__o21a_1
XFILLER_97_727 VGND VGND VPWR VPWR sky130_fd_sc_hd__fill_1
XFILLER_97_705 VGND VGND VPWR VPWR sky130_fd_sc_hd__decap_4
X_10397_ _04144_ _04145_ VGND VGND VPWR VPWR _04146_ sky130_fd_sc_hd__nor2_1
X_12136_ net183 _05803_ _05802_ VGND VGND VPWR VPWR _05867_ sky130_fd_sc_hd__a21o_1
XFILLER_145_91 VGND VGND VPWR VPWR sky130_fd_sc_hd__decap_4
XFILLER_111_559 VGND VGND VPWR VPWR sky130_fd_sc_hd__fill_1
XFILLER_1_193 VPWR VGND VPWR VGND sky130_ef_sc_hd__decap_12
X_12067_ _05793_ _05797_ _05799_ VGND VGND VPWR VPWR _00834_ sky130_fd_sc_hd__a21oi_1
X_11018_ _04635_ _04761_ VGND VGND VPWR VPWR _04762_ sky130_fd_sc_hd__nand2_1
XFILLER_92_421 VGND VGND VPWR VPWR sky130_fd_sc_hd__decap_6
XFILLER_92_454 VGND VGND VPWR VPWR sky130_fd_sc_hd__fill_1
XFILLER_52_307 VGND VGND VPWR VPWR sky130_fd_sc_hd__fill_1
X_12969_ u_interface.fifo_count\[4\] _06467_ VGND VGND VPWR VPWR _06487_ sky130_fd_sc_hd__or2_1
XFILLER_80_649 VGND VGND VPWR VPWR sky130_fd_sc_hd__fill_1
XFILLER_80_627 VGND VGND VPWR VPWR sky130_fd_sc_hd__fill_1
XFILLER_18_584 VGND VGND VPWR VPWR sky130_fd_sc_hd__decap_4
XFILLER_60_362 VGND VGND VPWR VPWR sky130_fd_sc_hd__fill_2
XFILLER_21_727 VGND VGND VPWR VPWR sky130_fd_sc_hd__fill_1
X_08160_ _01993_ _01994_ net540 VGND VGND VPWR VPWR _01999_ sky130_fd_sc_hd__o21a_1
XFILLER_119_615 VGND VGND VPWR VPWR sky130_fd_sc_hd__fill_1
X_07111_ net1149 net563 net225 VGND VGND VPWR VPWR _00151_ sky130_fd_sc_hd__mux2_1
X_08091_ u_interface.u_gelu_fp32.u_fp32_to_q16.s3_mag\[6\] _01876_ u_interface.u_gelu_fp32.u_fp32_to_q16.s3_mag\[7\]
+ VGND VGND VPWR VPWR _01941_ sky130_fd_sc_hd__a21oi_1
XFILLER_9_293 VGND VGND VPWR VPWR sky130_fd_sc_hd__decap_4
Xclkload30 clknet_leaf_15_clk VGND VGND VPWR VPWR clkload30/Y sky130_fd_sc_hd__inv_12
XFILLER_146_489 VPWR VGND VPWR VGND sky130_ef_sc_hd__decap_12
XFILLER_106_309 VGND VGND VPWR VPWR sky130_fd_sc_hd__decap_8
X_07042_ net1425 net574 net272 VGND VGND VPWR VPWR _00082_ sky130_fd_sc_hd__mux2_1
Xclkload41 clknet_leaf_60_clk VGND VGND VPWR VPWR clkload41/Y sky130_fd_sc_hd__inv_6
Xclkload52 clknet_leaf_87_clk VGND VGND VPWR VPWR clkload52/Y sky130_fd_sc_hd__clkinvlp_4
Xclkload74 clknet_leaf_37_clk VGND VGND VPWR VPWR clkload74/Y sky130_fd_sc_hd__clkinv_8
Xclkload85 clknet_leaf_50_clk VGND VGND VPWR VPWR clkload85/Y sky130_fd_sc_hd__inv_6
Xclkload63 clknet_leaf_74_clk VGND VGND VPWR VPWR clkload63/Y sky130_fd_sc_hd__inv_8
XFILLER_114_342 VPWR VGND VPWR VGND sky130_ef_sc_hd__decap_12
XTAP_TAPCELL_ROW_54_1204 VGND VPWR sky130_fd_sc_hd__tapvpwrvgnd_1
XTAP_TAPCELL_ROW_149_2721 VGND VPWR sky130_fd_sc_hd__tapvpwrvgnd_1
XFILLER_142_695 VGND VGND VPWR VPWR sky130_fd_sc_hd__decap_4
X_08993_ _02735_ _02736_ _02751_ VGND VGND VPWR VPWR _02752_ sky130_fd_sc_hd__nor3_1
X_07944_ _01815_ _01833_ net814 VGND VGND VPWR VPWR _01834_ sky130_fd_sc_hd__a21oi_1
XFILLER_68_451 VPWR VGND VPWR VGND sky130_ef_sc_hd__decap_12
X_07875_ net1157 net367 net265 VGND VGND VPWR VPWR _00636_ sky130_fd_sc_hd__mux2_1
XFILLER_18_15 VPWR VGND VPWR VGND sky130_ef_sc_hd__decap_12
X_06826_ u_interface.fifo_data\[4\]\[24\] u_interface.fifo_data\[5\]\[24\] u_interface.fifo_data\[6\]\[24\]
+ u_interface.fifo_data\[7\]\[24\] net765 net748 VGND VGND VPWR VPWR _01377_ sky130_fd_sc_hd__mux4_1
X_09614_ net500 net705 net713 net505 VGND VGND VPWR VPWR _03370_ sky130_fd_sc_hd__a22oi_1
XFILLER_95_292 VGND VGND VPWR VPWR sky130_fd_sc_hd__fill_1
XFILLER_95_281 VGND VGND VPWR VPWR sky130_fd_sc_hd__fill_2
XFILLER_83_410 VPWR VGND VPWR VGND sky130_ef_sc_hd__decap_12
XFILLER_55_167 VGND VGND VPWR VPWR sky130_fd_sc_hd__fill_1
X_06757_ u_interface.fifo_data\[12\]\[16\] u_interface.fifo_data\[13\]\[16\] u_interface.fifo_data\[14\]\[16\]
+ u_interface.fifo_data\[15\]\[16\] net768 net751 VGND VGND VPWR VPWR _01316_ sky130_fd_sc_hd__mux4_1
X_09545_ _03300_ _03301_ VGND VGND VPWR VPWR _03302_ sky130_fd_sc_hd__nor2_1
XFILLER_55_189 VGND VGND VPWR VPWR sky130_fd_sc_hd__fill_2
X_06688_ net323 _01253_ net727 VGND VGND VPWR VPWR _01256_ sky130_fd_sc_hd__o21a_1
X_09476_ net500 net696 net706 net505 VGND VGND VPWR VPWR _03233_ sky130_fd_sc_hd__a22o_1
XFILLER_24_554 VPWR VGND VPWR VGND sky130_ef_sc_hd__decap_12
XFILLER_36_392 VGND VGND VPWR VPWR sky130_fd_sc_hd__fill_2
X_08427_ _02207_ _02208_ _02217_ VGND VGND VPWR VPWR _02218_ sky130_fd_sc_hd__and3_1
XTAP_TAPCELL_ROW_65_1377 VGND VPWR sky130_fd_sc_hd__tapvpwrvgnd_1
XFILLER_24_587 VGND VGND VPWR VPWR sky130_fd_sc_hd__fill_1
XFILLER_12_749 VGND VGND VPWR VPWR sky130_fd_sc_hd__decap_6
Xclkload2 clknet_3_2__leaf_clk VGND VGND VPWR VPWR clkload2/Y sky130_fd_sc_hd__clkinvlp_4
X_08358_ _02150_ _02151_ VGND VGND VPWR VPWR _00773_ sky130_fd_sc_hd__nor2_1
XFILLER_153_905 VGND VGND VPWR VPWR sky130_fd_sc_hd__decap_3
XFILLER_109_136 VPWR VGND VPWR VGND sky130_ef_sc_hd__decap_12
XFILLER_109_125 VGND VGND VPWR VPWR sky130_fd_sc_hd__decap_8
X_08289_ net532 net1648 _02098_ net799 VGND VGND VPWR VPWR _02100_ sky130_fd_sc_hd__a31o_1
XFILLER_20_793 VPWR VGND VPWR VGND sky130_ef_sc_hd__decap_12
X_07309_ net1071 net372 net253 VGND VGND VPWR VPWR _00339_ sky130_fd_sc_hd__mux2_1
XFILLER_153_916 VGND VGND VPWR VPWR sky130_fd_sc_hd__decap_4
XFILLER_125_629 VGND VGND VPWR VPWR sky130_fd_sc_hd__decap_4
X_10320_ _03952_ _03954_ _04067_ _04068_ VGND VGND VPWR VPWR _04070_ sky130_fd_sc_hd__o211a_1
XFILLER_124_128 VGND VGND VPWR VPWR sky130_fd_sc_hd__decap_6
X_10251_ net474 net478 net707 net715 VGND VGND VPWR VPWR _04001_ sky130_fd_sc_hd__and4_1
XFILLER_3_447 VGND VGND VPWR VPWR sky130_fd_sc_hd__fill_1
X_10182_ net603 net432 net428 net594 VGND VGND VPWR VPWR _03933_ sky130_fd_sc_hd__a22o_1
XFILLER_59_55 VGND VGND VPWR VPWR sky130_fd_sc_hd__fill_1
XFILLER_120_345 VGND VGND VPWR VPWR sky130_fd_sc_hd__fill_1
Xfanout250 _01513_ VGND VGND VPWR VPWR net250 sky130_fd_sc_hd__clkbuf_4
Xfanout272 _01503_ VGND VGND VPWR VPWR net272 sky130_fd_sc_hd__buf_4
X_13941_ clknet_leaf_3_clk _00008_ VGND VGND VPWR VPWR u_interface.u_gelu_fp32.u_synth_top.s1_hits\[13\]
+ sky130_fd_sc_hd__dfxtp_1
Xfanout283 _01520_ VGND VGND VPWR VPWR net283 sky130_fd_sc_hd__buf_2
Xfanout261 _01507_ VGND VGND VPWR VPWR net261 sky130_fd_sc_hd__buf_4
Xfanout294 net295 VGND VGND VPWR VPWR net294 sky130_fd_sc_hd__clkbuf_2
XFILLER_19_337 VPWR VGND VPWR VGND sky130_ef_sc_hd__decap_12
X_13872_ clknet_leaf_22_clk net876 VGND VGND VPWR VPWR u_interface.u_gelu_fp32.u_synth_top.s2_dx\[8\]
+ sky130_fd_sc_hd__dfxtp_1
X_12823_ net777 net82 VGND VGND VPWR VPWR _00981_ sky130_fd_sc_hd__and2_1
XFILLER_28_893 VPWR VGND VPWR VGND sky130_ef_sc_hd__decap_12
XPHY_EDGE_ROW_141_Right_141 VGND VGND VPWR VPWR sky130_fd_sc_hd__decap_3
X_12754_ net1550 u_interface.u_gelu_fp32.u_q16_to_fp32.s3_exp\[7\] net825 VGND VGND
+ VPWR VPWR _00936_ sky130_fd_sc_hd__mux2_1
XFILLER_43_841 VGND VGND VPWR VPWR sky130_fd_sc_hd__decap_4
XFILLER_98_9 VGND VGND VPWR VPWR sky130_fd_sc_hd__fill_1
X_11705_ _05440_ _05441_ VGND VGND VPWR VPWR _05442_ sky130_fd_sc_hd__nor2_1
XFILLER_42_362 VGND VGND VPWR VPWR sky130_fd_sc_hd__fill_2
X_12685_ u_interface.u_gelu_fp32.u_q16_to_fp32.s2_mag\[17\] u_interface.u_gelu_fp32.u_q16_to_fp32.s2_mag\[15\]
+ u_interface.u_gelu_fp32.u_q16_to_fp32.s2_mag\[16\] u_interface.u_gelu_fp32.u_q16_to_fp32.s2_mag\[14\]
+ net332 net337 VGND VGND VPWR VPWR _06346_ sky130_fd_sc_hd__mux4_1
XFILLER_30_557 VGND VGND VPWR VPWR sky130_fd_sc_hd__decap_6
X_11636_ _05372_ _05373_ VGND VGND VPWR VPWR _05374_ sky130_fd_sc_hd__or2_1
XFILLER_128_456 VGND VGND VPWR VPWR sky130_fd_sc_hd__fill_1
X_11567_ _05304_ _05305_ VGND VGND VPWR VPWR _05306_ sky130_fd_sc_hd__nor2_1
XFILLER_155_253 VGND VGND VPWR VPWR sky130_fd_sc_hd__fill_2
Xhold709 u_interface.fifo_data\[7\]\[10\] VGND VGND VPWR VPWR net1574 sky130_fd_sc_hd__dlygate4sd3_1
X_13306_ clknet_leaf_66_clk _00316_ VGND VGND VPWR VPWR u_interface.fifo_data\[8\]\[15\]
+ sky130_fd_sc_hd__dfxtp_1
X_10518_ net626 net433 net427 net618 VGND VGND VPWR VPWR _04266_ sky130_fd_sc_hd__a22o_1
XFILLER_10_281 VPWR VGND VPWR VGND sky130_ef_sc_hd__decap_12
XFILLER_7_753 VPWR VGND VPWR VGND sky130_ef_sc_hd__decap_12
XFILLER_155_286 VGND VGND VPWR VPWR sky130_fd_sc_hd__decap_4
X_13237_ clknet_leaf_65_clk _00247_ VGND VGND VPWR VPWR u_interface.fifo_data\[11\]\[15\]
+ sky130_fd_sc_hd__dfxtp_1
XFILLER_7_797 VPWR VGND VPWR VGND sky130_ef_sc_hd__decap_12
X_11498_ _05162_ _05170_ _05169_ VGND VGND VPWR VPWR _05237_ sky130_fd_sc_hd__a21oi_2
X_10449_ _04194_ _04195_ _04197_ VGND VGND VPWR VPWR _04198_ sky130_fd_sc_hd__and3_1
X_13168_ clknet_leaf_38_clk _00178_ VGND VGND VPWR VPWR u_interface.fifo_data\[9\]\[10\]
+ sky130_fd_sc_hd__dfxtp_1
XFILLER_151_481 VPWR VGND VPWR VGND sky130_ef_sc_hd__decap_12
XFILLER_112_824 VGND VGND VPWR VPWR sky130_fd_sc_hd__fill_2
XFILLER_97_535 VPWR VGND VPWR VGND sky130_ef_sc_hd__decap_12
XFILLER_97_513 VGND VGND VPWR VPWR sky130_fd_sc_hd__fill_1
XFILLER_85_708 VGND VGND VPWR VPWR sky130_fd_sc_hd__decap_8
XFILLER_69_259 VPWR VGND VPWR VGND sky130_ef_sc_hd__decap_12
X_13099_ clknet_leaf_69_clk _00109_ VGND VGND VPWR VPWR u_interface.fifo_data\[15\]\[20\]
+ sky130_fd_sc_hd__dfxtp_1
X_12119_ _05849_ _05850_ VGND VGND VPWR VPWR _05851_ sky130_fd_sc_hd__or2_1
XFILLER_66_900 VGND VGND VPWR VPWR sky130_fd_sc_hd__decap_4
XFILLER_27_3 VPWR VGND VPWR VGND sky130_ef_sc_hd__decap_12
XFILLER_38_613 VPWR VGND VPWR VGND sky130_ef_sc_hd__decap_12
XTAP_TAPCELL_ROW_144_2640 VGND VPWR sky130_fd_sc_hd__tapvpwrvgnd_1
XFILLER_65_421 VGND VGND VPWR VPWR sky130_fd_sc_hd__decap_3
XFILLER_92_251 VGND VGND VPWR VPWR sky130_fd_sc_hd__fill_1
X_07660_ _01742_ _01729_ net330 VGND VGND VPWR VPWR _01743_ sky130_fd_sc_hd__mux2_1
XFILLER_1_51 VGND VGND VPWR VPWR sky130_fd_sc_hd__decap_4
X_07591_ net308 net302 _01665_ net1683 net813 VGND VGND VPWR VPWR _00465_ sky130_fd_sc_hd__a32o_1
X_06611_ u_interface.u_gelu_fp32.u_synth_top.s1_hits\[5\] _01185_ _01186_ _01187_
+ VGND VGND VPWR VPWR _01189_ sky130_fd_sc_hd__nor4_1
XFILLER_37_189 VPWR VGND VPWR VGND sky130_ef_sc_hd__decap_12
X_09330_ _03063_ _03072_ _03088_ _03071_ VGND VGND VPWR VPWR _03089_ sky130_fd_sc_hd__o31a_1
X_06542_ u_interface.u_gelu_fp32.s1_data\[17\] _01137_ VGND VGND VPWR VPWR _01139_
+ sky130_fd_sc_hd__nor2_1
XFILLER_52_137 VGND VGND VPWR VPWR sky130_fd_sc_hd__decap_3
X_09261_ net623 net513 net517 net630 VGND VGND VPWR VPWR _03020_ sky130_fd_sc_hd__a22oi_1
X_08212_ _02035_ _02036_ VGND VGND VPWR VPWR _02043_ sky130_fd_sc_hd__nand2_1
XTAP_TAPCELL_ROW_47_1085 VGND VPWR sky130_fd_sc_hd__tapvpwrvgnd_1
XTAP_TAPCELL_ROW_16_593 VGND VPWR sky130_fd_sc_hd__tapvpwrvgnd_1
X_09192_ _02907_ _02949_ _02950_ VGND VGND VPWR VPWR _02951_ sky130_fd_sc_hd__and3_1
X_08143_ net168 _01984_ net164 VGND VGND VPWR VPWR _01985_ sky130_fd_sc_hd__a21oi_1
XFILLER_147_798 VGND VGND VPWR VPWR sky130_fd_sc_hd__decap_3
X_08074_ _01909_ _01913_ _01917_ _01922_ VGND VGND VPWR VPWR _01927_ sky130_fd_sc_hd__and4_1
XFILLER_107_629 VGND VGND VPWR VPWR sky130_fd_sc_hd__fill_1
XTAP_TAPCELL_ROW_60_1296 VGND VPWR sky130_fd_sc_hd__tapvpwrvgnd_1
XFILLER_146_286 VGND VGND VPWR VPWR sky130_fd_sc_hd__fill_1
XFILLER_106_117 VGND VGND VPWR VPWR sky130_fd_sc_hd__fill_2
XFILLER_20_27 VGND VGND VPWR VPWR sky130_fd_sc_hd__fill_1
X_07025_ net1062 net368 net269 VGND VGND VPWR VPWR _00065_ sky130_fd_sc_hd__mux2_1
XFILLER_0_417 VGND VGND VPWR VPWR sky130_fd_sc_hd__decap_3
Xhold14 u_interface.u_gelu_fp32.u_synth_top.s1_x\[10\] VGND VGND VPWR VPWR net879
+ sky130_fd_sc_hd__dlygate4sd3_1
XFILLER_88_557 VGND VGND VPWR VPWR sky130_fd_sc_hd__decap_4
XFILLER_76_708 VPWR VGND VPWR VGND sky130_ef_sc_hd__decap_12
XFILLER_152_26 VGND VGND VPWR VPWR sky130_fd_sc_hd__fill_2
Xhold47 u_interface.u_gelu_fp32.u_q16_to_fp32.s2_valid VGND VGND VPWR VPWR net912
+ sky130_fd_sc_hd__dlygate4sd3_1
X_08976_ _02716_ _02733_ _02734_ _02576_ VGND VGND VPWR VPWR _02735_ sky130_fd_sc_hd__o211a_1
Xhold25 u_interface.u_gelu_fp32.s1_data\[13\] VGND VGND VPWR VPWR net890 sky130_fd_sc_hd__dlygate4sd3_1
Xhold36 u_interface.u_gelu_fp32.s1_data\[24\] VGND VGND VPWR VPWR net901 sky130_fd_sc_hd__dlygate4sd3_1
XFILLER_29_69 VPWR VGND VPWR VGND sky130_ef_sc_hd__decap_12
X_07927_ u_interface.u_gelu_fp32.u_fp32_to_q16.s1_mant\[21\] u_interface.u_gelu_fp32.u_fp32_to_q16.s1_mant\[20\]
+ u_interface.u_gelu_fp32.u_fp32_to_q16.s1_mant\[22\] u_interface.u_gelu_fp32.u_fp32_to_q16.s1_sign
+ VGND VGND VPWR VPWR _01821_ sky130_fd_sc_hd__or4b_1
Xhold69 u_interface.u_gelu_fp32.u_fp32_to_q16.s1_is_zero VGND VGND VPWR VPWR net934
+ sky130_fd_sc_hd__dlygate4sd3_1
Xhold58 u_interface.meta_tlast_pipe\[9\] VGND VGND VPWR VPWR net923 sky130_fd_sc_hd__dlygate4sd3_1
XFILLER_56_421 VGND VGND VPWR VPWR sky130_fd_sc_hd__decap_8
X_07858_ net575 net1440 net285 VGND VGND VPWR VPWR _00619_ sky130_fd_sc_hd__mux2_1
XFILLER_84_752 VGND VGND VPWR VPWR sky130_fd_sc_hd__decap_4
XFILLER_83_240 VGND VGND VPWR VPWR sky130_fd_sc_hd__fill_1
XTAP_TAPCELL_ROW_67_1406 VGND VPWR sky130_fd_sc_hd__tapvpwrvgnd_1
XFILLER_44_605 VGND VGND VPWR VPWR sky130_fd_sc_hd__fill_2
X_06809_ u_interface.fifo_data\[0\]\[22\] u_interface.fifo_data\[1\]\[22\] u_interface.fifo_data\[2\]\[22\]
+ u_interface.fifo_data\[3\]\[22\] net767 net750 VGND VGND VPWR VPWR _01362_ sky130_fd_sc_hd__mux4_1
X_07789_ net1055 net346 net235 VGND VGND VPWR VPWR _00550_ sky130_fd_sc_hd__mux2_1
XFILLER_43_104 VGND VGND VPWR VPWR sky130_fd_sc_hd__fill_1
X_09528_ _03283_ _03284_ VGND VGND VPWR VPWR _03285_ sky130_fd_sc_hd__and2b_1
XFILLER_71_457 VGND VGND VPWR VPWR sky130_fd_sc_hd__fill_1
XFILLER_45_57 VPWR VGND VPWR VGND sky130_ef_sc_hd__decap_12
XFILLER_25_841 VPWR VGND VPWR VGND sky130_ef_sc_hd__decap_12
XTAP_TAPCELL_ROW_80_1617 VGND VPWR sky130_fd_sc_hd__tapvpwrvgnd_1
XFILLER_24_340 VPWR VGND VPWR VGND sky130_ef_sc_hd__decap_12
XFILLER_40_811 VGND VGND VPWR VPWR sky130_fd_sc_hd__fill_1
X_09459_ _02706_ _02708_ _03214_ _03215_ VGND VGND VPWR VPWR _03217_ sky130_fd_sc_hd__o211a_1
XTAP_TAPCELL_ROW_35_891 VGND VPWR sky130_fd_sc_hd__tapvpwrvgnd_1
XFILLER_131_3 VGND VGND VPWR VPWR sky130_fd_sc_hd__decap_8
X_12470_ _06146_ _06148_ _06194_ VGND VGND VPWR VPWR _06196_ sky130_fd_sc_hd__a21o_1
XFILLER_12_557 VPWR VGND VPWR VGND sky130_ef_sc_hd__decap_12
X_11421_ _05144_ _05160_ VGND VGND VPWR VPWR _05161_ sky130_fd_sc_hd__xor2_2
X_14140_ clknet_leaf_62_clk _01066_ VGND VGND VPWR VPWR u_interface.fifo_data\[1\]\[0\]
+ sky130_fd_sc_hd__dfxtp_1
XFILLER_6_29 VPWR VGND VPWR VGND sky130_ef_sc_hd__decap_12
XFILLER_4_701 VPWR VGND VPWR VGND sky130_ef_sc_hd__decap_12
X_11352_ _05091_ _05092_ VGND VGND VPWR VPWR _05093_ sky130_fd_sc_hd__xnor2_1
XFILLER_152_201 VGND VGND VPWR VPWR sky130_fd_sc_hd__fill_1
XFILLER_125_426 VPWR VGND VPWR VGND sky130_ef_sc_hd__decap_12
XTAP_TAPCELL_ROW_111_2105 VGND VPWR sky130_fd_sc_hd__tapvpwrvgnd_1
X_10303_ net609 net436 _03933_ _03932_ VGND VGND VPWR VPWR _04053_ sky130_fd_sc_hd__a31oi_1
XTAP_TAPCELL_ROW_78_1579 VGND VPWR sky130_fd_sc_hd__tapvpwrvgnd_1
X_14071_ clknet_leaf_16_clk net1178 VGND VGND VPWR VPWR u_interface.u_gelu_fp32.u_fp32_to_q16.s2_norm_mag\[8\]
+ sky130_fd_sc_hd__dfxtp_1
XTAP_TAPCELL_ROW_111_2116 VGND VPWR sky130_fd_sc_hd__tapvpwrvgnd_1
XTAP_TAPCELL_ROW_95_1860 VGND VPWR sky130_fd_sc_hd__tapvpwrvgnd_1
X_11283_ _03758_ _04803_ _04917_ VGND VGND VPWR VPWR _05024_ sky130_fd_sc_hd__o21ai_2
XFILLER_112_109 VGND VGND VPWR VPWR sky130_fd_sc_hd__decap_3
XFILLER_105_161 VGND VGND VPWR VPWR sky130_fd_sc_hd__decap_6
X_10234_ _03979_ _03981_ _03982_ VGND VGND VPWR VPWR _03984_ sky130_fd_sc_hd__nand3_1
XFILLER_79_513 VGND VGND VPWR VPWR sky130_fd_sc_hd__decap_8
XFILLER_79_502 VGND VGND VPWR VPWR sky130_fd_sc_hd__fill_2
X_13022_ net170 net165 net161 net160 net151 VGND VGND VPWR VPWR _00849_ sky130_fd_sc_hd__o2111a_1
X_10165_ _03912_ _03913_ _03914_ VGND VGND VPWR VPWR _03916_ sky130_fd_sc_hd__and3_1
XFILLER_94_527 VGND VGND VPWR VPWR sky130_fd_sc_hd__decap_4
XFILLER_86_53 VPWR VGND VPWR VGND sky130_ef_sc_hd__decap_12
XFILLER_66_218 VGND VGND VPWR VPWR sky130_fd_sc_hd__fill_2
X_10096_ _03845_ _03846_ _03726_ _03728_ VGND VGND VPWR VPWR _03848_ sky130_fd_sc_hd__o211a_1
XFILLER_59_281 VGND VGND VPWR VPWR sky130_fd_sc_hd__fill_2
XTAP_TAPCELL_ROW_109_2078 VGND VPWR sky130_fd_sc_hd__tapvpwrvgnd_1
X_13924_ clknet_leaf_6_clk net895 VGND VGND VPWR VPWR u_interface.u_gelu_fp32.u_synth_top.s1_x\[28\]
+ sky130_fd_sc_hd__dfxtp_1
X_13855_ clknet_leaf_88_clk _00865_ VGND VGND VPWR VPWR u_interface.u_gelu_fp32.u_synth_top.s3_b\[11\]
+ sky130_fd_sc_hd__dfxtp_1
XFILLER_75_785 VGND VGND VPWR VPWR sky130_fd_sc_hd__fill_1
XFILLER_74_262 VGND VGND VPWR VPWR sky130_fd_sc_hd__decap_8
XFILLER_19_189 VGND VGND VPWR VPWR sky130_fd_sc_hd__fill_1
XFILLER_34_115 VGND VGND VPWR VPWR sky130_fd_sc_hd__decap_8
X_12806_ net776 net74 VGND VGND VPWR VPWR _00964_ sky130_fd_sc_hd__and2_1
XTAP_TAPCELL_ROW_122_2289 VGND VPWR sky130_fd_sc_hd__tapvpwrvgnd_1
X_10998_ _04628_ _04630_ _04629_ VGND VGND VPWR VPWR _04742_ sky130_fd_sc_hd__o21ba_1
X_13786_ clknet_leaf_85_clk _00796_ VGND VGND VPWR VPWR u_interface.u_gelu_fp32.s2_data\[20\]
+ sky130_fd_sc_hd__dfxtp_1
XFILLER_43_671 VGND VGND VPWR VPWR sky130_fd_sc_hd__fill_1
X_12737_ _01748_ _06357_ _06386_ net281 VGND VGND VPWR VPWR _06387_ sky130_fd_sc_hd__a22o_1
XFILLER_43_693 VPWR VGND VPWR VGND sky130_ef_sc_hd__decap_12
XFILLER_31_833 VGND VGND VPWR VPWR sky130_fd_sc_hd__decap_6
X_12668_ net1716 u_interface.u_gelu_fp32.u_q16_to_fp32.s2_mag\[23\] net802 VGND VGND
+ VPWR VPWR _00904_ sky130_fd_sc_hd__mux2_1
XTAP_TAPCELL_ROW_13_541 VGND VPWR sky130_fd_sc_hd__tapvpwrvgnd_1
XFILLER_31_877 VPWR VGND VPWR VGND sky130_ef_sc_hd__decap_12
XFILLER_30_365 VPWR VGND VPWR VGND sky130_ef_sc_hd__decap_12
X_11619_ _05346_ _05356_ VGND VGND VPWR VPWR _05357_ sky130_fd_sc_hd__xnor2_1
X_12599_ u_interface.u_gelu_fp32.u_q16_to_fp32.s1_mag\[12\] net211 u_interface.u_gelu_fp32.u_q16_to_fp32.s1_mag\[28\]
+ VGND VGND VPWR VPWR _06302_ sky130_fd_sc_hd__a21o_1
XFILLER_143_223 VGND VGND VPWR VPWR sky130_fd_sc_hd__fill_1
Xhold506 u_interface.fifo_data\[12\]\[4\] VGND VGND VPWR VPWR net1371 sky130_fd_sc_hd__dlygate4sd3_1
Xhold517 u_interface.fifo_data\[11\]\[15\] VGND VGND VPWR VPWR net1382 sky130_fd_sc_hd__dlygate4sd3_1
XFILLER_7_561 VPWR VGND VPWR VGND sky130_ef_sc_hd__decap_12
XFILLER_143_245 VGND VGND VPWR VPWR sky130_fd_sc_hd__decap_8
Xhold528 u_interface.fifo_data\[3\]\[1\] VGND VGND VPWR VPWR net1393 sky130_fd_sc_hd__dlygate4sd3_1
Xhold539 u_interface.fifo_data\[6\]\[15\] VGND VGND VPWR VPWR net1404 sky130_fd_sc_hd__dlygate4sd3_1
XFILLER_143_289 VGND VGND VPWR VPWR sky130_fd_sc_hd__fill_1
X_08830_ net680 net516 net520 net690 VGND VGND VPWR VPWR _02589_ sky130_fd_sc_hd__a22oi_1
XFILLER_85_505 VGND VGND VPWR VPWR sky130_fd_sc_hd__fill_1
XFILLER_57_207 VPWR VGND VPWR VGND sky130_ef_sc_hd__decap_12
X_08761_ net605 net472 VGND VGND VPWR VPWR _02520_ sky130_fd_sc_hd__and2_1
XFILLER_85_527 VGND VGND VPWR VPWR sky130_fd_sc_hd__decap_6
XPHY_EDGE_ROW_29_Left_185 VGND VGND VPWR VPWR sky130_fd_sc_hd__decap_3
X_08692_ _02448_ _02450_ VGND VGND VPWR VPWR _02451_ sky130_fd_sc_hd__nor2_1
X_07712_ _01129_ _01760_ _01764_ VGND VGND VPWR VPWR _00510_ sky130_fd_sc_hd__or3_1
XFILLER_66_752 VGND VGND VPWR VPWR sky130_fd_sc_hd__decap_4
XFILLER_54_903 VGND VGND VPWR VPWR sky130_fd_sc_hd__fill_2
XFILLER_38_443 VGND VGND VPWR VPWR sky130_fd_sc_hd__decap_3
X_07643_ _01729_ _01715_ net330 VGND VGND VPWR VPWR _01730_ sky130_fd_sc_hd__mux2_1
XFILLER_53_413 VPWR VGND VPWR VGND sky130_ef_sc_hd__decap_12
XTAP_TAPCELL_ROW_49_1125 VGND VPWR sky130_fd_sc_hd__tapvpwrvgnd_1
XTAP_TAPCELL_ROW_49_1114 VGND VPWR sky130_fd_sc_hd__tapvpwrvgnd_1
XFILLER_80_221 VGND VGND VPWR VPWR sky130_fd_sc_hd__decap_4
X_09313_ _03059_ _03060_ _03062_ VGND VGND VPWR VPWR _03072_ sky130_fd_sc_hd__a21oi_1
X_07574_ u_interface.u_gelu_fp32.u_fp32_to_q16.s2_shift\[4\] _01586_ VGND VGND VPWR
+ VPWR _01684_ sky130_fd_sc_hd__nor2_1
XFILLER_15_27 VPWR VGND VPWR VGND sky130_ef_sc_hd__decap_12
XFILLER_22_811 VGND VGND VPWR VPWR sky130_fd_sc_hd__fill_1
X_06525_ _01120_ _01124_ VGND VGND VPWR VPWR _01125_ sky130_fd_sc_hd__xnor2_1
XTAP_TAPCELL_ROW_62_1325 VGND VPWR sky130_fd_sc_hd__tapvpwrvgnd_1
XFILLER_34_693 VGND VGND VPWR VPWR sky130_fd_sc_hd__decap_6
X_09244_ _02866_ _03002_ _02914_ _02912_ VGND VGND VPWR VPWR _03003_ sky130_fd_sc_hd__o211a_1
Xclkbuf_leaf_60_clk clknet_3_4__leaf_clk VGND VGND VPWR VPWR clknet_leaf_60_clk sky130_fd_sc_hd__clkbuf_8
XTAP_TAPCELL_ROW_32_850 VGND VPWR sky130_fd_sc_hd__tapvpwrvgnd_1
XPHY_EDGE_ROW_38_Left_194 VGND VGND VPWR VPWR sky130_fd_sc_hd__decap_3
X_09175_ net637 net514 net518 net647 VGND VGND VPWR VPWR _02934_ sky130_fd_sc_hd__a22oi_1
XFILLER_31_15 VPWR VGND VPWR VGND sky130_ef_sc_hd__decap_12
XFILLER_147_15 VPWR VGND VPWR VGND sky130_ef_sc_hd__decap_12
X_08126_ net291 _01970_ VGND VGND VPWR VPWR _00722_ sky130_fd_sc_hd__nor2_1
XFILLER_135_724 VGND VGND VPWR VPWR sky130_fd_sc_hd__decap_4
XFILLER_134_201 VGND VGND VPWR VPWR sky130_fd_sc_hd__fill_1
X_08057_ _01873_ _01912_ VGND VGND VPWR VPWR _01913_ sky130_fd_sc_hd__or2_1
XPHY_EDGE_ROW_1_Right_1 VGND VGND VPWR VPWR sky130_fd_sc_hd__decap_3
X_07008_ net1184 net326 net227 VGND VGND VPWR VPWR _00053_ sky130_fd_sc_hd__mux2_1
XFILLER_0_225 VPWR VGND VPWR VGND sky130_ef_sc_hd__decap_12
Xinput104 s_axis_tdata[8] VGND VGND VPWR VPWR net104 sky130_fd_sc_hd__clkbuf_1
XFILLER_103_665 VGND VGND VPWR VPWR sky130_fd_sc_hd__decap_6
XFILLER_88_376 VGND VGND VPWR VPWR sky130_fd_sc_hd__fill_2
XFILLER_88_365 VGND VGND VPWR VPWR sky130_fd_sc_hd__decap_6
XFILLER_76_505 VGND VGND VPWR VPWR sky130_fd_sc_hd__decap_6
XTAP_TAPCELL_ROW_73_1498 VGND VPWR sky130_fd_sc_hd__tapvpwrvgnd_1
X_08959_ net598 net485 VGND VGND VPWR VPWR _02718_ sky130_fd_sc_hd__nand2_1
XFILLER_76_527 VGND VGND VPWR VPWR sky130_fd_sc_hd__decap_4
XFILLER_57_741 VPWR VGND VPWR VGND sky130_ef_sc_hd__decap_12
X_11970_ _05701_ _05702_ VGND VGND VPWR VPWR _05704_ sky130_fd_sc_hd__xnor2_1
XFILLER_84_571 VGND VGND VPWR VPWR sky130_fd_sc_hd__fill_1
X_10921_ _04665_ _04664_ VGND VGND VPWR VPWR _04666_ sky130_fd_sc_hd__nand2b_1
XFILLER_56_89 VPWR VGND VPWR VGND sky130_ef_sc_hd__decap_12
XFILLER_72_766 VGND VGND VPWR VPWR sky130_fd_sc_hd__decap_3
XFILLER_56_295 VGND VGND VPWR VPWR sky130_fd_sc_hd__decap_4
X_13640_ clknet_leaf_44_clk _00650_ VGND VGND VPWR VPWR u_interface.fifo_data\[13\]\[23\]
+ sky130_fd_sc_hd__dfxtp_1
XFILLER_71_243 VGND VGND VPWR VPWR sky130_fd_sc_hd__fill_1
X_10852_ _04503_ _04505_ VGND VGND VPWR VPWR _04597_ sky130_fd_sc_hd__nand2_1
XFILLER_25_671 VGND VGND VPWR VPWR sky130_fd_sc_hd__fill_1
X_13571_ clknet_leaf_49_clk _00581_ VGND VGND VPWR VPWR u_interface.fifo_data\[4\]\[18\]
+ sky130_fd_sc_hd__dfxtp_1
X_10783_ _04526_ _04527_ _04517_ VGND VGND VPWR VPWR _04529_ sky130_fd_sc_hd__a21oi_1
XFILLER_13_833 VGND VGND VPWR VPWR sky130_fd_sc_hd__decap_6
Xclkbuf_leaf_51_clk clknet_3_6__leaf_clk VGND VGND VPWR VPWR clknet_leaf_51_clk sky130_fd_sc_hd__clkbuf_8
XFILLER_13_877 VPWR VGND VPWR VGND sky130_ef_sc_hd__decap_12
X_12522_ _06245_ _06246_ VGND VGND VPWR VPWR _06247_ sky130_fd_sc_hd__xor2_1
XTAP_TAPCELL_ROW_30_809 VGND VPWR sky130_fd_sc_hd__tapvpwrvgnd_1
XTAP_TAPCELL_ROW_10_500 VGND VPWR sky130_fd_sc_hd__tapvpwrvgnd_1
XFILLER_8_314 VPWR VGND VPWR VGND sky130_ef_sc_hd__decap_12
XFILLER_12_365 VPWR VGND VPWR VGND sky130_ef_sc_hd__decap_12
X_12453_ _06172_ _06178_ _06179_ VGND VGND VPWR VPWR _00840_ sky130_fd_sc_hd__a21oi_1
XFILLER_138_573 VPWR VGND VPWR VGND sky130_ef_sc_hd__decap_12
XFILLER_126_735 VGND VGND VPWR VPWR sky130_fd_sc_hd__fill_1
X_11404_ _05050_ _05056_ _05057_ VGND VGND VPWR VPWR _05144_ sky130_fd_sc_hd__a21boi_2
X_12384_ _06109_ _06110_ VGND VGND VPWR VPWR _06112_ sky130_fd_sc_hd__xor2_1
XFILLER_153_543 VGND VGND VPWR VPWR sky130_fd_sc_hd__fill_1
X_14123_ clknet_leaf_32_clk _01049_ VGND VGND VPWR VPWR u_interface.fifo_wr_ptr\[0\]
+ sky130_fd_sc_hd__dfxtp_1
XFILLER_126_757 VGND VGND VPWR VPWR sky130_fd_sc_hd__decap_4
XTAP_TAPCELL_ROW_93_1819 VGND VPWR sky130_fd_sc_hd__tapvpwrvgnd_1
XFILLER_4_531 VGND VGND VPWR VPWR sky130_fd_sc_hd__fill_1
XFILLER_21_81 VPWR VGND VPWR VGND sky130_ef_sc_hd__decap_12
X_11335_ _05073_ _05074_ VGND VGND VPWR VPWR _05076_ sky130_fd_sc_hd__nor2_1
X_14054_ clknet_leaf_15_clk _00980_ VGND VGND VPWR VPWR u_interface.u_gelu_fp32.u_fp32_to_q16.s1_mant\[16\]
+ sky130_fd_sc_hd__dfxtp_1
X_11266_ _05004_ _05005_ VGND VGND VPWR VPWR _05008_ sky130_fd_sc_hd__xor2_1
X_13005_ net984 net340 net223 VGND VGND VPWR VPWR _01088_ sky130_fd_sc_hd__mux2_1
X_10217_ _03740_ _03858_ _03857_ VGND VGND VPWR VPWR _03968_ sky130_fd_sc_hd__o21ba_1
X_11197_ net205 _04938_ VGND VGND VPWR VPWR _04939_ sky130_fd_sc_hd__and2b_1
X_10148_ _03896_ _03897_ _03898_ VGND VGND VPWR VPWR _03899_ sky130_fd_sc_hd__a21oi_1
XFILLER_0_781 VGND VGND VPWR VPWR sky130_fd_sc_hd__decap_3
XTAP_TAPCELL_ROW_124_2318 VGND VPWR sky130_fd_sc_hd__tapvpwrvgnd_1
X_10079_ _03822_ _03828_ _03829_ VGND VGND VPWR VPWR _03831_ sky130_fd_sc_hd__nand3_1
X_13907_ clknet_leaf_2_clk net882 VGND VGND VPWR VPWR u_interface.u_gelu_fp32.u_synth_top.s1_x\[11\]
+ sky130_fd_sc_hd__dfxtp_1
XFILLER_90_530 VGND VGND VPWR VPWR sky130_fd_sc_hd__fill_2
XFILLER_75_593 VGND VGND VPWR VPWR sky130_fd_sc_hd__fill_2
XTAP_TAPCELL_ROW_18_622 VGND VPWR sky130_fd_sc_hd__tapvpwrvgnd_1
XFILLER_62_265 VPWR VGND VPWR VGND sky130_ef_sc_hd__decap_12
X_13838_ clknet_leaf_78_clk _00848_ VGND VGND VPWR VPWR u_interface.u_gelu_fp32.u_synth_top.s3_mult\[56\]
+ sky130_fd_sc_hd__dfxtp_1
X_13769_ clknet_leaf_57_clk _00779_ VGND VGND VPWR VPWR u_interface.u_gelu_fp32.s2_data\[3\]
+ sky130_fd_sc_hd__dfxtp_1
XFILLER_90_585 VGND VGND VPWR VPWR sky130_fd_sc_hd__decap_3
XFILLER_62_298 VGND VGND VPWR VPWR sky130_fd_sc_hd__decap_8
XFILLER_16_693 VGND VGND VPWR VPWR sky130_fd_sc_hd__decap_6
X_07290_ net1436 net346 net248 VGND VGND VPWR VPWR _00320_ sky130_fd_sc_hd__mux2_1
Xclkbuf_leaf_42_clk clknet_3_7__leaf_clk VGND VGND VPWR VPWR clknet_leaf_42_clk sky130_fd_sc_hd__clkbuf_8
XFILLER_94_3 VPWR VGND VPWR VGND sky130_ef_sc_hd__decap_12
XTAP_TAPCELL_ROW_44_1044 VGND VPWR sky130_fd_sc_hd__tapvpwrvgnd_1
XTAP_TAPCELL_ROW_44_1033 VGND VPWR sky130_fd_sc_hd__tapvpwrvgnd_1
XFILLER_43_490 VGND VGND VPWR VPWR sky130_fd_sc_hd__fill_1
XFILLER_31_641 VPWR VGND VPWR VGND sky130_ef_sc_hd__decap_12
XTAP_TAPCELL_ROW_139_2561 VGND VPWR sky130_fd_sc_hd__tapvpwrvgnd_1
XFILLER_31_685 VPWR VGND VPWR VGND sky130_ef_sc_hd__decap_12
XFILLER_30_195 VGND VGND VPWR VPWR sky130_fd_sc_hd__fill_1
XTAP_TAPCELL_ROW_152_2761 VGND VPWR sky130_fd_sc_hd__tapvpwrvgnd_1
XFILLER_144_510 VGND VGND VPWR VPWR sky130_fd_sc_hd__decap_6
XFILLER_8_881 VPWR VGND VPWR VGND sky130_ef_sc_hd__decap_12
XTAP_TAPCELL_ROW_152_2772 VGND VPWR sky130_fd_sc_hd__tapvpwrvgnd_1
XFILLER_116_223 VGND VGND VPWR VPWR sky130_fd_sc_hd__decap_4
Xhold325 u_interface.fifo_data\[13\]\[29\] VGND VGND VPWR VPWR net1190 sky130_fd_sc_hd__dlygate4sd3_1
Xhold303 u_interface.fifo_data\[12\]\[18\] VGND VGND VPWR VPWR net1168 sky130_fd_sc_hd__dlygate4sd3_1
Xhold314 u_interface.fifo_data\[12\]\[15\] VGND VGND VPWR VPWR net1179 sky130_fd_sc_hd__dlygate4sd3_1
XFILLER_7_391 VGND VGND VPWR VPWR sky130_fd_sc_hd__fill_1
Xhold369 u_interface.fifo_data\[1\]\[24\] VGND VGND VPWR VPWR net1234 sky130_fd_sc_hd__dlygate4sd3_1
X_09931_ _03574_ _03683_ VGND VGND VPWR VPWR _03684_ sky130_fd_sc_hd__nor2_1
Xhold347 u_interface.fifo_data\[14\]\[5\] VGND VGND VPWR VPWR net1212 sky130_fd_sc_hd__dlygate4sd3_1
Xhold336 u_interface.u_gelu_fp32.u_q16_to_fp32.s2_sign VGND VGND VPWR VPWR net1201
+ sky130_fd_sc_hd__dlygate4sd3_1
Xhold358 u_interface.fifo_data\[15\]\[21\] VGND VGND VPWR VPWR net1223 sky130_fd_sc_hd__dlygate4sd3_1
Xfanout816 net822 VGND VGND VPWR VPWR net816 sky130_fd_sc_hd__buf_2
Xfanout805 net809 VGND VGND VPWR VPWR net805 sky130_fd_sc_hd__clkbuf_4
Xfanout827 net829 VGND VGND VPWR VPWR net827 sky130_fd_sc_hd__buf_2
XFILLER_112_462 VPWR VGND VPWR VGND sky130_ef_sc_hd__decap_12
X_09862_ _03614_ _03615_ _03464_ VGND VGND VPWR VPWR _03616_ sky130_fd_sc_hd__a21oi_1
XFILLER_97_140 VGND VGND VPWR VPWR sky130_fd_sc_hd__decap_6
X_08813_ _02513_ _02565_ _02564_ VGND VGND VPWR VPWR _02572_ sky130_fd_sc_hd__a21o_1
XFILLER_100_635 VGND VGND VPWR VPWR sky130_fd_sc_hd__decap_8
X_09793_ net499 net713 _03544_ _03545_ VGND VGND VPWR VPWR _03547_ sky130_fd_sc_hd__nand4_2
X_08744_ net597 net604 net477 net481 VGND VGND VPWR VPWR _02503_ sky130_fd_sc_hd__and4_1
XFILLER_73_508 VGND VGND VPWR VPWR sky130_fd_sc_hd__decap_6
XFILLER_100_679 VGND VGND VPWR VPWR sky130_fd_sc_hd__fill_1
XFILLER_26_15 VPWR VGND VPWR VGND sky130_ef_sc_hd__decap_12
XFILLER_39_785 VGND VGND VPWR VPWR sky130_fd_sc_hd__decap_4
XFILLER_93_390 VGND VGND VPWR VPWR sky130_fd_sc_hd__fill_2
XFILLER_81_541 VGND VGND VPWR VPWR sky130_fd_sc_hd__fill_1
XFILLER_54_755 VGND VGND VPWR VPWR sky130_fd_sc_hd__fill_1
XFILLER_53_232 VPWR VGND VPWR VGND sky130_ef_sc_hd__decap_12
XFILLER_53_221 VGND VGND VPWR VPWR sky130_fd_sc_hd__decap_3
X_08675_ _02281_ _02286_ _02334_ VGND VGND VPWR VPWR _02436_ sky130_fd_sc_hd__and3_1
XTAP_TAPCELL_ROW_37_920 VGND VPWR sky130_fd_sc_hd__tapvpwrvgnd_1
XTAP_TAPCELL_ROW_37_931 VGND VPWR sky130_fd_sc_hd__tapvpwrvgnd_1
X_07626_ _01716_ _01701_ net331 VGND VGND VPWR VPWR _01717_ sky130_fd_sc_hd__mux2_1
XFILLER_26_457 VGND VGND VPWR VPWR sky130_fd_sc_hd__decap_3
XFILLER_41_405 VPWR VGND VPWR VGND sky130_ef_sc_hd__decap_12
X_07557_ _01632_ _01628_ net547 VGND VGND VPWR VPWR _01672_ sky130_fd_sc_hd__mux2_1
XPHY_EDGE_ROW_46_Left_202 VGND VGND VPWR VPWR sky130_fd_sc_hd__decap_3
X_06508_ net727 VGND VGND VPWR VPWR _01108_ sky130_fd_sc_hd__inv_2
Xclkbuf_leaf_33_clk clknet_3_6__leaf_clk VGND VGND VPWR VPWR clknet_leaf_33_clk sky130_fd_sc_hd__clkbuf_8
XFILLER_139_337 VGND VGND VPWR VPWR sky130_fd_sc_hd__fill_2
X_07488_ _01589_ _01591_ net555 VGND VGND VPWR VPWR _01621_ sky130_fd_sc_hd__mux2_1
XFILLER_10_825 VPWR VGND VPWR VGND sky130_ef_sc_hd__decap_12
XFILLER_21_151 VPWR VGND VPWR VGND sky130_ef_sc_hd__decap_12
XFILLER_42_36 VGND VGND VPWR VPWR sky130_fd_sc_hd__decap_4
X_09227_ _02945_ _02964_ _02985_ VGND VGND VPWR VPWR _02986_ sky130_fd_sc_hd__nand3_1
XFILLER_148_860 VGND VGND VPWR VPWR sky130_fd_sc_hd__fill_1
XFILLER_10_869 VPWR VGND VPWR VGND sky130_ef_sc_hd__decap_12
XFILLER_21_195 VPWR VGND VPWR VGND sky130_ef_sc_hd__decap_12
XFILLER_147_370 VGND VGND VPWR VPWR sky130_fd_sc_hd__decap_6
X_09158_ _02718_ _02720_ VGND VGND VPWR VPWR _02917_ sky130_fd_sc_hd__xnor2_1
XFILLER_108_735 VGND VGND VPWR VPWR sky130_fd_sc_hd__decap_3
XFILLER_5_317 VGND VGND VPWR VPWR sky130_fd_sc_hd__decap_8
X_09089_ _02795_ _02834_ _02846_ VGND VGND VPWR VPWR _02848_ sky130_fd_sc_hd__nand3_1
X_08109_ u_interface.u_gelu_fp32.u_fp32_to_q16.s3_mag\[9\] u_interface.u_gelu_fp32.u_fp32_to_q16.s3_mag\[8\]
+ _01877_ u_interface.u_gelu_fp32.u_fp32_to_q16.s3_mag\[10\] VGND VGND VPWR VPWR _01956_
+ sky130_fd_sc_hd__a31o_1
XFILLER_122_204 VGND VGND VPWR VPWR sky130_fd_sc_hd__fill_2
XTAP_TAPCELL_ROW_75_1538 VGND VPWR sky130_fd_sc_hd__tapvpwrvgnd_1
XPHY_EDGE_ROW_55_Left_211 VGND VGND VPWR VPWR sky130_fd_sc_hd__decap_3
X_11120_ _04860_ _04861_ VGND VGND VPWR VPWR _04863_ sky130_fd_sc_hd__nor2_1
XFILLER_123_749 VGND VGND VPWR VPWR sky130_fd_sc_hd__decap_4
Xhold870 u_interface.u_gelu_fp32.u_fp32_to_q16.s3_mag\[23\] VGND VGND VPWR VPWR net1735
+ sky130_fd_sc_hd__dlygate4sd3_1
Xhold881 u_interface.u_gelu_fp32.u_q16_to_fp32.s3_norm_mag\[22\] VGND VGND VPWR VPWR
+ net1746 sky130_fd_sc_hd__dlygate4sd3_1
Xhold892 u_interface.u_gelu_fp32.u_synth_top.s2_b\[7\] VGND VGND VPWR VPWR net1757
+ sky130_fd_sc_hd__dlygate4sd3_1
X_11051_ _04676_ _04693_ _04695_ VGND VGND VPWR VPWR _04794_ sky130_fd_sc_hd__a21o_1
XFILLER_131_782 VGND VGND VPWR VPWR sky130_fd_sc_hd__fill_2
XFILLER_107_95 VGND VGND VPWR VPWR sky130_fd_sc_hd__decap_4
XFILLER_103_495 VGND VGND VPWR VPWR sky130_fd_sc_hd__decap_8
X_10002_ _03653_ _03664_ VGND VGND VPWR VPWR _03754_ sky130_fd_sc_hd__nand2_1
XFILLER_67_55 VGND VGND VPWR VPWR sky130_fd_sc_hd__fill_1
XFILLER_49_516 VGND VGND VPWR VPWR sky130_fd_sc_hd__fill_1
XFILLER_88_195 VGND VGND VPWR VPWR sky130_fd_sc_hd__fill_1
XFILLER_76_357 VGND VGND VPWR VPWR sky130_fd_sc_hd__decap_6
XTAP_TAPCELL_ROW_106_2037 VGND VPWR sky130_fd_sc_hd__tapvpwrvgnd_1
XTAP_TAPCELL_ROW_106_2026 VGND VPWR sky130_fd_sc_hd__tapvpwrvgnd_1
XFILLER_85_891 VGND VGND VPWR VPWR sky130_fd_sc_hd__decap_4
XTAP_TAPCELL_ROW_4_394 VGND VPWR sky130_fd_sc_hd__tapvpwrvgnd_1
XFILLER_29_240 VPWR VGND VPWR VGND sky130_ef_sc_hd__decap_12
XFILLER_83_21 VGND VGND VPWR VPWR sky130_fd_sc_hd__fill_1
X_11953_ _05684_ _05685_ VGND VGND VPWR VPWR _05687_ sky130_fd_sc_hd__xnor2_1
XPHY_EDGE_ROW_64_Left_220 VGND VGND VPWR VPWR sky130_fd_sc_hd__decap_3
X_10904_ _04595_ _04596_ _04647_ _04648_ VGND VGND VPWR VPWR _04649_ sky130_fd_sc_hd__a2bb2o_1
XFILLER_44_265 VPWR VGND VPWR VGND sky130_ef_sc_hd__decap_12
X_11884_ _05618_ _05617_ VGND VGND VPWR VPWR _05619_ sky130_fd_sc_hd__and2b_1
X_10835_ net460 net712 VGND VGND VPWR VPWR _04580_ sky130_fd_sc_hd__nand2_1
XFILLER_32_438 VGND VGND VPWR VPWR sky130_fd_sc_hd__decap_4
X_13623_ clknet_leaf_75_clk _00633_ VGND VGND VPWR VPWR u_interface.fifo_data\[13\]\[6\]
+ sky130_fd_sc_hd__dfxtp_1
Xclkbuf_leaf_24_clk clknet_3_1__leaf_clk VGND VGND VPWR VPWR clknet_leaf_24_clk sky130_fd_sc_hd__clkbuf_8
XFILLER_13_641 VPWR VGND VPWR VGND sky130_ef_sc_hd__decap_12
X_13554_ clknet_leaf_53_clk _00564_ VGND VGND VPWR VPWR u_interface.fifo_data\[4\]\[1\]
+ sky130_fd_sc_hd__dfxtp_1
X_10766_ net586 net595 net404 net400 VGND VGND VPWR VPWR _04512_ sky130_fd_sc_hd__and4_1
XFILLER_13_685 VPWR VGND VPWR VGND sky130_ef_sc_hd__decap_12
X_13485_ clknet_leaf_4_clk _00495_ VGND VGND VPWR VPWR u_interface.u_gelu_fp32.u_synth_top.s2_b\[8\]
+ sky130_fd_sc_hd__dfxtp_1
X_10697_ _04424_ _04426_ VGND VGND VPWR VPWR _04443_ sky130_fd_sc_hd__nand2b_2
XFILLER_8_133 VGND VGND VPWR VPWR sky130_fd_sc_hd__decap_6
X_12505_ _06136_ _06228_ VGND VGND VPWR VPWR _06230_ sky130_fd_sc_hd__nor2_1
XFILLER_145_318 VGND VGND VPWR VPWR sky130_fd_sc_hd__fill_1
XFILLER_139_893 VGND VGND VPWR VPWR sky130_fd_sc_hd__decap_3
XFILLER_139_882 VGND VGND VPWR VPWR sky130_fd_sc_hd__decap_3
XFILLER_126_521 VGND VGND VPWR VPWR sky130_fd_sc_hd__fill_1
XFILLER_8_177 VPWR VGND VPWR VGND sky130_ef_sc_hd__decap_12
X_12436_ _06125_ _06162_ VGND VGND VPWR VPWR _06163_ sky130_fd_sc_hd__xnor2_1
XTAP_TAPCELL_ROW_134_2480 VGND VPWR sky130_fd_sc_hd__tapvpwrvgnd_1
X_14106_ clknet_leaf_27_clk _01032_ VGND VGND VPWR VPWR u_interface.meta_tuser_pipe\[1\]
+ sky130_fd_sc_hd__dfxtp_1
XFILLER_126_576 VGND VGND VPWR VPWR sky130_fd_sc_hd__decap_6
XFILLER_113_204 VGND VGND VPWR VPWR sky130_fd_sc_hd__fill_1
XFILLER_99_427 VPWR VGND VPWR VGND sky130_ef_sc_hd__decap_12
XFILLER_99_405 VPWR VGND VPWR VGND sky130_ef_sc_hd__decap_12
X_12367_ _06019_ _06094_ VGND VGND VPWR VPWR _06095_ sky130_fd_sc_hd__or2_1
XFILLER_99_449 VPWR VGND VPWR VGND sky130_ef_sc_hd__decap_12
X_11318_ _05050_ _05058_ VGND VGND VPWR VPWR _05059_ sky130_fd_sc_hd__xor2_1
X_12298_ _06025_ _06026_ VGND VGND VPWR VPWR _06027_ sky130_fd_sc_hd__and2_1
XFILLER_5_895 VGND VGND VPWR VPWR sky130_fd_sc_hd__fill_1
X_14037_ clknet_leaf_33_clk _00963_ VGND VGND VPWR VPWR u_interface.core_valid_out
+ sky130_fd_sc_hd__dfxtp_1
X_11249_ _04989_ _04990_ VGND VGND VPWR VPWR _04991_ sky130_fd_sc_hd__nand2_1
XFILLER_67_302 VPWR VGND VPWR VGND sky130_ef_sc_hd__decap_12
XFILLER_83_817 VPWR VGND VPWR VGND sky130_ef_sc_hd__decap_12
XFILLER_68_869 VGND VGND VPWR VPWR sky130_fd_sc_hd__decap_6
X_06790_ u_interface.fifo_data\[12\]\[20\] u_interface.fifo_data\[13\]\[20\] u_interface.fifo_data\[14\]\[20\]
+ u_interface.fifo_data\[15\]\[20\] net758 net741 VGND VGND VPWR VPWR _01345_ sky130_fd_sc_hd__mux4_1
X_08460_ _02171_ _02174_ _02172_ VGND VGND VPWR VPWR _02251_ sky130_fd_sc_hd__a21bo_1
XFILLER_23_405 VPWR VGND VPWR VGND sky130_ef_sc_hd__decap_12
XFILLER_24_917 VGND VGND VPWR VPWR sky130_fd_sc_hd__decap_4
X_07411_ u_interface.u_gelu_fp32.u_fp32_to_q16.s2_norm_mag\[22\] u_interface.u_gelu_fp32.u_fp32_to_q16.s2_norm_mag\[23\]
+ net559 VGND VGND VPWR VPWR _01547_ sky130_fd_sc_hd__mux2_1
X_08391_ u_interface.u_gelu_fp32.u_synth_top.s3_mult\[29\] u_interface.u_gelu_fp32.u_synth_top.s3_b\[13\]
+ VGND VGND VPWR VPWR _02182_ sky130_fd_sc_hd__nor2_1
XFILLER_63_585 VGND VGND VPWR VPWR sky130_fd_sc_hd__decap_3
XFILLER_36_799 VPWR VGND VPWR VGND sky130_ef_sc_hd__decap_12
Xclkbuf_leaf_15_clk clknet_3_2__leaf_clk VGND VGND VPWR VPWR clknet_leaf_15_clk sky130_fd_sc_hd__clkbuf_8
X_07342_ net370 net1511 net243 VGND VGND VPWR VPWR _00372_ sky130_fd_sc_hd__mux2_1
XFILLER_23_449 VGND VGND VPWR VPWR sky130_fd_sc_hd__decap_4
XTAP_TAPCELL_ROW_154_2801 VGND VPWR sky130_fd_sc_hd__tapvpwrvgnd_1
XFILLER_31_482 VPWR VGND VPWR VGND sky130_ef_sc_hd__decap_12
X_07273_ net1193 net380 net245 VGND VGND VPWR VPWR _00303_ sky130_fd_sc_hd__mux2_1
X_09012_ net598 net604 net487 net492 VGND VGND VPWR VPWR _02771_ sky130_fd_sc_hd__and4_1
Xhold100 u_interface.meta_tlast_pipe\[1\] VGND VGND VPWR VPWR net965 sky130_fd_sc_hd__dlygate4sd3_1
Xhold133 u_interface.fifo_tlast\[13\] VGND VGND VPWR VPWR net998 sky130_fd_sc_hd__dlygate4sd3_1
XFILLER_105_705 VGND VGND VPWR VPWR sky130_fd_sc_hd__fill_2
Xhold111 u_interface.fifo_data\[13\]\[0\] VGND VGND VPWR VPWR net976 sky130_fd_sc_hd__dlygate4sd3_1
XTAP_TAPCELL_ROW_57_1246 VGND VPWR sky130_fd_sc_hd__tapvpwrvgnd_1
XFILLER_2_309 VPWR VGND VPWR VGND sky130_ef_sc_hd__decap_12
Xhold144 u_interface.fifo_data\[12\]\[21\] VGND VGND VPWR VPWR net1009 sky130_fd_sc_hd__dlygate4sd3_1
Xhold122 u_interface.fifo_data\[10\]\[21\] VGND VGND VPWR VPWR net987 sky130_fd_sc_hd__dlygate4sd3_1
Xhold177 u_interface.fifo_data\[10\]\[28\] VGND VGND VPWR VPWR net1042 sky130_fd_sc_hd__dlygate4sd3_1
Xhold155 u_interface.fifo_data\[9\]\[30\] VGND VGND VPWR VPWR net1020 sky130_fd_sc_hd__dlygate4sd3_1
Xhold166 u_interface.fifo_data\[15\]\[20\] VGND VGND VPWR VPWR net1031 sky130_fd_sc_hd__dlygate4sd3_1
Xfanout613 net614 VGND VGND VPWR VPWR net613 sky130_fd_sc_hd__buf_2
Xhold188 u_interface.fifo_data\[2\]\[7\] VGND VGND VPWR VPWR net1053 sky130_fd_sc_hd__dlygate4sd3_1
Xhold199 u_interface.fifo_data\[2\]\[17\] VGND VGND VPWR VPWR net1064 sky130_fd_sc_hd__dlygate4sd3_1
XFILLER_104_259 VGND VGND VPWR VPWR sky130_fd_sc_hd__fill_1
X_09914_ _03665_ _03666_ _03559_ _03561_ VGND VGND VPWR VPWR _03667_ sky130_fd_sc_hd__o211a_1
Xfanout624 u_interface.u_gelu_fp32.u_synth_top.s2_m\[5\] VGND VGND VPWR VPWR net624
+ sky130_fd_sc_hd__clkbuf_4
Xfanout602 net608 VGND VGND VPWR VPWR net602 sky130_fd_sc_hd__buf_2
Xfanout646 net647 VGND VGND VPWR VPWR net646 sky130_fd_sc_hd__buf_2
XFILLER_112_270 VPWR VGND VPWR VGND sky130_ef_sc_hd__decap_12
X_09845_ net463 net641 _03597_ _03598_ VGND VGND VPWR VPWR _03599_ sky130_fd_sc_hd__a22o_1
Xfanout657 u_interface.u_gelu_fp32.u_synth_top.s2_m\[9\] VGND VGND VPWR VPWR net657
+ sky130_fd_sc_hd__buf_2
XFILLER_86_622 VGND VGND VPWR VPWR sky130_fd_sc_hd__fill_1
Xfanout635 net636 VGND VGND VPWR VPWR net635 sky130_fd_sc_hd__buf_2
XTAP_TAPCELL_ROW_70_1457 VGND VPWR sky130_fd_sc_hd__tapvpwrvgnd_1
XFILLER_58_302 VGND VGND VPWR VPWR sky130_fd_sc_hd__decap_6
Xfanout679 net680 VGND VGND VPWR VPWR net679 sky130_fd_sc_hd__clkbuf_2
XFILLER_100_421 VGND VGND VPWR VPWR sky130_fd_sc_hd__fill_2
Xfanout668 net674 VGND VGND VPWR VPWR net668 sky130_fd_sc_hd__buf_2
X_06988_ net326 net1392 net259 VGND VGND VPWR VPWR _00044_ sky130_fd_sc_hd__mux2_1
X_09776_ _03421_ _03516_ _03517_ VGND VGND VPWR VPWR _03530_ sky130_fd_sc_hd__o21ai_2
XFILLER_74_839 VPWR VGND VPWR VGND sky130_ef_sc_hd__decap_12
X_08727_ _02479_ _02485_ _02478_ VGND VGND VPWR VPWR _02486_ sky130_fd_sc_hd__a21o_1
X_08658_ net156 _02423_ VGND VGND VPWR VPWR _02424_ sky130_fd_sc_hd__nand2_1
XTAP_TAPCELL_ROW_1_353 VGND VPWR sky130_fd_sc_hd__tapvpwrvgnd_1
XFILLER_27_777 VGND VGND VPWR VPWR sky130_fd_sc_hd__decap_6
XFILLER_81_360 VPWR VGND VPWR VGND sky130_ef_sc_hd__decap_12
X_07609_ net803 net1549 net298 _01703_ VGND VGND VPWR VPWR _00471_ sky130_fd_sc_hd__a22o_1
XFILLER_53_35 VGND VGND VPWR VPWR sky130_fd_sc_hd__fill_1
X_08589_ net159 _02373_ VGND VGND VPWR VPWR _02374_ sky130_fd_sc_hd__nand2_1
XFILLER_81_393 VGND VGND VPWR VPWR sky130_fd_sc_hd__decap_3
XFILLER_41_246 VPWR VGND VPWR VGND sky130_ef_sc_hd__decap_12
X_10620_ _04351_ _04363_ _04364_ VGND VGND VPWR VPWR _04367_ sky130_fd_sc_hd__nor3_1
XFILLER_155_605 VGND VGND VPWR VPWR sky130_fd_sc_hd__fill_1
X_10551_ _04256_ _04257_ _04296_ _04297_ VGND VGND VPWR VPWR _04299_ sky130_fd_sc_hd__a22oi_2
X_10482_ _04227_ _04228_ _04229_ VGND VGND VPWR VPWR _04230_ sky130_fd_sc_hd__nor3_1
X_13270_ clknet_leaf_70_clk _00280_ VGND VGND VPWR VPWR u_interface.fifo_data\[0\]\[12\]
+ sky130_fd_sc_hd__dfxtp_1
XTAP_TAPCELL_ROW_20_650 VGND VPWR sky130_fd_sc_hd__tapvpwrvgnd_1
XFILLER_10_699 VGND VGND VPWR VPWR sky130_fd_sc_hd__fill_1
XFILLER_6_637 VGND VGND VPWR VPWR sky130_fd_sc_hd__decap_6
XFILLER_5_125 VPWR VGND VPWR VGND sky130_ef_sc_hd__decap_12
X_12221_ _05949_ _05950_ VGND VGND VPWR VPWR _05951_ sky130_fd_sc_hd__nand2b_1
XTAP_TAPCELL_ROW_20_661 VGND VPWR sky130_fd_sc_hd__tapvpwrvgnd_1
XFILLER_108_587 VGND VGND VPWR VPWR sky130_fd_sc_hd__fill_1
XFILLER_108_565 VGND VGND VPWR VPWR sky130_fd_sc_hd__fill_1
XFILLER_5_169 VPWR VGND VPWR VGND sky130_ef_sc_hd__decap_12
XFILLER_123_535 VGND VGND VPWR VPWR sky130_fd_sc_hd__fill_1
XFILLER_118_83 VGND VGND VPWR VPWR sky130_fd_sc_hd__fill_1
X_12152_ net717 net407 _05825_ _05824_ VGND VGND VPWR VPWR _05883_ sky130_fd_sc_hd__a31o_1
XFILLER_78_54 VGND VGND VPWR VPWR sky130_fd_sc_hd__fill_1
X_11103_ _04748_ _04750_ _04844_ VGND VGND VPWR VPWR _04846_ sky130_fd_sc_hd__a21oi_1
XTAP_TAPCELL_ROW_9_486 VGND VPWR sky130_fd_sc_hd__tapvpwrvgnd_1
XTAP_TAPCELL_ROW_9_475 VGND VPWR sky130_fd_sc_hd__tapvpwrvgnd_1
X_12083_ _05670_ _05744_ VGND VGND VPWR VPWR _05815_ sky130_fd_sc_hd__nand2_4
X_11034_ _04775_ _04776_ VGND VGND VPWR VPWR _04778_ sky130_fd_sc_hd__xor2_1
XFILLER_49_324 VPWR VGND VPWR VGND sky130_ef_sc_hd__decap_12
XFILLER_134_71 VGND VGND VPWR VPWR sky130_fd_sc_hd__decap_4
XFILLER_103_281 VPWR VGND VPWR VGND sky130_ef_sc_hd__decap_12
XFILLER_49_368 VGND VGND VPWR VPWR sky130_fd_sc_hd__fill_1
XFILLER_91_113 VPWR VGND VPWR VGND sky130_ef_sc_hd__decap_12
XFILLER_64_338 VGND VGND VPWR VPWR sky130_fd_sc_hd__decap_6
X_12985_ net1146 net381 net221 VGND VGND VPWR VPWR _01068_ sky130_fd_sc_hd__mux2_1
XFILLER_45_530 VPWR VGND VPWR VGND sky130_ef_sc_hd__decap_12
XFILLER_92_669 VGND VGND VPWR VPWR sky130_fd_sc_hd__decap_3
X_11936_ net717 net415 net410 VGND VGND VPWR VPWR _05670_ sky130_fd_sc_hd__nand3_2
XFILLER_18_755 VGND VGND VPWR VPWR sky130_fd_sc_hd__fill_1
XFILLER_72_371 VGND VGND VPWR VPWR sky130_fd_sc_hd__fill_1
XTAP_TAPCELL_ROW_28_783 VGND VPWR sky130_fd_sc_hd__tapvpwrvgnd_1
XFILLER_32_202 VPWR VGND VPWR VGND sky130_ef_sc_hd__decap_12
XFILLER_72_393 VGND VGND VPWR VPWR sky130_fd_sc_hd__decap_3
XFILLER_60_533 VGND VGND VPWR VPWR sky130_fd_sc_hd__decap_3
X_11867_ net684 net402 net398 net675 VGND VGND VPWR VPWR _05602_ sky130_fd_sc_hd__a22oi_1
XFILLER_21_909 VPWR VGND VPWR VGND sky130_ef_sc_hd__decap_12
X_10818_ _04445_ _04562_ VGND VGND VPWR VPWR _04563_ sky130_fd_sc_hd__nand2_1
X_13606_ clknet_leaf_82_clk _00616_ VGND VGND VPWR VPWR u_interface.fifo_data\[3\]\[21\]
+ sky130_fd_sc_hd__dfxtp_1
X_11798_ net650 net394 _05448_ _05447_ VGND VGND VPWR VPWR _05534_ sky130_fd_sc_hd__a31o_1
X_13537_ clknet_leaf_32_clk _00547_ VGND VGND VPWR VPWR u_interface.fifo_data\[5\]\[16\]
+ sky130_fd_sc_hd__dfxtp_1
XTAP_TAPCELL_ROW_119_2239 VGND VPWR sky130_fd_sc_hd__tapvpwrvgnd_1
X_10749_ _04493_ _04494_ VGND VGND VPWR VPWR _04495_ sky130_fd_sc_hd__and2b_1
XFILLER_9_453 VGND VGND VPWR VPWR sky130_fd_sc_hd__fill_1
XFILLER_13_482 VPWR VGND VPWR VGND sky130_ef_sc_hd__decap_12
XFILLER_145_104 VGND VGND VPWR VPWR sky130_fd_sc_hd__decap_8
XFILLER_145_137 VGND VGND VPWR VPWR sky130_fd_sc_hd__fill_2
XFILLER_127_830 VGND VGND VPWR VPWR sky130_fd_sc_hd__fill_1
X_13468_ clknet_leaf_63_clk _00478_ VGND VGND VPWR VPWR u_interface.u_gelu_fp32.u_q16_to_fp32.s3_norm_mag\[8\]
+ sky130_fd_sc_hd__dfxtp_1
XFILLER_9_497 VGND VGND VPWR VPWR sky130_fd_sc_hd__decap_6
XFILLER_126_362 VGND VGND VPWR VPWR sky130_fd_sc_hd__fill_2
X_13399_ clknet_leaf_63_clk _00409_ VGND VGND VPWR VPWR u_interface.fifo_data\[6\]\[12\]
+ sky130_fd_sc_hd__dfxtp_1
XFILLER_57_3 VPWR VGND VPWR VGND sky130_ef_sc_hd__decap_12
X_12419_ _06145_ _06144_ VGND VGND VPWR VPWR _06146_ sky130_fd_sc_hd__nand2b_1
XFILLER_142_822 VGND VGND VPWR VPWR sky130_fd_sc_hd__fill_2
XFILLER_126_384 VPWR VGND VPWR VGND sky130_ef_sc_hd__decap_12
X_07960_ net544 _01625_ net279 _01670_ net543 VGND VGND VPWR VPWR _01842_ sky130_fd_sc_hd__a32o_1
XFILLER_99_279 VGND VGND VPWR VPWR sky130_fd_sc_hd__fill_1
Xclkbuf_leaf_4_clk clknet_3_0__leaf_clk VGND VGND VPWR VPWR clknet_leaf_4_clk sky130_fd_sc_hd__clkbuf_8
X_06911_ u_interface.u_gelu_fp32.u_synth_top.s1_x\[19\] u_interface.u_gelu_fp32.u_synth_top.comb_b\[18\]
+ VGND VGND VPWR VPWR _01450_ sky130_fd_sc_hd__xnor2_1
XPHY_EDGE_ROW_155_Right_155 VGND VGND VPWR VPWR sky130_fd_sc_hd__decap_3
X_07891_ net1058 net574 net268 VGND VGND VPWR VPWR _00652_ sky130_fd_sc_hd__mux2_1
XTAP_TAPCELL_ROW_52_1165 VGND VPWR sky130_fd_sc_hd__tapvpwrvgnd_1
XTAP_TAPCELL_ROW_147_2693 VGND VPWR sky130_fd_sc_hd__tapvpwrvgnd_1
XTAP_TAPCELL_ROW_147_2682 VGND VPWR sky130_fd_sc_hd__tapvpwrvgnd_1
X_06842_ u_interface.fifo_data\[4\]\[26\] u_interface.fifo_data\[5\]\[26\] u_interface.fifo_data\[6\]\[26\]
+ u_interface.fifo_data\[7\]\[26\] net770 net753 VGND VGND VPWR VPWR _01391_ sky130_fd_sc_hd__mux4_1
X_09630_ net499 net696 _03384_ _03385_ VGND VGND VPWR VPWR _03386_ sky130_fd_sc_hd__a22o_1
XFILLER_68_688 VGND VGND VPWR VPWR sky130_fd_sc_hd__fill_1
X_09561_ _03217_ _03219_ _03316_ _03317_ VGND VGND VPWR VPWR _03318_ sky130_fd_sc_hd__o211a_1
X_06773_ u_interface.fifo_data\[8\]\[18\] u_interface.fifo_data\[9\]\[18\] u_interface.fifo_data\[10\]\[18\]
+ u_interface.fifo_data\[11\]\[18\] net762 net745 VGND VGND VPWR VPWR _01330_ sky130_fd_sc_hd__mux4_1
XFILLER_82_113 VGND VGND VPWR VPWR sky130_fd_sc_hd__fill_1
XFILLER_55_327 VGND VGND VPWR VPWR sky130_fd_sc_hd__decap_8
X_08512_ net523 u_interface.u_gelu_fp32.u_synth_top.s3_mult\[55\] VGND VGND VPWR VPWR
+ _02303_ sky130_fd_sc_hd__xnor2_1
X_09492_ net499 net689 _03247_ _03248_ VGND VGND VPWR VPWR _03249_ sky130_fd_sc_hd__a22o_1
XFILLER_91_691 VGND VGND VPWR VPWR sky130_fd_sc_hd__fill_1
XFILLER_63_371 VPWR VGND VPWR VGND sky130_ef_sc_hd__decap_12
XFILLER_51_511 VPWR VGND VPWR VGND sky130_ef_sc_hd__decap_12
XFILLER_24_725 VPWR VGND VPWR VGND sky130_ef_sc_hd__decap_12
XFILLER_36_585 VGND VGND VPWR VPWR sky130_fd_sc_hd__decap_3
X_08443_ _02186_ _02187_ _02232_ _02184_ VGND VGND VPWR VPWR _02234_ sky130_fd_sc_hd__o31a_1
XFILLER_63_393 VGND VGND VPWR VPWR sky130_fd_sc_hd__decap_3
XFILLER_24_769 VPWR VGND VPWR VGND sky130_ef_sc_hd__decap_12
XFILLER_51_599 VGND VGND VPWR VPWR sky130_fd_sc_hd__fill_1
XFILLER_51_577 VGND VGND VPWR VPWR sky130_fd_sc_hd__decap_4
XFILLER_11_408 VGND VGND VPWR VPWR sky130_fd_sc_hd__decap_3
XFILLER_23_27 VPWR VGND VPWR VGND sky130_ef_sc_hd__decap_12
XFILLER_23_268 VPWR VGND VPWR VGND sky130_ef_sc_hd__decap_12
X_08374_ _02163_ _02164_ VGND VGND VPWR VPWR _02165_ sky130_fd_sc_hd__nand2_1
X_07325_ net972 net341 net256 VGND VGND VPWR VPWR _00355_ sky130_fd_sc_hd__mux2_1
XFILLER_109_329 VGND VGND VPWR VPWR sky130_fd_sc_hd__decap_6
X_07256_ net1532 net344 net250 VGND VGND VPWR VPWR _00288_ sky130_fd_sc_hd__mux2_1
XFILLER_136_126 VGND VGND VPWR VPWR sky130_fd_sc_hd__fill_2
X_07187_ net1057 net570 net262 VGND VGND VPWR VPWR _00227_ sky130_fd_sc_hd__mux2_1
XFILLER_151_129 VGND VGND VPWR VPWR sky130_fd_sc_hd__fill_1
XFILLER_144_170 VGND VGND VPWR VPWR sky130_fd_sc_hd__fill_2
XFILLER_132_321 VPWR VGND VPWR VGND sky130_ef_sc_hd__decap_12
XFILLER_3_629 VPWR VGND VPWR VGND sky130_ef_sc_hd__decap_12
XFILLER_132_354 VGND VGND VPWR VPWR sky130_fd_sc_hd__decap_8
XFILLER_2_139 VGND VGND VPWR VPWR sky130_fd_sc_hd__fill_1
XFILLER_132_365 VGND VGND VPWR VPWR sky130_fd_sc_hd__fill_2
XFILLER_87_920 VGND VGND VPWR VPWR sky130_fd_sc_hd__fill_1
Xfanout432 net433 VGND VGND VPWR VPWR net432 sky130_fd_sc_hd__clkbuf_2
XFILLER_78_419 VGND VGND VPWR VPWR sky130_fd_sc_hd__fill_1
XTAP_TAPCELL_ROW_6_434 VGND VPWR sky130_fd_sc_hd__tapvpwrvgnd_1
Xfanout410 net411 VGND VGND VPWR VPWR net410 sky130_fd_sc_hd__buf_2
Xfanout421 u_interface.u_gelu_fp32.u_synth_top.s2_dx\[23\] VGND VGND VPWR VPWR net421
+ sky130_fd_sc_hd__clkbuf_2
Xfanout454 net455 VGND VGND VPWR VPWR net454 sky130_fd_sc_hd__buf_2
Xfanout465 u_interface.u_gelu_fp32.u_synth_top.s2_dx\[13\] VGND VGND VPWR VPWR net465
+ sky130_fd_sc_hd__buf_2
Xfanout443 net445 VGND VGND VPWR VPWR net443 sky130_fd_sc_hd__clkbuf_2
Xfanout498 u_interface.u_gelu_fp32.u_synth_top.s2_dx\[5\] VGND VGND VPWR VPWR net498
+ sky130_fd_sc_hd__buf_2
Xfanout487 net489 VGND VGND VPWR VPWR net487 sky130_fd_sc_hd__clkbuf_2
Xfanout476 net477 VGND VGND VPWR VPWR net476 sky130_fd_sc_hd__buf_2
XPHY_EDGE_ROW_122_Right_122 VGND VGND VPWR VPWR sky130_fd_sc_hd__decap_3
X_09828_ _03580_ _03581_ VGND VGND VPWR VPWR _03582_ sky130_fd_sc_hd__and2b_1
XFILLER_58_154 VGND VGND VPWR VPWR sky130_fd_sc_hd__fill_1
X_09759_ _03512_ _03513_ _03401_ _03403_ VGND VGND VPWR VPWR _03514_ sky130_fd_sc_hd__a211o_1
XFILLER_100_273 VGND VGND VPWR VPWR sky130_fd_sc_hd__decap_3
XFILLER_74_658 VGND VGND VPWR VPWR sky130_fd_sc_hd__fill_1
XFILLER_73_124 VGND VGND VPWR VPWR sky130_fd_sc_hd__decap_8
XFILLER_73_113 VGND VGND VPWR VPWR sky130_fd_sc_hd__fill_1
XFILLER_104_96 VGND VGND VPWR VPWR sky130_fd_sc_hd__decap_3
XFILLER_39_390 VGND VGND VPWR VPWR sky130_fd_sc_hd__fill_2
X_12770_ _01779_ _06401_ VGND VGND VPWR VPWR _00945_ sky130_fd_sc_hd__nor2_1
XFILLER_27_585 VPWR VGND VPWR VGND sky130_ef_sc_hd__decap_12
XFILLER_42_500 VGND VGND VPWR VPWR sky130_fd_sc_hd__decap_6
XFILLER_42_522 VGND VGND VPWR VPWR sky130_fd_sc_hd__fill_2
XTAP_TAPCELL_ROW_83_1659 VGND VPWR sky130_fd_sc_hd__tapvpwrvgnd_1
XFILLER_14_246 VGND VGND VPWR VPWR sky130_fd_sc_hd__decap_6
XTAP_TAPCELL_ROW_25_731 VGND VPWR sky130_fd_sc_hd__tapvpwrvgnd_1
XTAP_TAPCELL_ROW_25_742 VGND VPWR sky130_fd_sc_hd__tapvpwrvgnd_1
X_11721_ _05457_ _05456_ VGND VGND VPWR VPWR _05458_ sky130_fd_sc_hd__and2b_1
XFILLER_70_886 VGND VGND VPWR VPWR sky130_fd_sc_hd__fill_2
X_11652_ _05388_ _05389_ VGND VGND VPWR VPWR _05390_ sky130_fd_sc_hd__nor2_1
XFILLER_128_605 VGND VGND VPWR VPWR sky130_fd_sc_hd__fill_1
XFILLER_80_66 VGND VGND VPWR VPWR sky130_fd_sc_hd__decap_8
X_10603_ _04348_ _04349_ VGND VGND VPWR VPWR _04350_ sky130_fd_sc_hd__and2b_1
XFILLER_10_441 VPWR VGND VPWR VGND sky130_ef_sc_hd__decap_12
X_11583_ _05237_ _05250_ _05253_ VGND VGND VPWR VPWR _05321_ sky130_fd_sc_hd__o21ai_2
X_13322_ clknet_leaf_75_clk _00332_ VGND VGND VPWR VPWR u_interface.fifo_data\[8\]\[31\]
+ sky130_fd_sc_hd__dfxtp_1
XFILLER_128_649 VGND VGND VPWR VPWR sky130_fd_sc_hd__fill_1
XFILLER_127_137 VGND VGND VPWR VPWR sky130_fd_sc_hd__fill_2
XFILLER_109_841 VGND VGND VPWR VPWR sky130_fd_sc_hd__decap_4
X_10534_ net609 net423 VGND VGND VPWR VPWR _04282_ sky130_fd_sc_hd__nand2_1
XFILLER_13_93 VPWR VGND VPWR VGND sky130_ef_sc_hd__decap_12
XFILLER_155_468 VGND VGND VPWR VPWR sky130_fd_sc_hd__decap_4
XFILLER_129_93 VGND VGND VPWR VPWR sky130_fd_sc_hd__fill_1
X_10465_ _04211_ _04212_ _04204_ VGND VGND VPWR VPWR _04213_ sky130_fd_sc_hd__a21o_1
XFILLER_6_467 VGND VGND VPWR VPWR sky130_fd_sc_hd__decap_8
X_13253_ clknet_leaf_75_clk _00263_ VGND VGND VPWR VPWR u_interface.fifo_data\[11\]\[31\]
+ sky130_fd_sc_hd__dfxtp_1
X_13184_ clknet_leaf_41_clk _00194_ VGND VGND VPWR VPWR u_interface.fifo_data\[9\]\[26\]
+ sky130_fd_sc_hd__dfxtp_1
XFILLER_124_822 VGND VGND VPWR VPWR sky130_fd_sc_hd__decap_4
XTAP_TAPCELL_ROW_114_2158 VGND VPWR sky130_fd_sc_hd__tapvpwrvgnd_1
X_10396_ net594 net417 net413 net587 VGND VGND VPWR VPWR _04145_ sky130_fd_sc_hd__a22oi_1
XFILLER_6_489 VPWR VGND VPWR VGND sky130_ef_sc_hd__decap_12
X_12204_ _05793_ _05862_ _05863_ _05795_ VGND VGND VPWR VPWR _05935_ sky130_fd_sc_hd__or4b_1
X_12135_ _05864_ _05865_ _05866_ VGND VGND VPWR VPWR _00835_ sky130_fd_sc_hd__a21oi_1
XFILLER_124_888 VGND VGND VPWR VPWR sky130_fd_sc_hd__decap_3
XFILLER_123_387 VGND VGND VPWR VPWR sky130_fd_sc_hd__fill_1
XFILLER_111_505 VPWR VGND VPWR VGND sky130_ef_sc_hd__decap_12
XFILLER_97_739 VGND VGND VPWR VPWR sky130_fd_sc_hd__decap_6
XFILLER_96_227 VGND VGND VPWR VPWR sky130_fd_sc_hd__fill_1
XFILLER_1_161 VGND VGND VPWR VPWR sky130_fd_sc_hd__decap_6
XFILLER_77_430 VGND VGND VPWR VPWR sky130_fd_sc_hd__decap_4
XFILLER_49_121 VGND VGND VPWR VPWR sky130_fd_sc_hd__fill_1
XFILLER_49_110 VGND VGND VPWR VPWR sky130_fd_sc_hd__fill_2
X_12066_ net795 _05798_ VGND VGND VPWR VPWR _05799_ sky130_fd_sc_hd__or2_1
X_11017_ _04757_ _04760_ VGND VGND VPWR VPWR _04761_ sky130_fd_sc_hd__xnor2_1
XFILLER_49_165 VGND VGND VPWR VPWR sky130_fd_sc_hd__decap_3
XFILLER_49_143 VPWR VGND VPWR VGND sky130_ef_sc_hd__decap_12
XFILLER_65_625 VGND VGND VPWR VPWR sky130_fd_sc_hd__decap_4
Xclkbuf_3_7__f_clk clknet_0_clk VGND VGND VPWR VPWR clknet_3_7__leaf_clk sky130_fd_sc_hd__clkbuf_16
XFILLER_92_466 VGND VGND VPWR VPWR sky130_fd_sc_hd__fill_2
X_12968_ u_interface.fifo_count\[3\] _06468_ _06486_ net790 VGND VGND VPWR VPWR _01062_
+ sky130_fd_sc_hd__o211a_1
X_12899_ net787 net955 VGND VGND VPWR VPWR _01041_ sky130_fd_sc_hd__and2_1
XFILLER_45_393 VGND VGND VPWR VPWR sky130_fd_sc_hd__decap_8
XFILLER_33_533 VGND VGND VPWR VPWR sky130_fd_sc_hd__decap_8
X_11919_ _05651_ _05652_ VGND VGND VPWR VPWR _05653_ sky130_fd_sc_hd__nor2_1
X_07110_ net1387 net565 net228 VGND VGND VPWR VPWR _00150_ sky130_fd_sc_hd__mux2_1
X_08090_ net292 _01940_ VGND VGND VPWR VPWR _00716_ sky130_fd_sc_hd__nor2_1
Xclkload20 clknet_leaf_2_clk VGND VGND VPWR VPWR clkload20/Y sky130_fd_sc_hd__bufinv_16
Xclkload31 clknet_leaf_16_clk VGND VGND VPWR VPWR clkload31/Y sky130_fd_sc_hd__clkinvlp_4
X_07041_ net1096 net576 net272 VGND VGND VPWR VPWR _00081_ sky130_fd_sc_hd__mux2_1
Xclkload42 clknet_leaf_61_clk VGND VGND VPWR VPWR clkload42/Y sky130_fd_sc_hd__inv_12
Xclkload53 clknet_leaf_62_clk VGND VGND VPWR VPWR clkload53/Y sky130_fd_sc_hd__clkinv_2
Xclkload75 clknet_leaf_38_clk VGND VGND VPWR VPWR clkload75/Y sky130_fd_sc_hd__clkinv_8
Xclkload86 clknet_leaf_52_clk VGND VGND VPWR VPWR clkload86/Y sky130_fd_sc_hd__inv_8
Xclkload64 clknet_leaf_75_clk VGND VGND VPWR VPWR clkload64/Y sky130_fd_sc_hd__clkinv_4
XFILLER_115_866 VGND VGND VPWR VPWR sky130_fd_sc_hd__decap_4
XFILLER_114_354 VGND VGND VPWR VPWR sky130_fd_sc_hd__decap_8
XTAP_TAPCELL_ROW_54_1205 VGND VPWR sky130_fd_sc_hd__tapvpwrvgnd_1
XTAP_TAPCELL_ROW_149_2722 VGND VPWR sky130_fd_sc_hd__tapvpwrvgnd_1
X_08992_ _02737_ _02750_ VGND VGND VPWR VPWR _02751_ sky130_fd_sc_hd__xnor2_1
XFILLER_114_365 VPWR VGND VPWR VGND sky130_ef_sc_hd__decap_12
XFILLER_141_184 VGND VGND VPWR VPWR sky130_fd_sc_hd__fill_1
X_07943_ u_interface.u_gelu_fp32.u_fp32_to_q16.s1_exp\[4\] _01811_ VGND VGND VPWR
+ VPWR _01833_ sky130_fd_sc_hd__xnor2_1
XFILLER_87_249 VGND VGND VPWR VPWR sky130_fd_sc_hd__decap_6
XPHY_EDGE_ROW_10_Left_166 VGND VGND VPWR VPWR sky130_fd_sc_hd__decap_3
XFILLER_84_901 VGND VGND VPWR VPWR sky130_fd_sc_hd__decap_6
XFILLER_68_463 VGND VGND VPWR VPWR sky130_fd_sc_hd__decap_4
X_07874_ net1191 net368 net265 VGND VGND VPWR VPWR _00635_ sky130_fd_sc_hd__mux2_1
X_06825_ u_interface.fifo_data\[0\]\[24\] u_interface.fifo_data\[1\]\[24\] u_interface.fifo_data\[2\]\[24\]
+ u_interface.fifo_data\[3\]\[24\] net765 net748 VGND VGND VPWR VPWR _01376_ sky130_fd_sc_hd__mux4_1
X_09613_ net500 net505 net705 net713 VGND VGND VPWR VPWR _03369_ sky130_fd_sc_hd__and4_1
XFILLER_83_422 VPWR VGND VPWR VGND sky130_ef_sc_hd__decap_12
XFILLER_55_113 VGND VGND VPWR VPWR sky130_fd_sc_hd__decap_8
XFILLER_18_27 VGND VGND VPWR VPWR sky130_fd_sc_hd__fill_1
XFILLER_29_839 VGND VGND VPWR VPWR sky130_fd_sc_hd__fill_1
XFILLER_83_466 VPWR VGND VPWR VGND sky130_ef_sc_hd__decap_12
X_09544_ _03298_ _03299_ _03159_ _03161_ VGND VGND VPWR VPWR _03301_ sky130_fd_sc_hd__o211a_1
X_06756_ _01310_ _01312_ _01315_ net317 VGND VGND VPWR VPWR net115 sky130_fd_sc_hd__a22o_1
XFILLER_37_883 VGND VGND VPWR VPWR sky130_fd_sc_hd__decap_4
XFILLER_43_319 VGND VGND VPWR VPWR sky130_fd_sc_hd__fill_1
X_06687_ net734 _01254_ VGND VGND VPWR VPWR _01255_ sky130_fd_sc_hd__or2_1
X_09475_ net500 net505 net696 net706 VGND VGND VPWR VPWR _03232_ sky130_fd_sc_hd__and4_1
XFILLER_34_15 VPWR VGND VPWR VGND sky130_ef_sc_hd__decap_12
X_08426_ _02210_ _02215_ _02209_ VGND VGND VPWR VPWR _02217_ sky130_fd_sc_hd__a21bo_1
XTAP_TAPCELL_ROW_65_1378 VGND VPWR sky130_fd_sc_hd__tapvpwrvgnd_1
XFILLER_24_566 VGND VGND VPWR VPWR sky130_fd_sc_hd__fill_1
Xclkload3 clknet_3_3__leaf_clk VGND VGND VPWR VPWR clkload3/Y sky130_fd_sc_hd__inv_12
X_08357_ net528 net1641 _02149_ net798 VGND VGND VPWR VPWR _02151_ sky130_fd_sc_hd__a31o_1
XFILLER_137_446 VGND VGND VPWR VPWR sky130_fd_sc_hd__fill_2
X_08288_ net532 _02098_ net1648 VGND VGND VPWR VPWR _02099_ sky130_fd_sc_hd__a21oi_1
X_07308_ net1344 net374 net254 VGND VGND VPWR VPWR _00338_ sky130_fd_sc_hd__mux2_1
XFILLER_109_148 VGND VGND VPWR VPWR sky130_fd_sc_hd__decap_3
X_07239_ net1301 net378 net249 VGND VGND VPWR VPWR _00271_ sky130_fd_sc_hd__mux2_1
XFILLER_4_905 VPWR VGND VPWR VGND sky130_ef_sc_hd__decap_12
XFILLER_152_438 VPWR VGND VPWR VGND sky130_ef_sc_hd__decap_12
XFILLER_152_416 VGND VGND VPWR VPWR sky130_fd_sc_hd__decap_4
XFILLER_106_811 VGND VGND VPWR VPWR sky130_fd_sc_hd__fill_1
X_10250_ net482 net722 VGND VGND VPWR VPWR _04000_ sky130_fd_sc_hd__nand2_2
XFILLER_79_706 VGND VGND VPWR VPWR sky130_fd_sc_hd__decap_8
X_10181_ net594 net603 net432 net428 VGND VGND VPWR VPWR _03932_ sky130_fd_sc_hd__and4_1
Xfanout240 _01517_ VGND VGND VPWR VPWR net240 sky130_fd_sc_hd__clkbuf_8
XFILLER_94_709 VGND VGND VPWR VPWR sky130_fd_sc_hd__decap_4
XFILLER_59_430 VGND VGND VPWR VPWR sky130_fd_sc_hd__fill_1
Xfanout251 net252 VGND VGND VPWR VPWR net251 sky130_fd_sc_hd__buf_4
XFILLER_115_40 VGND VGND VPWR VPWR sky130_fd_sc_hd__fill_2
X_13940_ clknet_leaf_3_clk _00007_ VGND VGND VPWR VPWR u_interface.u_gelu_fp32.u_synth_top.s1_hits\[12\]
+ sky130_fd_sc_hd__dfxtp_1
Xfanout262 _01507_ VGND VGND VPWR VPWR net262 sky130_fd_sc_hd__buf_2
XFILLER_87_783 VGND VGND VPWR VPWR sky130_fd_sc_hd__fill_1
Xfanout273 net276 VGND VGND VPWR VPWR net273 sky130_fd_sc_hd__buf_2
XFILLER_19_305 VGND VGND VPWR VPWR sky130_fd_sc_hd__fill_2
Xfanout284 net285 VGND VGND VPWR VPWR net284 sky130_fd_sc_hd__buf_4
Xfanout295 net296 VGND VGND VPWR VPWR net295 sky130_fd_sc_hd__clkbuf_2
XFILLER_75_33 VGND VGND VPWR VPWR sky130_fd_sc_hd__decap_6
XFILLER_59_496 VGND VGND VPWR VPWR sky130_fd_sc_hd__decap_8
XFILLER_59_485 VGND VGND VPWR VPWR sky130_fd_sc_hd__fill_2
X_13871_ clknet_leaf_22_clk net872 VGND VGND VPWR VPWR u_interface.u_gelu_fp32.u_synth_top.s2_dx\[7\]
+ sky130_fd_sc_hd__dfxtp_1
XFILLER_19_349 VGND VGND VPWR VPWR sky130_fd_sc_hd__decap_4
XFILLER_28_861 VGND VGND VPWR VPWR sky130_fd_sc_hd__decap_6
XFILLER_35_809 VPWR VGND VPWR VGND sky130_ef_sc_hd__decap_12
X_12822_ net776 net81 VGND VGND VPWR VPWR _00980_ sky130_fd_sc_hd__and2_1
XFILLER_131_50 VGND VGND VPWR VPWR sky130_fd_sc_hd__fill_1
X_12753_ net985 net1571 net825 VGND VGND VPWR VPWR _00935_ sky130_fd_sc_hd__mux2_1
XFILLER_27_393 VGND VGND VPWR VPWR sky130_fd_sc_hd__decap_8
X_11704_ net666 net402 net398 net658 VGND VGND VPWR VPWR _05441_ sky130_fd_sc_hd__a22oi_1
X_12684_ _01727_ net280 _06342_ net281 _06345_ VGND VGND VPWR VPWR _00915_ sky130_fd_sc_hd__a221o_1
XFILLER_128_402 VGND VGND VPWR VPWR sky130_fd_sc_hd__fill_2
X_11635_ _05270_ _05279_ _05278_ VGND VGND VPWR VPWR _05373_ sky130_fd_sc_hd__a21oi_1
X_11566_ net195 _05210_ _05209_ VGND VGND VPWR VPWR _05305_ sky130_fd_sc_hd__a21oi_1
XFILLER_11_783 VGND VGND VPWR VPWR sky130_fd_sc_hd__fill_1
XFILLER_10_260 VGND VGND VPWR VPWR sky130_fd_sc_hd__decap_8
XFILLER_7_721 VGND VGND VPWR VPWR sky130_fd_sc_hd__decap_6
XFILLER_155_265 VGND VGND VPWR VPWR sky130_fd_sc_hd__decap_4
X_13305_ clknet_leaf_44_clk _00315_ VGND VGND VPWR VPWR u_interface.fifo_data\[8\]\[14\]
+ sky130_fd_sc_hd__dfxtp_1
X_10517_ net618 net626 net433 net427 VGND VGND VPWR VPWR _04265_ sky130_fd_sc_hd__nand4_1
XFILLER_10_293 VGND VGND VPWR VPWR sky130_fd_sc_hd__decap_8
XFILLER_7_765 VPWR VGND VPWR VGND sky130_ef_sc_hd__decap_12
XFILLER_6_253 VPWR VGND VPWR VGND sky130_ef_sc_hd__decap_12
X_13236_ clknet_leaf_43_clk _00246_ VGND VGND VPWR VPWR u_interface.fifo_data\[11\]\[14\]
+ sky130_fd_sc_hd__dfxtp_1
X_11497_ _05152_ _05153_ _05155_ _05156_ _05148_ VGND VGND VPWR VPWR _05236_ sky130_fd_sc_hd__a32o_1
X_10448_ _03969_ _03970_ _04196_ VGND VGND VPWR VPWR _04197_ sky130_fd_sc_hd__a21o_1
XFILLER_97_503 VGND VGND VPWR VPWR sky130_fd_sc_hd__fill_1
X_10379_ net461 net682 _04125_ _04126_ VGND VGND VPWR VPWR _04128_ sky130_fd_sc_hd__nand4_1
X_13167_ clknet_leaf_62_clk _00177_ VGND VGND VPWR VPWR u_interface.fifo_data\[9\]\[9\]
+ sky130_fd_sc_hd__dfxtp_1
XFILLER_151_493 VGND VGND VPWR VPWR sky130_fd_sc_hd__decap_8
X_13098_ clknet_leaf_42_clk _00108_ VGND VGND VPWR VPWR u_interface.fifo_data\[15\]\[19\]
+ sky130_fd_sc_hd__dfxtp_1
XFILLER_112_847 VGND VGND VPWR VPWR sky130_fd_sc_hd__fill_1
XFILLER_97_547 VPWR VGND VPWR VGND sky130_ef_sc_hd__decap_12
X_12118_ _05734_ _05776_ _05775_ VGND VGND VPWR VPWR _05850_ sky130_fd_sc_hd__a21oi_1
X_12049_ _05654_ _05709_ _05708_ VGND VGND VPWR VPWR _05782_ sky130_fd_sc_hd__o21ai_1
XTAP_TAPCELL_ROW_144_2641 VGND VPWR sky130_fd_sc_hd__tapvpwrvgnd_1
XFILLER_77_260 VPWR VGND VPWR VGND sky130_ef_sc_hd__decap_12
XFILLER_65_411 VGND VGND VPWR VPWR sky130_fd_sc_hd__decap_4
XFILLER_37_113 VGND VGND VPWR VPWR sky130_fd_sc_hd__decap_4
XFILLER_38_625 VPWR VGND VPWR VGND sky130_ef_sc_hd__decap_12
XFILLER_65_444 VGND VGND VPWR VPWR sky130_fd_sc_hd__decap_4
X_07590_ net810 net1645 net302 _01691_ VGND VGND VPWR VPWR _00464_ sky130_fd_sc_hd__a22o_1
X_06610_ u_interface.u_gelu_fp32.u_synth_top.s1_hits\[5\] u_interface.u_gelu_fp32.u_synth_top.s1_hits\[4\]
+ u_interface.u_gelu_fp32.u_synth_top.s1_hits\[1\] VGND VGND VPWR VPWR _01188_ sky130_fd_sc_hd__or3_1
X_06541_ _01137_ _01106_ u_interface.u_gelu_fp32.s1_data\[17\] VGND VGND VPWR VPWR
+ _01138_ sky130_fd_sc_hd__and3b_1
XFILLER_52_149 VGND VGND VPWR VPWR sky130_fd_sc_hd__fill_1
XFILLER_33_330 VGND VGND VPWR VPWR sky130_fd_sc_hd__decap_6
X_09260_ _02971_ _03013_ _03018_ VGND VGND VPWR VPWR _03019_ sky130_fd_sc_hd__nand3_1
XFILLER_21_503 VGND VGND VPWR VPWR sky130_fd_sc_hd__fill_1
X_08211_ _02041_ net167 VGND VGND VPWR VPWR _02042_ sky130_fd_sc_hd__nand2b_1
XTAP_TAPCELL_ROW_47_1086 VGND VPWR sky130_fd_sc_hd__tapvpwrvgnd_1
XTAP_TAPCELL_ROW_16_594 VGND VPWR sky130_fd_sc_hd__tapvpwrvgnd_1
X_09191_ _02905_ _02906_ _02872_ VGND VGND VPWR VPWR _02950_ sky130_fd_sc_hd__o21ai_1
XFILLER_147_744 VGND VGND VPWR VPWR sky130_fd_sc_hd__decap_3
X_08142_ _01982_ _01983_ VGND VGND VPWR VPWR _01984_ sky130_fd_sc_hd__xnor2_1
XFILLER_146_243 VGND VGND VPWR VPWR sky130_fd_sc_hd__decap_4
XFILLER_134_405 VGND VGND VPWR VPWR sky130_fd_sc_hd__fill_2
X_08073_ _01875_ _01925_ VGND VGND VPWR VPWR _01926_ sky130_fd_sc_hd__or2_1
XTAP_TAPCELL_ROW_60_1297 VGND VPWR sky130_fd_sc_hd__tapvpwrvgnd_1
XFILLER_146_298 VGND VGND VPWR VPWR sky130_fd_sc_hd__decap_8
XFILLER_134_438 VGND VGND VPWR VPWR sky130_fd_sc_hd__decap_4
X_07024_ net1221 net371 net271 VGND VGND VPWR VPWR _00064_ sky130_fd_sc_hd__mux2_1
XFILLER_142_471 VGND VGND VPWR VPWR sky130_fd_sc_hd__fill_1
XFILLER_142_482 VPWR VGND VPWR VGND sky130_ef_sc_hd__decap_12
X_08975_ _02559_ _02575_ _02574_ VGND VGND VPWR VPWR _02734_ sky130_fd_sc_hd__a21o_1
XFILLER_29_15 VPWR VGND VPWR VGND sky130_ef_sc_hd__decap_12
X_07926_ u_interface.u_gelu_fp32.u_fp32_to_q16.s1_mant\[1\] u_interface.u_gelu_fp32.u_fp32_to_q16.s1_mant\[0\]
+ u_interface.u_gelu_fp32.u_fp32_to_q16.s1_mant\[3\] _01819_ VGND VGND VPWR VPWR _01820_
+ sky130_fd_sc_hd__or4_1
XFILLER_130_688 VGND VGND VPWR VPWR sky130_fd_sc_hd__fill_1
Xhold26 u_interface.u_gelu_fp32.s1_data\[6\] VGND VGND VPWR VPWR net891 sky130_fd_sc_hd__dlygate4sd3_1
Xhold15 u_interface.u_gelu_fp32.s1_data\[7\] VGND VGND VPWR VPWR net880 sky130_fd_sc_hd__dlygate4sd3_1
Xhold37 u_interface.u_gelu_fp32.s1_data\[21\] VGND VGND VPWR VPWR net902 sky130_fd_sc_hd__dlygate4sd3_1
Xhold59 u_interface.meta_tuser_pipe\[2\] VGND VGND VPWR VPWR net924 sky130_fd_sc_hd__dlygate4sd3_1
XFILLER_69_783 VGND VGND VPWR VPWR sky130_fd_sc_hd__fill_1
Xhold48 u_interface.u_gelu_fp32.u_q16_to_fp32.s1_sign VGND VGND VPWR VPWR net913 sky130_fd_sc_hd__dlygate4sd3_1
X_07857_ net578 net1535 net285 VGND VGND VPWR VPWR _00618_ sky130_fd_sc_hd__mux2_1
XTAP_TAPCELL_ROW_67_1407 VGND VPWR sky130_fd_sc_hd__tapvpwrvgnd_1
XFILLER_17_809 VPWR VGND VPWR VGND sky130_ef_sc_hd__decap_12
X_06808_ net323 _01358_ net727 VGND VGND VPWR VPWR _01361_ sky130_fd_sc_hd__o21a_1
X_07788_ net1068 net348 net236 VGND VGND VPWR VPWR _00549_ sky130_fd_sc_hd__mux2_1
XFILLER_56_477 VGND VGND VPWR VPWR sky130_fd_sc_hd__fill_2
X_06739_ _01299_ _01300_ net735 VGND VGND VPWR VPWR _01301_ sky130_fd_sc_hd__mux2_1
X_09527_ net477 net648 net656 net481 VGND VGND VPWR VPWR _03284_ sky130_fd_sc_hd__a22o_1
XFILLER_71_447 VGND VGND VPWR VPWR sky130_fd_sc_hd__fill_1
XFILLER_45_69 VPWR VGND VPWR VGND sky130_ef_sc_hd__decap_12
XFILLER_25_853 VPWR VGND VPWR VGND sky130_ef_sc_hd__decap_12
XTAP_TAPCELL_ROW_80_1618 VGND VPWR sky130_fd_sc_hd__tapvpwrvgnd_1
XFILLER_12_503 VPWR VGND VPWR VGND sky130_ef_sc_hd__decap_12
XFILLER_24_352 VPWR VGND VPWR VGND sky130_ef_sc_hd__decap_12
X_09458_ _03214_ _03215_ _02706_ _02708_ VGND VGND VPWR VPWR _03216_ sky130_fd_sc_hd__a211oi_2
XFILLER_25_897 VPWR VGND VPWR VGND sky130_ef_sc_hd__decap_12
XTAP_TAPCELL_ROW_35_892 VGND VPWR sky130_fd_sc_hd__tapvpwrvgnd_1
XFILLER_40_823 VGND VGND VPWR VPWR sky130_fd_sc_hd__fill_1
X_09389_ _03143_ _03144_ _03145_ VGND VGND VPWR VPWR _03147_ sky130_fd_sc_hd__a21o_1
X_08409_ u_interface.u_gelu_fp32.u_synth_top.s3_mult\[22\] u_interface.u_gelu_fp32.u_synth_top.s3_b\[6\]
+ VGND VGND VPWR VPWR _02200_ sky130_fd_sc_hd__or2_1
XFILLER_61_57 VGND VGND VPWR VPWR sky130_fd_sc_hd__decap_8
XFILLER_61_46 VGND VGND VPWR VPWR sky130_fd_sc_hd__decap_8
XFILLER_12_569 VPWR VGND VPWR VGND sky130_ef_sc_hd__decap_12
XFILLER_40_867 VGND VGND VPWR VPWR sky130_fd_sc_hd__fill_1
XFILLER_40_889 VGND VGND VPWR VPWR sky130_fd_sc_hd__decap_6
X_11420_ _05158_ _05159_ VGND VGND VPWR VPWR _05160_ sky130_fd_sc_hd__or2_1
XFILLER_153_703 VGND VGND VPWR VPWR sky130_fd_sc_hd__fill_1
XFILLER_124_3 VPWR VGND VPWR VGND sky130_ef_sc_hd__decap_12
X_11351_ _04983_ _04992_ _04991_ VGND VGND VPWR VPWR _05092_ sky130_fd_sc_hd__a21boi_1
XFILLER_152_224 VGND VGND VPWR VPWR sky130_fd_sc_hd__fill_1
XFILLER_137_298 VGND VGND VPWR VPWR sky130_fd_sc_hd__fill_1
XFILLER_125_438 VGND VGND VPWR VPWR sky130_fd_sc_hd__decap_3
XTAP_TAPCELL_ROW_95_1850 VGND VPWR sky130_fd_sc_hd__tapvpwrvgnd_1
X_10302_ _04048_ _04051_ VGND VGND VPWR VPWR _04052_ sky130_fd_sc_hd__xnor2_1
XFILLER_4_713 VPWR VGND VPWR VGND sky130_ef_sc_hd__decap_12
X_14070_ clknet_leaf_21_clk _00996_ VGND VGND VPWR VPWR net146 sky130_fd_sc_hd__dfxtp_1
XFILLER_153_758 VPWR VGND VPWR VGND sky130_ef_sc_hd__decap_12
XTAP_TAPCELL_ROW_111_2117 VGND VPWR sky130_fd_sc_hd__tapvpwrvgnd_1
XTAP_TAPCELL_ROW_111_2106 VGND VPWR sky130_fd_sc_hd__tapvpwrvgnd_1
XFILLER_106_641 VGND VGND VPWR VPWR sky130_fd_sc_hd__decap_3
XFILLER_106_630 VGND VGND VPWR VPWR sky130_fd_sc_hd__fill_2
XTAP_TAPCELL_ROW_95_1861 VGND VPWR sky130_fd_sc_hd__tapvpwrvgnd_1
X_11282_ _04919_ net180 _04924_ VGND VGND VPWR VPWR _05023_ sky130_fd_sc_hd__a21o_1
XFILLER_4_757 VPWR VGND VPWR VGND sky130_ef_sc_hd__decap_12
XFILLER_3_223 VGND VGND VPWR VPWR sky130_fd_sc_hd__fill_1
XFILLER_140_419 VGND VGND VPWR VPWR sky130_fd_sc_hd__fill_1
XFILLER_140_408 VGND VGND VPWR VPWR sky130_fd_sc_hd__fill_1
X_10233_ _03981_ _03982_ _03979_ VGND VGND VPWR VPWR _03983_ sky130_fd_sc_hd__a21o_1
X_13021_ net170 net165 _06275_ _06278_ net151 VGND VGND VPWR VPWR _00848_ sky130_fd_sc_hd__o2111a_1
X_10164_ _03912_ _03913_ _03914_ VGND VGND VPWR VPWR _03915_ sky130_fd_sc_hd__a21oi_1
XFILLER_10_83 VGND VGND VPWR VPWR sky130_fd_sc_hd__fill_1
XFILLER_86_65 VPWR VGND VPWR VGND sky130_ef_sc_hd__decap_12
X_10095_ _03783_ _03784_ _03843_ _03844_ VGND VGND VPWR VPWR _03847_ sky130_fd_sc_hd__nand4_1
XFILLER_47_400 VPWR VGND VPWR VGND sky130_ef_sc_hd__decap_12
XFILLER_19_113 VPWR VGND VPWR VGND sky130_ef_sc_hd__decap_12
XFILLER_142_60 VGND VGND VPWR VPWR sky130_fd_sc_hd__decap_4
XTAP_TAPCELL_ROW_109_2079 VGND VPWR sky130_fd_sc_hd__tapvpwrvgnd_1
X_13923_ clknet_leaf_6_clk net905 VGND VGND VPWR VPWR u_interface.u_gelu_fp32.u_synth_top.s1_x\[27\]
+ sky130_fd_sc_hd__dfxtp_1
XFILLER_75_764 VGND VGND VPWR VPWR sky130_fd_sc_hd__fill_1
XFILLER_19_81 VPWR VGND VPWR VGND sky130_ef_sc_hd__decap_12
XFILLER_142_93 VGND VGND VPWR VPWR sky130_fd_sc_hd__decap_3
X_13854_ clknet_leaf_58_clk _00864_ VGND VGND VPWR VPWR u_interface.u_gelu_fp32.u_synth_top.s3_b\[10\]
+ sky130_fd_sc_hd__dfxtp_1
XFILLER_35_617 VPWR VGND VPWR VGND sky130_ef_sc_hd__decap_12
X_12805_ net787 net911 VGND VGND VPWR VPWR _00963_ sky130_fd_sc_hd__and2_1
XFILLER_34_149 VPWR VGND VPWR VGND sky130_ef_sc_hd__decap_12
X_10997_ _04619_ _04621_ _04620_ VGND VGND VPWR VPWR _04741_ sky130_fd_sc_hd__o21ba_1
X_13785_ clknet_leaf_85_clk _00795_ VGND VGND VPWR VPWR u_interface.u_gelu_fp32.s2_data\[19\]
+ sky130_fd_sc_hd__dfxtp_1
XFILLER_96_7 VGND VGND VPWR VPWR sky130_fd_sc_hd__fill_1
X_12736_ _06385_ _06378_ _06370_ _06364_ net332 net328 VGND VGND VPWR VPWR _06386_
+ sky130_fd_sc_hd__mux4_1
XFILLER_15_396 VGND VGND VPWR VPWR sky130_fd_sc_hd__fill_1
XFILLER_30_300 VGND VGND VPWR VPWR sky130_fd_sc_hd__fill_2
X_12667_ net1692 u_interface.u_gelu_fp32.u_q16_to_fp32.s2_mag\[22\] net802 VGND VGND
+ VPWR VPWR _00903_ sky130_fd_sc_hd__mux2_1
XTAP_TAPCELL_ROW_13_542 VGND VPWR sky130_fd_sc_hd__tapvpwrvgnd_1
XFILLER_30_333 VPWR VGND VPWR VGND sky130_ef_sc_hd__decap_12
XFILLER_42_193 VGND VGND VPWR VPWR sky130_fd_sc_hd__decap_3
XFILLER_129_733 VGND VGND VPWR VPWR sky130_fd_sc_hd__fill_1
XFILLER_30_377 VGND VGND VPWR VPWR sky130_fd_sc_hd__decap_8
XFILLER_31_889 VGND VGND VPWR VPWR sky130_fd_sc_hd__decap_6
X_11618_ _05353_ _05355_ VGND VGND VPWR VPWR _05356_ sky130_fd_sc_hd__nor2_1
X_12598_ net211 _06299_ _06300_ _06293_ VGND VGND VPWR VPWR _06301_ sky130_fd_sc_hd__a211o_1
Xhold518 u_interface.u_gelu_fp32.u_fp32_to_q16.s1_mant\[10\] VGND VGND VPWR VPWR net1383
+ sky130_fd_sc_hd__dlygate4sd3_1
Xhold507 u_interface.fifo_data\[4\]\[10\] VGND VGND VPWR VPWR net1372 sky130_fd_sc_hd__dlygate4sd3_1
XFILLER_116_405 VGND VGND VPWR VPWR sky130_fd_sc_hd__decap_8
XFILLER_7_573 VPWR VGND VPWR VGND sky130_ef_sc_hd__decap_12
X_11549_ _05161_ _05194_ _05193_ VGND VGND VPWR VPWR _05288_ sky130_fd_sc_hd__a21oi_2
XFILLER_116_449 VGND VGND VPWR VPWR sky130_fd_sc_hd__fill_1
Xhold529 u_interface.fifo_data\[12\]\[25\] VGND VGND VPWR VPWR net1394 sky130_fd_sc_hd__dlygate4sd3_1
XFILLER_143_268 VPWR VGND VPWR VGND sky130_ef_sc_hd__decap_12
XFILLER_140_920 VGND VGND VPWR VPWR sky130_fd_sc_hd__fill_1
X_13219_ clknet_leaf_45_clk _00229_ VGND VGND VPWR VPWR u_interface.fifo_data\[12\]\[29\]
+ sky130_fd_sc_hd__dfxtp_1
XFILLER_112_633 VGND VGND VPWR VPWR sky130_fd_sc_hd__decap_3
XFILLER_111_121 VGND VGND VPWR VPWR sky130_fd_sc_hd__fill_2
XFILLER_111_110 VGND VGND VPWR VPWR sky130_fd_sc_hd__fill_2
XFILLER_97_333 VGND VGND VPWR VPWR sky130_fd_sc_hd__decap_3
XFILLER_112_677 VGND VGND VPWR VPWR sky130_fd_sc_hd__decap_8
XFILLER_100_806 VGND VGND VPWR VPWR sky130_fd_sc_hd__decap_6
XFILLER_98_889 VGND VGND VPWR VPWR sky130_fd_sc_hd__decap_4
X_08760_ _02509_ _02516_ _02517_ _02501_ VGND VGND VPWR VPWR _02519_ sky130_fd_sc_hd__a211o_1
XFILLER_111_165 VGND VGND VPWR VPWR sky130_fd_sc_hd__decap_3
XFILLER_57_219 VGND VGND VPWR VPWR sky130_fd_sc_hd__decap_4
X_08691_ _02448_ _02449_ net679 net511 VGND VGND VPWR VPWR _02450_ sky130_fd_sc_hd__and4bb_1
X_07711_ net1753 _01186_ _01435_ _01762_ VGND VGND VPWR VPWR _00509_ sky130_fd_sc_hd__or4_1
XFILLER_93_572 VGND VGND VPWR VPWR sky130_fd_sc_hd__decap_3
X_07642_ u_interface.u_gelu_fp32.u_q16_to_fp32.s2_mag\[9\] u_interface.u_gelu_fp32.u_q16_to_fp32.s2_mag\[8\]
+ u_interface.u_gelu_fp32.u_q16_to_fp32.s2_mag\[7\] u_interface.u_gelu_fp32.u_q16_to_fp32.s2_mag\[6\]
+ net338 net333 VGND VGND VPWR VPWR _01729_ sky130_fd_sc_hd__mux4_1
XTAP_TAPCELL_ROW_49_1126 VGND VPWR sky130_fd_sc_hd__tapvpwrvgnd_1
XTAP_TAPCELL_ROW_49_1115 VGND VPWR sky130_fd_sc_hd__tapvpwrvgnd_1
XFILLER_25_105 VGND VGND VPWR VPWR sky130_fd_sc_hd__decap_6
XFILLER_81_745 VGND VGND VPWR VPWR sky130_fd_sc_hd__decap_3
XFILLER_53_425 VPWR VGND VPWR VGND sky130_ef_sc_hd__decap_12
X_09312_ _03058_ _03059_ VGND VGND VPWR VPWR _03071_ sky130_fd_sc_hd__and2_1
X_07573_ net811 net1669 net304 _01683_ VGND VGND VPWR VPWR _00455_ sky130_fd_sc_hd__a22o_1
XFILLER_15_39 VPWR VGND VPWR VGND sky130_ef_sc_hd__decap_12
X_06524_ _01121_ _01123_ VGND VGND VPWR VPWR _01124_ sky130_fd_sc_hd__nand2_1
XTAP_TAPCELL_ROW_62_1326 VGND VPWR sky130_fd_sc_hd__tapvpwrvgnd_1
XFILLER_33_160 VGND VGND VPWR VPWR sky130_fd_sc_hd__decap_3
X_09243_ _02863_ _02865_ _02864_ VGND VGND VPWR VPWR _03002_ sky130_fd_sc_hd__a21oi_1
XFILLER_22_867 VGND VGND VPWR VPWR sky130_fd_sc_hd__fill_1
XTAP_TAPCELL_ROW_32_840 VGND VPWR sky130_fd_sc_hd__tapvpwrvgnd_1
XTAP_TAPCELL_ROW_32_851 VGND VPWR sky130_fd_sc_hd__tapvpwrvgnd_1
X_09174_ _02889_ _02927_ _02932_ VGND VGND VPWR VPWR _02933_ sky130_fd_sc_hd__nand3_1
XFILLER_119_221 VGND VGND VPWR VPWR sky130_fd_sc_hd__decap_3
X_08125_ net168 _01968_ _01969_ net163 VGND VGND VPWR VPWR _01970_ sky130_fd_sc_hd__a31oi_1
XFILLER_31_27 VPWR VGND VPWR VGND sky130_ef_sc_hd__decap_12
XFILLER_147_27 VPWR VGND VPWR VGND sky130_ef_sc_hd__decap_12
XFILLER_107_405 VGND VGND VPWR VPWR sky130_fd_sc_hd__decap_4
X_08056_ u_interface.u_gelu_fp32.u_fp32_to_q16.s3_mag\[0\] u_interface.u_gelu_fp32.u_fp32_to_q16.round_bit
+ u_interface.u_gelu_fp32.u_fp32_to_q16.s3_mag\[1\] VGND VGND VPWR VPWR _01912_ sky130_fd_sc_hd__a21oi_1
X_07007_ _01501_ _01512_ VGND VGND VPWR VPWR _01521_ sky130_fd_sc_hd__nor2_2
XFILLER_122_419 VGND VGND VPWR VPWR sky130_fd_sc_hd__fill_1
XFILLER_1_727 VGND VGND VPWR VPWR sky130_fd_sc_hd__fill_1
XFILLER_131_920 VGND VGND VPWR VPWR sky130_fd_sc_hd__fill_1
XFILLER_103_633 VGND VGND VPWR VPWR sky130_fd_sc_hd__fill_1
XFILLER_0_237 VPWR VGND VPWR VGND sky130_ef_sc_hd__decap_12
Xinput105 s_axis_tdata[9] VGND VGND VPWR VPWR net105 sky130_fd_sc_hd__clkbuf_1
XFILLER_102_121 VGND VGND VPWR VPWR sky130_fd_sc_hd__fill_1
XTAP_TAPCELL_ROW_90_1780 VGND VPWR sky130_fd_sc_hd__tapvpwrvgnd_1
XTAP_TAPCELL_ROW_73_1499 VGND VPWR sky130_fd_sc_hd__tapvpwrvgnd_1
X_08958_ net582 net590 u_interface.u_gelu_fp32.u_synth_top.s2_dx\[10\] net480 VGND
+ VGND VPWR VPWR _02717_ sky130_fd_sc_hd__and4_1
XFILLER_57_720 VGND VGND VPWR VPWR sky130_fd_sc_hd__decap_8
X_07909_ net774 net93 VGND VGND VPWR VPWR _00668_ sky130_fd_sc_hd__and2_1
X_08889_ _02645_ _02646_ _02647_ VGND VGND VPWR VPWR _02648_ sky130_fd_sc_hd__a21oi_1
XFILLER_57_753 VGND VGND VPWR VPWR sky130_fd_sc_hd__fill_1
XFILLER_29_433 VGND VGND VPWR VPWR sky130_fd_sc_hd__decap_8
XFILLER_84_561 VGND VGND VPWR VPWR sky130_fd_sc_hd__fill_1
X_10920_ _04443_ _04547_ _04548_ _04550_ _03752_ VGND VGND VPWR VPWR _04665_ sky130_fd_sc_hd__a32oi_4
XFILLER_71_200 VPWR VGND VPWR VGND sky130_ef_sc_hd__decap_12
XFILLER_56_274 VPWR VGND VPWR VGND sky130_ef_sc_hd__decap_12
XFILLER_17_617 VPWR VGND VPWR VGND sky130_ef_sc_hd__decap_12
XFILLER_112_74 VGND VGND VPWR VPWR sky130_fd_sc_hd__decap_8
X_10851_ _04482_ _04485_ _04593_ _04594_ VGND VGND VPWR VPWR _04596_ sky130_fd_sc_hd__a211oi_1
X_13570_ clknet_leaf_26_clk _00580_ VGND VGND VPWR VPWR u_interface.fifo_data\[4\]\[17\]
+ sky130_fd_sc_hd__dfxtp_1
XFILLER_72_56 VGND VGND VPWR VPWR sky130_fd_sc_hd__fill_1
X_10782_ _04517_ _04526_ _04527_ VGND VGND VPWR VPWR _04528_ sky130_fd_sc_hd__and3_1
XFILLER_24_160 VGND VGND VPWR VPWR sky130_fd_sc_hd__fill_1
XFILLER_24_171 VPWR VGND VPWR VGND sky130_ef_sc_hd__decap_12
XFILLER_72_89 VGND VGND VPWR VPWR sky130_fd_sc_hd__fill_1
X_12521_ net191 _06212_ _06211_ VGND VGND VPWR VPWR _06246_ sky130_fd_sc_hd__a21oi_1
XTAP_TAPCELL_ROW_10_501 VGND VPWR sky130_fd_sc_hd__tapvpwrvgnd_1
XFILLER_8_326 VGND VGND VPWR VPWR sky130_fd_sc_hd__decap_4
XFILLER_12_377 VGND VGND VPWR VPWR sky130_fd_sc_hd__decap_8
XFILLER_13_889 VGND VGND VPWR VPWR sky130_fd_sc_hd__decap_6
X_12452_ _06172_ _06178_ net772 VGND VGND VPWR VPWR _06179_ sky130_fd_sc_hd__o21ai_1
XFILLER_138_530 VGND VGND VPWR VPWR sky130_fd_sc_hd__fill_2
X_11403_ _05128_ _05141_ VGND VGND VPWR VPWR _05143_ sky130_fd_sc_hd__xnor2_1
XFILLER_138_585 VGND VGND VPWR VPWR sky130_fd_sc_hd__decap_3
X_12383_ _06110_ _06109_ VGND VGND VPWR VPWR _06111_ sky130_fd_sc_hd__nand2b_1
X_14122_ clknet_leaf_36_clk net1640 VGND VGND VPWR VPWR u_interface.fifo_rd_ptr\[3\]
+ sky130_fd_sc_hd__dfxtp_1
XFILLER_125_246 VPWR VGND VPWR VGND sky130_ef_sc_hd__decap_12
X_11334_ _05064_ _05072_ VGND VGND VPWR VPWR _05075_ sky130_fd_sc_hd__nand2_1
X_14053_ clknet_leaf_16_clk _00979_ VGND VGND VPWR VPWR u_interface.u_gelu_fp32.u_fp32_to_q16.s1_mant\[15\]
+ sky130_fd_sc_hd__dfxtp_1
XFILLER_153_588 VPWR VGND VPWR VGND sky130_ef_sc_hd__decap_12
XFILLER_125_279 VGND VGND VPWR VPWR sky130_fd_sc_hd__fill_1
X_11265_ _05004_ _05005_ VGND VGND VPWR VPWR _05007_ sky130_fd_sc_hd__nand2_1
XFILLER_21_93 VPWR VGND VPWR VGND sky130_ef_sc_hd__decap_12
XFILLER_137_93 VGND VGND VPWR VPWR sky130_fd_sc_hd__fill_1
X_10216_ _03741_ _03859_ VGND VGND VPWR VPWR _03967_ sky130_fd_sc_hd__nand2_1
X_13004_ net1040 net343 net221 VGND VGND VPWR VPWR _01087_ sky130_fd_sc_hd__mux2_1
XFILLER_4_587 VGND VGND VPWR VPWR sky130_fd_sc_hd__fill_1
XFILLER_133_290 VPWR VGND VPWR VGND sky130_ef_sc_hd__decap_12
X_11196_ _04927_ _04937_ VGND VGND VPWR VPWR _04938_ sky130_fd_sc_hd__xor2_1
XFILLER_121_496 VGND VGND VPWR VPWR sky130_fd_sc_hd__decap_8
X_10147_ _03811_ _03813_ _03812_ VGND VGND VPWR VPWR _03898_ sky130_fd_sc_hd__a21bo_1
XFILLER_67_539 VPWR VGND VPWR VGND sky130_ef_sc_hd__decap_12
XTAP_TAPCELL_ROW_124_2319 VGND VPWR sky130_fd_sc_hd__tapvpwrvgnd_1
X_10078_ _03828_ _03829_ _03822_ VGND VGND VPWR VPWR _03830_ sky130_fd_sc_hd__a21o_1
X_13906_ clknet_leaf_2_clk net888 VGND VGND VPWR VPWR u_interface.u_gelu_fp32.u_synth_top.s1_x\[10\]
+ sky130_fd_sc_hd__dfxtp_1
XFILLER_75_561 VGND VGND VPWR VPWR sky130_fd_sc_hd__fill_2
XFILLER_63_723 VGND VGND VPWR VPWR sky130_fd_sc_hd__decap_4
XFILLER_62_233 VGND VGND VPWR VPWR sky130_fd_sc_hd__fill_2
XFILLER_62_222 VGND VGND VPWR VPWR sky130_fd_sc_hd__fill_2
XFILLER_62_211 VGND VGND VPWR VPWR sky130_fd_sc_hd__fill_1
XTAP_TAPCELL_ROW_18_623 VGND VPWR sky130_fd_sc_hd__tapvpwrvgnd_1
XFILLER_35_425 VPWR VGND VPWR VGND sky130_ef_sc_hd__decap_12
XFILLER_63_778 VGND VGND VPWR VPWR sky130_fd_sc_hd__decap_6
XFILLER_51_918 VGND VGND VPWR VPWR sky130_fd_sc_hd__decap_3
X_13837_ clknet_leaf_78_clk _00847_ VGND VGND VPWR VPWR u_interface.u_gelu_fp32.u_synth_top.s3_mult\[55\]
+ sky130_fd_sc_hd__dfxtp_1
X_13768_ clknet_leaf_54_clk _00778_ VGND VGND VPWR VPWR u_interface.u_gelu_fp32.s2_data\[2\]
+ sky130_fd_sc_hd__dfxtp_1
XFILLER_62_277 VPWR VGND VPWR VGND sky130_ef_sc_hd__decap_12
XFILLER_50_428 VPWR VGND VPWR VGND sky130_ef_sc_hd__decap_12
XFILLER_148_305 VGND VGND VPWR VPWR sky130_fd_sc_hd__decap_3
Xclkbuf_0_clk clk VGND VGND VPWR VPWR clknet_0_clk sky130_fd_sc_hd__clkbuf_16
X_12719_ net807 u_interface.u_gelu_fp32.u_q16_to_fp32.s3_norm_mag\[24\] net299 _06372_
+ VGND VGND VPWR VPWR _06373_ sky130_fd_sc_hd__a22o_1
XTAP_TAPCELL_ROW_44_1045 VGND VPWR sky130_fd_sc_hd__tapvpwrvgnd_1
XTAP_TAPCELL_ROW_44_1034 VGND VPWR sky130_fd_sc_hd__tapvpwrvgnd_1
XFILLER_31_653 VPWR VGND VPWR VGND sky130_ef_sc_hd__decap_12
X_13699_ clknet_leaf_29_clk _00709_ VGND VGND VPWR VPWR u_interface.u_gelu_fp32.u_fp32_to_q16.s3_valid
+ sky130_fd_sc_hd__dfxtp_1
XTAP_TAPCELL_ROW_139_2562 VGND VPWR sky130_fd_sc_hd__tapvpwrvgnd_1
XFILLER_87_3 VPWR VGND VPWR VGND sky130_ef_sc_hd__decap_12
XFILLER_31_697 VPWR VGND VPWR VGND sky130_ef_sc_hd__decap_12
XFILLER_7_51 VGND VGND VPWR VPWR sky130_fd_sc_hd__decap_4
XTAP_TAPCELL_ROW_152_2773 VGND VPWR sky130_fd_sc_hd__tapvpwrvgnd_1
XTAP_TAPCELL_ROW_152_2762 VGND VPWR sky130_fd_sc_hd__tapvpwrvgnd_1
Xhold315 u_interface.fifo_tlast\[14\] VGND VGND VPWR VPWR net1180 sky130_fd_sc_hd__dlygate4sd3_1
XFILLER_144_533 VPWR VGND VPWR VGND sky130_ef_sc_hd__decap_12
XFILLER_117_758 VGND VGND VPWR VPWR sky130_fd_sc_hd__fill_2
Xhold304 u_interface.fifo_data\[6\]\[9\] VGND VGND VPWR VPWR net1169 sky130_fd_sc_hd__dlygate4sd3_1
XFILLER_8_893 VPWR VGND VPWR VGND sky130_ef_sc_hd__decap_12
Xhold326 u_interface.fifo_data\[13\]\[8\] VGND VGND VPWR VPWR net1191 sky130_fd_sc_hd__dlygate4sd3_1
Xhold359 u_interface.fifo_data\[15\]\[13\] VGND VGND VPWR VPWR net1224 sky130_fd_sc_hd__dlygate4sd3_1
XFILLER_116_257 VGND VGND VPWR VPWR sky130_fd_sc_hd__fill_1
XFILLER_89_119 VGND VGND VPWR VPWR sky130_fd_sc_hd__fill_1
X_09930_ _03674_ _03681_ VGND VGND VPWR VPWR _03683_ sky130_fd_sc_hd__xnor2_1
Xhold337 _00938_ VGND VGND VPWR VPWR net1202 sky130_fd_sc_hd__dlygate4sd3_1
Xhold348 u_interface.fifo_data\[2\]\[2\] VGND VGND VPWR VPWR net1213 sky130_fd_sc_hd__dlygate4sd3_1
XFILLER_113_920 VGND VGND VPWR VPWR sky130_fd_sc_hd__fill_1
Xfanout806 net809 VGND VGND VPWR VPWR net806 sky130_fd_sc_hd__clkbuf_2
XPHY_EDGE_ROW_15_Right_15 VGND VGND VPWR VPWR sky130_fd_sc_hd__decap_3
Xfanout828 net829 VGND VGND VPWR VPWR net828 sky130_fd_sc_hd__clkbuf_2
Xfanout817 net822 VGND VGND VPWR VPWR net817 sky130_fd_sc_hd__clkbuf_4
X_09861_ _03611_ _03612_ _03578_ VGND VGND VPWR VPWR _03615_ sky130_fd_sc_hd__a21o_1
XFILLER_97_152 VGND VGND VPWR VPWR sky130_fd_sc_hd__fill_1
X_08812_ _02567_ _02570_ VGND VGND VPWR VPWR _02571_ sky130_fd_sc_hd__nand2b_1
XFILLER_112_474 VGND VGND VPWR VPWR sky130_fd_sc_hd__fill_2
X_09792_ net499 net713 _03544_ _03545_ VGND VGND VPWR VPWR _03546_ sky130_fd_sc_hd__a22o_1
XFILLER_86_826 VGND VGND VPWR VPWR sky130_fd_sc_hd__fill_1
XFILLER_85_325 VGND VGND VPWR VPWR sky130_fd_sc_hd__decap_8
X_08743_ _02501_ VGND VGND VPWR VPWR _02502_ sky130_fd_sc_hd__inv_2
XFILLER_38_230 VPWR VGND VPWR VGND sky130_ef_sc_hd__decap_12
XFILLER_39_742 VGND VGND VPWR VPWR sky130_fd_sc_hd__decap_4
XFILLER_26_27 VGND VGND VPWR VPWR sky130_fd_sc_hd__fill_1
XTAP_TAPCELL_ROW_37_921 VGND VPWR sky130_fd_sc_hd__tapvpwrvgnd_1
X_08674_ net152 _02435_ net798 VGND VGND VPWR VPWR _00805_ sky130_fd_sc_hd__a21oi_1
XTAP_TAPCELL_ROW_37_932 VGND VPWR sky130_fd_sc_hd__tapvpwrvgnd_1
X_07625_ _01715_ VGND VGND VPWR VPWR _01716_ sky130_fd_sc_hd__inv_2
XFILLER_53_244 VPWR VGND VPWR VGND sky130_ef_sc_hd__decap_12
XPHY_EDGE_ROW_24_Right_24 VGND VGND VPWR VPWR sky130_fd_sc_hd__decap_3
XFILLER_26_469 VGND VGND VPWR VPWR sky130_fd_sc_hd__fill_1
XFILLER_42_918 VGND VGND VPWR VPWR sky130_fd_sc_hd__decap_3
X_07556_ net548 _01629_ VGND VGND VPWR VPWR _01671_ sky130_fd_sc_hd__nor2_1
XFILLER_41_417 VPWR VGND VPWR VGND sky130_ef_sc_hd__decap_12
XFILLER_41_439 VGND VGND VPWR VPWR sky130_fd_sc_hd__decap_8
X_06507_ net735 VGND VGND VPWR VPWR _01107_ sky130_fd_sc_hd__inv_2
XFILLER_42_15 VPWR VGND VPWR VGND sky130_ef_sc_hd__decap_12
X_09226_ _02981_ _02982_ _02984_ VGND VGND VPWR VPWR _02985_ sky130_fd_sc_hd__and3_1
X_07487_ _01617_ _01619_ net544 VGND VGND VPWR VPWR _01620_ sky130_fd_sc_hd__mux2_1
XFILLER_21_163 VGND VGND VPWR VPWR sky130_fd_sc_hd__decap_4
XFILLER_10_837 VPWR VGND VPWR VGND sky130_ef_sc_hd__decap_12
X_09157_ _02909_ _02910_ _02905_ VGND VGND VPWR VPWR _02916_ sky130_fd_sc_hd__a21o_1
XFILLER_107_202 VPWR VGND VPWR VGND sky130_ef_sc_hd__decap_12
X_09088_ _02795_ _02834_ _02846_ VGND VGND VPWR VPWR _02847_ sky130_fd_sc_hd__a21o_1
X_08108_ net291 _01955_ VGND VGND VPWR VPWR _00719_ sky130_fd_sc_hd__nor2_1
XFILLER_150_503 VPWR VGND VPWR VGND sky130_ef_sc_hd__decap_12
X_08039_ net539 _01895_ u_interface.u_gelu_fp32.u_fp32_to_q16.s3_overflow VGND VGND
+ VPWR VPWR _01896_ sky130_fd_sc_hd__o21ba_1
XFILLER_107_279 VGND VGND VPWR VPWR sky130_fd_sc_hd__fill_1
XTAP_TAPCELL_ROW_75_1539 VGND VPWR sky130_fd_sc_hd__tapvpwrvgnd_1
XTAP_TAPCELL_ROW_75_1528 VGND VPWR sky130_fd_sc_hd__tapvpwrvgnd_1
XPHY_EDGE_ROW_2_Left_158 VGND VGND VPWR VPWR sky130_fd_sc_hd__decap_3
XPHY_EDGE_ROW_33_Right_33 VGND VGND VPWR VPWR sky130_fd_sc_hd__decap_3
Xhold882 u_interface.fifo_count\[5\] VGND VGND VPWR VPWR net1747 sky130_fd_sc_hd__dlygate4sd3_1
XFILLER_122_238 VPWR VGND VPWR VGND sky130_ef_sc_hd__decap_12
Xhold871 u_interface.u_gelu_fp32.s2_data\[4\] VGND VGND VPWR VPWR net1736 sky130_fd_sc_hd__dlygate4sd3_1
Xhold860 u_interface.u_gelu_fp32.u_q16_to_fp32.s3_norm_mag\[11\] VGND VGND VPWR VPWR
+ net1725 sky130_fd_sc_hd__dlygate4sd3_1
Xhold893 u_interface.u_gelu_fp32.u_fp32_to_q16.s3_mag\[0\] VGND VGND VPWR VPWR net1758
+ sky130_fd_sc_hd__dlygate4sd3_1
XFILLER_89_642 VGND VGND VPWR VPWR sky130_fd_sc_hd__fill_1
XFILLER_88_141 VPWR VGND VPWR VGND sky130_ef_sc_hd__decap_12
X_11050_ _04677_ _04679_ _04682_ VGND VGND VPWR VPWR _04793_ sky130_fd_sc_hd__a21bo_1
X_10001_ _03666_ _03668_ VGND VGND VPWR VPWR _03753_ sky130_fd_sc_hd__nor2_1
XFILLER_77_826 VGND VGND VPWR VPWR sky130_fd_sc_hd__decap_4
XTAP_TAPCELL_ROW_106_2038 VGND VPWR sky130_fd_sc_hd__tapvpwrvgnd_1
XTAP_TAPCELL_ROW_106_2027 VGND VPWR sky130_fd_sc_hd__tapvpwrvgnd_1
XFILLER_76_369 VGND VGND VPWR VPWR sky130_fd_sc_hd__fill_1
XFILLER_29_252 VPWR VGND VPWR VGND sky130_ef_sc_hd__decap_12
XTAP_TAPCELL_ROW_4_395 VGND VPWR sky130_fd_sc_hd__tapvpwrvgnd_1
X_11952_ net666 net389 _05684_ VGND VGND VPWR VPWR _05686_ sky130_fd_sc_hd__and3_1
XPHY_EDGE_ROW_42_Right_42 VGND VGND VPWR VPWR sky130_fd_sc_hd__decap_3
X_10903_ _04644_ _04645_ _04646_ VGND VGND VPWR VPWR _04648_ sky130_fd_sc_hd__nand3_1
XFILLER_17_447 VGND VGND VPWR VPWR sky130_fd_sc_hd__fill_1
X_11883_ _05520_ _05521_ _05539_ _05538_ _05537_ VGND VGND VPWR VPWR _05618_ sky130_fd_sc_hd__o32a_1
XFILLER_72_586 VGND VGND VPWR VPWR sky130_fd_sc_hd__fill_2
X_13622_ clknet_leaf_70_clk _00632_ VGND VGND VPWR VPWR u_interface.fifo_data\[13\]\[5\]
+ sky130_fd_sc_hd__dfxtp_1
X_10834_ net678 net448 _04494_ _04493_ VGND VGND VPWR VPWR _04579_ sky130_fd_sc_hd__a31o_1
XFILLER_44_277 VGND VGND VPWR VPWR sky130_fd_sc_hd__decap_8
X_13553_ clknet_leaf_62_clk _00563_ VGND VGND VPWR VPWR u_interface.fifo_data\[4\]\[0\]
+ sky130_fd_sc_hd__dfxtp_1
XFILLER_13_653 VPWR VGND VPWR VGND sky130_ef_sc_hd__decap_12
X_10765_ net602 net408 VGND VGND VPWR VPWR _04511_ sky130_fd_sc_hd__nand2_1
X_12504_ _06136_ _06228_ VGND VGND VPWR VPWR _06229_ sky130_fd_sc_hd__and2_1
XFILLER_12_141 VPWR VGND VPWR VGND sky130_ef_sc_hd__decap_12
XFILLER_40_450 VGND VGND VPWR VPWR sky130_fd_sc_hd__decap_8
XFILLER_139_850 VGND VGND VPWR VPWR sky130_fd_sc_hd__decap_6
X_13484_ clknet_leaf_4_clk _00494_ VGND VGND VPWR VPWR u_interface.u_gelu_fp32.u_synth_top.s2_b\[9\]
+ sky130_fd_sc_hd__dfxtp_1
X_10696_ _04433_ _04441_ VGND VGND VPWR VPWR _04442_ sky130_fd_sc_hd__nor2_1
XFILLER_13_697 VPWR VGND VPWR VGND sky130_ef_sc_hd__decap_12
XPHY_EDGE_ROW_51_Right_51 VGND VGND VPWR VPWR sky130_fd_sc_hd__decap_3
X_12435_ _06160_ _06161_ VGND VGND VPWR VPWR _06162_ sky130_fd_sc_hd__nor2_1
XFILLER_154_853 VPWR VGND VPWR VGND sky130_ef_sc_hd__decap_12
X_12366_ _06092_ _06093_ VGND VGND VPWR VPWR _06094_ sky130_fd_sc_hd__xnor2_1
XFILLER_8_189 VGND VGND VPWR VPWR sky130_fd_sc_hd__fill_1
XFILLER_5_841 VPWR VGND VPWR VGND sky130_ef_sc_hd__decap_12
XPHY_EDGE_ROW_136_Right_136 VGND VGND VPWR VPWR sky130_fd_sc_hd__decap_3
X_14105_ clknet_leaf_27_clk _01031_ VGND VGND VPWR VPWR u_interface.meta_tuser_pipe\[2\]
+ sky130_fd_sc_hd__dfxtp_1
XTAP_TAPCELL_ROW_134_2481 VGND VPWR sky130_fd_sc_hd__tapvpwrvgnd_1
XFILLER_99_417 VGND VGND VPWR VPWR sky130_fd_sc_hd__decap_6
X_11317_ _05056_ _05057_ VGND VGND VPWR VPWR _05058_ sky130_fd_sc_hd__nand2_1
XFILLER_153_374 VGND VGND VPWR VPWR sky130_fd_sc_hd__decap_4
XFILLER_99_439 VGND VGND VPWR VPWR sky130_fd_sc_hd__decap_8
X_12297_ net709 net395 _05962_ _05961_ VGND VGND VPWR VPWR _06026_ sky130_fd_sc_hd__a31o_1
XFILLER_141_558 VGND VGND VPWR VPWR sky130_fd_sc_hd__fill_2
X_14036_ clknet_leaf_34_clk _00962_ VGND VGND VPWR VPWR u_interface.core_data_out\[22\]
+ sky130_fd_sc_hd__dfxtp_1
XFILLER_122_750 VGND VGND VPWR VPWR sky130_fd_sc_hd__decap_6
X_11248_ net602 net396 _04873_ _04872_ VGND VGND VPWR VPWR _04990_ sky130_fd_sc_hd__a31o_1
XFILLER_67_314 VGND VGND VPWR VPWR sky130_fd_sc_hd__decap_4
X_11179_ net189 _04920_ VGND VGND VPWR VPWR _04921_ sky130_fd_sc_hd__xnor2_2
XFILLER_83_829 VGND VGND VPWR VPWR sky130_fd_sc_hd__decap_6
XPHY_EDGE_ROW_60_Right_60 VGND VGND VPWR VPWR sky130_fd_sc_hd__decap_3
XFILLER_36_701 VGND VGND VPWR VPWR sky130_fd_sc_hd__decap_3
XFILLER_35_244 VGND VGND VPWR VPWR sky130_fd_sc_hd__fill_2
X_07410_ u_interface.u_gelu_fp32.u_fp32_to_q16.s2_norm_mag\[20\] u_interface.u_gelu_fp32.u_fp32_to_q16.s2_norm_mag\[21\]
+ net558 VGND VGND VPWR VPWR _01546_ sky130_fd_sc_hd__mux2_1
X_08390_ _02179_ _02180_ VGND VGND VPWR VPWR _02181_ sky130_fd_sc_hd__nand2_1
XFILLER_23_417 VGND VGND VPWR VPWR sky130_fd_sc_hd__decap_8
X_07341_ net373 net1430 net241 VGND VGND VPWR VPWR _00371_ sky130_fd_sc_hd__mux2_1
XTAP_TAPCELL_ROW_154_2802 VGND VPWR sky130_fd_sc_hd__tapvpwrvgnd_1
X_07272_ net1156 net382 net247 VGND VGND VPWR VPWR _00302_ sky130_fd_sc_hd__mux2_1
XFILLER_31_494 VGND VGND VPWR VPWR sky130_fd_sc_hd__decap_8
XFILLER_148_179 VGND VGND VPWR VPWR sky130_fd_sc_hd__fill_1
X_09011_ _02727_ _02768_ _02769_ VGND VGND VPWR VPWR _02770_ sky130_fd_sc_hd__and3_1
XFILLER_12_29 VPWR VGND VPWR VGND sky130_ef_sc_hd__decap_12
XFILLER_129_393 VGND VGND VPWR VPWR sky130_fd_sc_hd__decap_6
Xhold101 u_interface.fifo_data\[1\]\[17\] VGND VGND VPWR VPWR net966 sky130_fd_sc_hd__dlygate4sd3_1
Xhold134 u_interface.fifo_data\[14\]\[16\] VGND VGND VPWR VPWR net999 sky130_fd_sc_hd__dlygate4sd3_1
Xhold112 u_interface.fifo_data\[6\]\[22\] VGND VGND VPWR VPWR net977 sky130_fd_sc_hd__dlygate4sd3_1
XPHY_EDGE_ROW_103_Right_103 VGND VGND VPWR VPWR sky130_fd_sc_hd__decap_3
Xhold123 u_interface.fifo_data\[13\]\[21\] VGND VGND VPWR VPWR net988 sky130_fd_sc_hd__dlygate4sd3_1
Xhold167 u_interface.fifo_data\[0\]\[10\] VGND VGND VPWR VPWR net1032 sky130_fd_sc_hd__dlygate4sd3_1
Xhold145 u_interface.fifo_data\[13\]\[1\] VGND VGND VPWR VPWR net1010 sky130_fd_sc_hd__dlygate4sd3_1
Xhold156 u_interface.fifo_data\[13\]\[24\] VGND VGND VPWR VPWR net1021 sky130_fd_sc_hd__dlygate4sd3_1
XTAP_TAPCELL_ROW_57_1247 VGND VPWR sky130_fd_sc_hd__tapvpwrvgnd_1
Xfanout614 net615 VGND VGND VPWR VPWR net614 sky130_fd_sc_hd__buf_2
Xhold189 u_interface.fifo_data\[8\]\[23\] VGND VGND VPWR VPWR net1054 sky130_fd_sc_hd__dlygate4sd3_1
XFILLER_98_450 VGND VGND VPWR VPWR sky130_fd_sc_hd__decap_8
X_09913_ _03610_ _03663_ _03664_ VGND VGND VPWR VPWR _03666_ sky130_fd_sc_hd__and3_1
Xfanout603 net608 VGND VGND VPWR VPWR net603 sky130_fd_sc_hd__buf_2
Xhold178 u_interface.fifo_data\[2\]\[31\] VGND VGND VPWR VPWR net1043 sky130_fd_sc_hd__dlygate4sd3_1
Xfanout647 net648 VGND VGND VPWR VPWR net647 sky130_fd_sc_hd__buf_2
X_09844_ net454 net620 net632 net459 VGND VGND VPWR VPWR _03598_ sky130_fd_sc_hd__a22o_1
Xfanout636 u_interface.u_gelu_fp32.u_synth_top.s2_m\[7\] VGND VGND VPWR VPWR net636
+ sky130_fd_sc_hd__clkbuf_2
Xfanout658 net661 VGND VGND VPWR VPWR net658 sky130_fd_sc_hd__buf_2
Xfanout625 net628 VGND VGND VPWR VPWR net625 sky130_fd_sc_hd__buf_2
XFILLER_112_282 VPWR VGND VPWR VGND sky130_ef_sc_hd__decap_12
Xfanout669 net674 VGND VGND VPWR VPWR net669 sky130_fd_sc_hd__clkbuf_2
XTAP_TAPCELL_ROW_70_1458 VGND VPWR sky130_fd_sc_hd__tapvpwrvgnd_1
XFILLER_58_358 VGND VGND VPWR VPWR sky130_fd_sc_hd__decap_6
XFILLER_58_347 VGND VGND VPWR VPWR sky130_fd_sc_hd__decap_8
XFILLER_37_15 VPWR VGND VPWR VGND sky130_ef_sc_hd__decap_12
X_06987_ net827 _01508_ _01509_ VGND VGND VPWR VPWR _01510_ sky130_fd_sc_hd__or3_2
XFILLER_100_477 VPWR VGND VPWR VGND sky130_ef_sc_hd__decap_12
X_09775_ _03522_ _03527_ _03529_ VGND VGND VPWR VPWR _00812_ sky130_fd_sc_hd__o21a_1
XFILLER_39_561 VGND VGND VPWR VPWR sky130_fd_sc_hd__decap_4
X_08726_ _02481_ _02484_ VGND VGND VPWR VPWR _02485_ sky130_fd_sc_hd__xnor2_1
XFILLER_54_531 VGND VGND VPWR VPWR sky130_fd_sc_hd__fill_1
X_08657_ _02268_ _02422_ VGND VGND VPWR VPWR _02423_ sky130_fd_sc_hd__xnor2_1
XTAP_TAPCELL_ROW_1_354 VGND VPWR sky130_fd_sc_hd__tapvpwrvgnd_1
XFILLER_81_372 VPWR VGND VPWR VGND sky130_ef_sc_hd__decap_12
X_07608_ net306 _01702_ VGND VGND VPWR VPWR _01703_ sky130_fd_sc_hd__and2_1
XFILLER_14_406 VPWR VGND VPWR VGND sky130_ef_sc_hd__decap_12
X_08588_ _02201_ _02222_ VGND VGND VPWR VPWR _02373_ sky130_fd_sc_hd__xnor2_1
XTAP_TAPCELL_ROW_85_1690 VGND VPWR sky130_fd_sc_hd__tapvpwrvgnd_1
XFILLER_41_225 VPWR VGND VPWR VGND sky130_ef_sc_hd__decap_12
XFILLER_139_113 VPWR VGND VPWR VGND sky130_ef_sc_hd__decap_12
X_07539_ net821 net1646 net304 _01644_ VGND VGND VPWR VPWR _00444_ sky130_fd_sc_hd__a22o_1
XFILLER_10_601 VPWR VGND VPWR VGND sky130_ef_sc_hd__decap_12
XFILLER_41_258 VPWR VGND VPWR VGND sky130_ef_sc_hd__decap_12
X_10550_ _04297_ VGND VGND VPWR VPWR _04298_ sky130_fd_sc_hd__inv_2
XFILLER_10_645 VPWR VGND VPWR VGND sky130_ef_sc_hd__decap_12
XFILLER_154_105 VGND VGND VPWR VPWR sky130_fd_sc_hd__fill_1
X_09209_ net597 net604 net501 net506 VGND VGND VPWR VPWR _02968_ sky130_fd_sc_hd__and4_1
X_10481_ net473 net715 VGND VGND VPWR VPWR _04229_ sky130_fd_sc_hd__nand2_1
XTAP_TAPCELL_ROW_20_651 VGND VPWR sky130_fd_sc_hd__tapvpwrvgnd_1
XFILLER_136_842 VGND VGND VPWR VPWR sky130_fd_sc_hd__decap_3
XFILLER_108_533 VPWR VGND VPWR VGND sky130_ef_sc_hd__decap_12
XFILLER_5_137 VPWR VGND VPWR VGND sky130_ef_sc_hd__decap_12
X_12220_ _05884_ _05887_ net203 VGND VGND VPWR VPWR _05950_ sky130_fd_sc_hd__a21o_1
XTAP_TAPCELL_ROW_20_662 VGND VPWR sky130_fd_sc_hd__tapvpwrvgnd_1
XFILLER_135_352 VGND VGND VPWR VPWR sky130_fd_sc_hd__fill_2
XFILLER_136_897 VGND VGND VPWR VPWR sky130_fd_sc_hd__decap_3
XFILLER_78_11 VGND VGND VPWR VPWR sky130_fd_sc_hd__decap_3
XFILLER_2_811 VGND VGND VPWR VPWR sky130_fd_sc_hd__fill_1
X_12151_ _05662_ _05881_ VGND VGND VPWR VPWR _05882_ sky130_fd_sc_hd__xnor2_1
XFILLER_150_344 VPWR VGND VPWR VGND sky130_ef_sc_hd__decap_12
X_11102_ _04748_ _04750_ _04844_ VGND VGND VPWR VPWR _04845_ sky130_fd_sc_hd__and3_1
Xhold690 u_interface.fifo_data\[7\]\[2\] VGND VGND VPWR VPWR net1555 sky130_fd_sc_hd__dlygate4sd3_1
XTAP_TAPCELL_ROW_9_476 VGND VPWR sky130_fd_sc_hd__tapvpwrvgnd_1
X_12082_ _05661_ _05813_ VGND VGND VPWR VPWR _05814_ sky130_fd_sc_hd__xnor2_1
XFILLER_89_472 VGND VGND VPWR VPWR sky130_fd_sc_hd__decap_8
X_11033_ _04775_ _04776_ VGND VGND VPWR VPWR _04777_ sky130_fd_sc_hd__nand2b_1
XTAP_TAPCELL_ROW_9_487 VGND VPWR sky130_fd_sc_hd__tapvpwrvgnd_1
XFILLER_104_794 VGND VGND VPWR VPWR sky130_fd_sc_hd__fill_2
XFILLER_103_293 VGND VGND VPWR VPWR sky130_fd_sc_hd__decap_6
XFILLER_18_701 VPWR VGND VPWR VGND sky130_ef_sc_hd__decap_12
X_12984_ net1099 net382 net224 VGND VGND VPWR VPWR _01067_ sky130_fd_sc_hd__mux2_1
XFILLER_92_648 VPWR VGND VPWR VGND sky130_ef_sc_hd__decap_12
XFILLER_91_136 VPWR VGND VPWR VGND sky130_ef_sc_hd__decap_12
XFILLER_91_125 VGND VGND VPWR VPWR sky130_fd_sc_hd__decap_4
XFILLER_17_200 VPWR VGND VPWR VGND sky130_ef_sc_hd__decap_12
XFILLER_91_169 VGND VGND VPWR VPWR sky130_fd_sc_hd__decap_6
XFILLER_45_542 VGND VGND VPWR VPWR sky130_fd_sc_hd__decap_8
XFILLER_17_233 VGND VGND VPWR VPWR sky130_fd_sc_hd__decap_3
X_11935_ net721 net415 net410 net709 VGND VGND VPWR VPWR _05669_ sky130_fd_sc_hd__a22o_1
XFILLER_27_81 VPWR VGND VPWR VGND sky130_ef_sc_hd__decap_12
XTAP_TAPCELL_ROW_28_784 VGND VPWR sky130_fd_sc_hd__tapvpwrvgnd_1
X_13605_ clknet_leaf_70_clk _00615_ VGND VGND VPWR VPWR u_interface.fifo_data\[3\]\[20\]
+ sky130_fd_sc_hd__dfxtp_1
X_11866_ net675 net684 net402 net398 VGND VGND VPWR VPWR _05601_ sky130_fd_sc_hd__and4_1
X_10817_ _04328_ _04560_ VGND VGND VPWR VPWR _04562_ sky130_fd_sc_hd__xnor2_1
X_11797_ _05528_ _05532_ VGND VGND VPWR VPWR _05533_ sky130_fd_sc_hd__xnor2_1
XTAP_TAPCELL_ROW_136_2510 VGND VPWR sky130_fd_sc_hd__tapvpwrvgnd_1
X_13536_ clknet_leaf_50_clk _00546_ VGND VGND VPWR VPWR u_interface.fifo_data\[5\]\[15\]
+ sky130_fd_sc_hd__dfxtp_1
X_10748_ net668 net443 net438 net660 VGND VGND VPWR VPWR _04494_ sky130_fd_sc_hd__a22o_1
XFILLER_9_432 VGND VGND VPWR VPWR sky130_fd_sc_hd__decap_4
XFILLER_13_494 VGND VGND VPWR VPWR sky130_fd_sc_hd__decap_8
XFILLER_43_80 VGND VGND VPWR VPWR sky130_fd_sc_hd__fill_1
X_13467_ clknet_leaf_63_clk _00477_ VGND VGND VPWR VPWR u_interface.u_gelu_fp32.u_q16_to_fp32.s3_norm_mag\[7\]
+ sky130_fd_sc_hd__dfxtp_1
X_10679_ _04220_ _04222_ _04423_ _04424_ VGND VGND VPWR VPWR _04426_ sky130_fd_sc_hd__a211o_1
X_12418_ _06092_ _06093_ _06095_ VGND VGND VPWR VPWR _06145_ sky130_fd_sc_hd__o21a_1
XFILLER_154_661 VGND VGND VPWR VPWR sky130_fd_sc_hd__fill_1
X_13398_ clknet_leaf_53_clk _00408_ VGND VGND VPWR VPWR u_interface.fifo_data\[6\]\[11\]
+ sky130_fd_sc_hd__dfxtp_1
XFILLER_127_897 VGND VGND VPWR VPWR sky130_fd_sc_hd__fill_1
XFILLER_126_396 VGND VGND VPWR VPWR sky130_fd_sc_hd__fill_2
XFILLER_99_225 VPWR VGND VPWR VGND sky130_ef_sc_hd__decap_12
XFILLER_5_671 VGND VGND VPWR VPWR sky130_fd_sc_hd__fill_1
X_12349_ _06075_ _06076_ VGND VGND VPWR VPWR _06077_ sky130_fd_sc_hd__nor2_1
XFILLER_141_355 VGND VGND VPWR VPWR sky130_fd_sc_hd__fill_1
XFILLER_4_41 VPWR VGND VPWR VGND sky130_ef_sc_hd__decap_12
X_06910_ _01447_ _01448_ VGND VGND VPWR VPWR _00035_ sky130_fd_sc_hd__xnor2_1
X_14019_ clknet_leaf_65_clk _00945_ VGND VGND VPWR VPWR u_interface.core_data_out\[5\]
+ sky130_fd_sc_hd__dfxtp_1
XFILLER_4_85 VPWR VGND VPWR VGND sky130_ef_sc_hd__decap_12
X_07890_ net1021 net576 net268 VGND VGND VPWR VPWR _00651_ sky130_fd_sc_hd__mux2_1
XFILLER_67_111 VGND VGND VPWR VPWR sky130_fd_sc_hd__fill_1
XTAP_TAPCELL_ROW_52_1166 VGND VPWR sky130_fd_sc_hd__tapvpwrvgnd_1
XTAP_TAPCELL_ROW_147_2694 VGND VPWR sky130_fd_sc_hd__tapvpwrvgnd_1
XTAP_TAPCELL_ROW_147_2683 VGND VPWR sky130_fd_sc_hd__tapvpwrvgnd_1
X_06841_ u_interface.fifo_data\[0\]\[26\] u_interface.fifo_data\[1\]\[26\] u_interface.fifo_data\[2\]\[26\]
+ u_interface.fifo_data\[3\]\[26\] net770 net753 VGND VGND VPWR VPWR _01390_ sky130_fd_sc_hd__mux4_1
XFILLER_110_753 VGND VGND VPWR VPWR sky130_fd_sc_hd__decap_3
XFILLER_95_453 VPWR VGND VPWR VGND sky130_ef_sc_hd__decap_12
XFILLER_83_615 VGND VGND VPWR VPWR sky130_fd_sc_hd__fill_1
XFILLER_56_829 VPWR VGND VPWR VGND sky130_ef_sc_hd__decap_12
X_09560_ _03225_ _03314_ _03315_ VGND VGND VPWR VPWR _03317_ sky130_fd_sc_hd__nand3b_2
X_06772_ _01325_ _01326_ _01329_ net318 VGND VGND VPWR VPWR net117 sky130_fd_sc_hd__a22o_1
XFILLER_83_637 VGND VGND VPWR VPWR sky130_fd_sc_hd__fill_2
X_09491_ net486 net671 net680 net491 VGND VGND VPWR VPWR _03248_ sky130_fd_sc_hd__a22o_1
XFILLER_70_309 VPWR VGND VPWR VGND sky130_ef_sc_hd__decap_12
X_08511_ _02300_ _02301_ VGND VGND VPWR VPWR _02302_ sky130_fd_sc_hd__nand2_1
XFILLER_91_670 VGND VGND VPWR VPWR sky130_fd_sc_hd__fill_2
X_08442_ _02187_ _02232_ VGND VGND VPWR VPWR _02233_ sky130_fd_sc_hd__nor2_1
XFILLER_51_523 VPWR VGND VPWR VGND sky130_ef_sc_hd__decap_12
XFILLER_24_737 VPWR VGND VPWR VGND sky130_ef_sc_hd__decap_12
XFILLER_63_383 VGND VGND VPWR VPWR sky130_fd_sc_hd__decap_8
X_08373_ net521 u_interface.u_gelu_fp32.u_synth_top.s3_mult\[48\] VGND VGND VPWR VPWR
+ _02164_ sky130_fd_sc_hd__or2_1
XPHY_EDGE_ROW_83_Left_239 VGND VGND VPWR VPWR sky130_fd_sc_hd__decap_3
XFILLER_23_39 VPWR VGND VPWR VGND sky130_ef_sc_hd__decap_12
XFILLER_32_781 VPWR VGND VPWR VGND sky130_ef_sc_hd__decap_12
X_07324_ net987 net342 net253 VGND VGND VPWR VPWR _00354_ sky130_fd_sc_hd__mux2_1
XFILLER_137_606 VGND VGND VPWR VPWR sky130_fd_sc_hd__fill_1
X_07255_ net1324 net346 net251 VGND VGND VPWR VPWR _00287_ sky130_fd_sc_hd__mux2_1
X_07186_ net1052 net571 net263 VGND VGND VPWR VPWR _00226_ sky130_fd_sc_hd__mux2_1
XFILLER_155_27 VGND VGND VPWR VPWR sky130_fd_sc_hd__fill_1
XFILLER_132_333 VGND VGND VPWR VPWR sky130_fd_sc_hd__decap_6
XFILLER_133_889 VGND VGND VPWR VPWR sky130_fd_sc_hd__fill_1
Xfanout422 u_interface.u_gelu_fp32.u_synth_top.s2_dx\[23\] VGND VGND VPWR VPWR net422
+ sky130_fd_sc_hd__clkbuf_4
Xfanout400 u_interface.u_gelu_fp32.u_synth_top.s2_dx\[28\] VGND VGND VPWR VPWR net400
+ sky130_fd_sc_hd__buf_2
XTAP_TAPCELL_ROW_6_435 VGND VPWR sky130_fd_sc_hd__tapvpwrvgnd_1
XTAP_TAPCELL_ROW_6_424 VGND VPWR sky130_fd_sc_hd__tapvpwrvgnd_1
Xfanout411 net412 VGND VGND VPWR VPWR net411 sky130_fd_sc_hd__clkbuf_2
Xfanout466 u_interface.u_gelu_fp32.u_synth_top.s2_dx\[13\] VGND VGND VPWR VPWR net466
+ sky130_fd_sc_hd__buf_2
XPHY_EDGE_ROW_92_Left_248 VGND VGND VPWR VPWR sky130_fd_sc_hd__decap_3
Xfanout455 u_interface.u_gelu_fp32.u_synth_top.s2_dx\[16\] VGND VGND VPWR VPWR net455
+ sky130_fd_sc_hd__clkbuf_2
Xfanout433 u_interface.u_gelu_fp32.u_synth_top.s2_dx\[21\] VGND VGND VPWR VPWR net433
+ sky130_fd_sc_hd__clkbuf_2
Xfanout444 net445 VGND VGND VPWR VPWR net444 sky130_fd_sc_hd__clkbuf_1
Xfanout488 net489 VGND VGND VPWR VPWR net488 sky130_fd_sc_hd__clkbuf_2
Xfanout477 u_interface.u_gelu_fp32.u_synth_top.s2_dx\[10\] VGND VGND VPWR VPWR net477
+ sky130_fd_sc_hd__buf_2
Xfanout499 u_interface.u_gelu_fp32.u_synth_top.s2_dx\[5\] VGND VGND VPWR VPWR net499
+ sky130_fd_sc_hd__clkbuf_4
X_09827_ net475 net672 net681 net479 VGND VGND VPWR VPWR _03581_ sky130_fd_sc_hd__a22o_1
XFILLER_46_306 VGND VGND VPWR VPWR sky130_fd_sc_hd__fill_2
X_09758_ _03366_ _03406_ _03509_ _03510_ VGND VGND VPWR VPWR _03513_ sky130_fd_sc_hd__a211o_1
XTAP_TAPCELL_ROW_87_1730 VGND VPWR sky130_fd_sc_hd__tapvpwrvgnd_1
XFILLER_46_328 VGND VGND VPWR VPWR sky130_fd_sc_hd__fill_1
X_08709_ _02465_ _02466_ _02461_ VGND VGND VPWR VPWR _02468_ sky130_fd_sc_hd__a21boi_1
X_09689_ _03441_ _03443_ VGND VGND VPWR VPWR _03444_ sky130_fd_sc_hd__nor2_1
XFILLER_55_895 VGND VGND VPWR VPWR sky130_fd_sc_hd__fill_1
X_11720_ _05357_ _05375_ _05374_ VGND VGND VPWR VPWR _05457_ sky130_fd_sc_hd__o21a_1
XTAP_TAPCELL_ROW_25_732 VGND VPWR sky130_fd_sc_hd__tapvpwrvgnd_1
XTAP_TAPCELL_ROW_25_743 VGND VPWR sky130_fd_sc_hd__tapvpwrvgnd_1
XFILLER_27_597 VPWR VGND VPWR VGND sky130_ef_sc_hd__decap_12
X_11651_ _05220_ _05295_ _05294_ VGND VGND VPWR VPWR _05389_ sky130_fd_sc_hd__a21boi_1
XFILLER_42_589 VPWR VGND VPWR VGND sky130_ef_sc_hd__decap_12
XFILLER_120_96 VGND VGND VPWR VPWR sky130_fd_sc_hd__decap_4
X_10602_ _04346_ _04347_ _04227_ _04230_ VGND VGND VPWR VPWR _04349_ sky130_fd_sc_hd__a211o_1
X_11582_ net205 _05230_ _05229_ VGND VGND VPWR VPWR _05320_ sky130_fd_sc_hd__o21ai_1
X_10533_ _04278_ _04280_ VGND VGND VPWR VPWR _04281_ sky130_fd_sc_hd__nand2_1
X_13321_ clknet_leaf_68_clk _00331_ VGND VGND VPWR VPWR u_interface.fifo_data\[8\]\[30\]
+ sky130_fd_sc_hd__dfxtp_1
XFILLER_10_453 VPWR VGND VPWR VGND sky130_ef_sc_hd__decap_12
XFILLER_155_447 VGND VGND VPWR VPWR sky130_fd_sc_hd__fill_1
X_10464_ _04205_ _04209_ _04210_ VGND VGND VPWR VPWR _04212_ sky130_fd_sc_hd__nand3_1
X_13252_ clknet_leaf_68_clk _00262_ VGND VGND VPWR VPWR u_interface.fifo_data\[11\]\[30\]
+ sky130_fd_sc_hd__dfxtp_1
XFILLER_151_620 VPWR VGND VPWR VGND sky130_ef_sc_hd__decap_12
XTAP_TAPCELL_ROW_114_2159 VGND VPWR sky130_fd_sc_hd__tapvpwrvgnd_1
XFILLER_109_897 VGND VGND VPWR VPWR sky130_fd_sc_hd__fill_2
X_13183_ clknet_leaf_48_clk _00193_ VGND VGND VPWR VPWR u_interface.fifo_data\[9\]\[25\]
+ sky130_fd_sc_hd__dfxtp_1
X_10395_ net587 net594 net417 net413 VGND VGND VPWR VPWR _04144_ sky130_fd_sc_hd__and4_1
X_12203_ _05863_ _05932_ _05933_ VGND VGND VPWR VPWR _05934_ sky130_fd_sc_hd__and3b_1
XFILLER_151_653 VGND VGND VPWR VPWR sky130_fd_sc_hd__fill_2
XFILLER_123_333 VGND VGND VPWR VPWR sky130_fd_sc_hd__decap_3
X_12134_ _05864_ _05865_ net772 VGND VGND VPWR VPWR _05866_ sky130_fd_sc_hd__o21ai_1
XFILLER_151_697 VGND VGND VPWR VPWR sky130_fd_sc_hd__fill_1
XFILLER_111_517 VGND VGND VPWR VPWR sky130_fd_sc_hd__fill_1
XFILLER_104_580 VGND VGND VPWR VPWR sky130_fd_sc_hd__decap_8
X_12065_ _05793_ _05797_ VGND VGND VPWR VPWR _05798_ sky130_fd_sc_hd__nor2_1
X_11016_ _04634_ _04758_ VGND VGND VPWR VPWR _04760_ sky130_fd_sc_hd__xnor2_1
XFILLER_49_155 VGND VGND VPWR VPWR sky130_fd_sc_hd__fill_1
XFILLER_38_829 VGND VGND VPWR VPWR sky130_fd_sc_hd__decap_4
XFILLER_46_862 VGND VGND VPWR VPWR sky130_fd_sc_hd__decap_6
X_12967_ _06468_ _06485_ VGND VGND VPWR VPWR _06486_ sky130_fd_sc_hd__nand2_1
XFILLER_52_309 VGND VGND VPWR VPWR sky130_fd_sc_hd__decap_6
XFILLER_45_361 VGND VGND VPWR VPWR sky130_fd_sc_hd__fill_1
XFILLER_33_501 VGND VGND VPWR VPWR sky130_fd_sc_hd__decap_3
XFILLER_33_512 VPWR VGND VPWR VGND sky130_ef_sc_hd__decap_12
X_12898_ net786 net916 VGND VGND VPWR VPWR _01040_ sky130_fd_sc_hd__and2_1
X_11918_ _05572_ _05575_ net179 VGND VGND VPWR VPWR _05652_ sky130_fd_sc_hd__o21a_1
XFILLER_21_729 VPWR VGND VPWR VGND sky130_ef_sc_hd__decap_12
X_11849_ _05578_ _05583_ VGND VGND VPWR VPWR _05584_ sky130_fd_sc_hd__nor2_1
XFILLER_14_781 VPWR VGND VPWR VGND sky130_ef_sc_hd__decap_12
XFILLER_146_414 VGND VGND VPWR VPWR sky130_fd_sc_hd__decap_6
XFILLER_119_617 VPWR VGND VPWR VGND sky130_ef_sc_hd__decap_12
XFILLER_146_447 VGND VGND VPWR VPWR sky130_fd_sc_hd__decap_8
Xclkload10 clknet_leaf_58_clk VGND VGND VPWR VPWR clkload10/Y sky130_fd_sc_hd__inv_6
X_13519_ clknet_leaf_66_clk _00529_ VGND VGND VPWR VPWR u_interface.core_data_out\[30\]
+ sky130_fd_sc_hd__dfxtp_1
Xclkload32 clknet_leaf_18_clk VGND VGND VPWR VPWR clkload32/Y sky130_fd_sc_hd__clkinvlp_4
X_07040_ net1274 net577 net272 VGND VGND VPWR VPWR _00080_ sky130_fd_sc_hd__mux2_1
Xclkload21 clknet_leaf_5_clk VGND VGND VPWR VPWR clkload21/Y sky130_fd_sc_hd__bufinv_16
Xclkload43 clknet_leaf_76_clk VGND VGND VPWR VPWR clkload43/Y sky130_fd_sc_hd__clkinvlp_4
Xclkload76 clknet_leaf_39_clk VGND VGND VPWR VPWR clkload76/Y sky130_fd_sc_hd__clkinv_4
Xclkload65 clknet_leaf_26_clk VGND VGND VPWR VPWR clkload65/X sky130_fd_sc_hd__clkbuf_8
Xclkload87 clknet_leaf_67_clk VGND VGND VPWR VPWR clkload87/Y sky130_fd_sc_hd__clkinv_4
Xclkload54 clknet_leaf_63_clk VGND VGND VPWR VPWR clkload54/Y sky130_fd_sc_hd__clkinv_4
XTAP_TAPCELL_ROW_54_1206 VGND VPWR sky130_fd_sc_hd__tapvpwrvgnd_1
XTAP_TAPCELL_ROW_149_2723 VGND VPWR sky130_fd_sc_hd__tapvpwrvgnd_1
XTAP_TAPCELL_ROW_149_2712 VGND VPWR sky130_fd_sc_hd__tapvpwrvgnd_1
X_08991_ _02738_ _02748_ VGND VGND VPWR VPWR _02750_ sky130_fd_sc_hd__xnor2_1
XFILLER_114_377 VGND VGND VPWR VPWR sky130_fd_sc_hd__decap_8
XFILLER_87_217 VGND VGND VPWR VPWR sky130_fd_sc_hd__decap_6
X_07942_ net817 net547 _01832_ VGND VGND VPWR VPWR _00676_ sky130_fd_sc_hd__a21o_1
XFILLER_130_859 VGND VGND VPWR VPWR sky130_fd_sc_hd__fill_1
X_07873_ net1018 net371 net267 VGND VGND VPWR VPWR _00634_ sky130_fd_sc_hd__mux2_1
XFILLER_96_762 VGND VGND VPWR VPWR sky130_fd_sc_hd__fill_2
X_06824_ net322 _01374_ net728 VGND VGND VPWR VPWR _01375_ sky130_fd_sc_hd__o21a_1
X_09612_ net510 net724 VGND VGND VPWR VPWR _03368_ sky130_fd_sc_hd__nand2_2
XFILLER_83_434 VPWR VGND VPWR VGND sky130_ef_sc_hd__decap_12
XFILLER_68_475 VGND VGND VPWR VPWR sky130_fd_sc_hd__fill_1
XFILLER_55_103 VGND VGND VPWR VPWR sky130_fd_sc_hd__decap_8
XFILLER_28_317 VGND VGND VPWR VPWR sky130_fd_sc_hd__fill_1
X_09543_ _03159_ _03161_ _03298_ _03299_ VGND VGND VPWR VPWR _03300_ sky130_fd_sc_hd__a211oi_2
X_06755_ _01313_ _01314_ net731 VGND VGND VPWR VPWR _01315_ sky130_fd_sc_hd__mux2_1
XFILLER_83_478 VGND VGND VPWR VPWR sky130_fd_sc_hd__fill_1
XFILLER_55_169 VGND VGND VPWR VPWR sky130_fd_sc_hd__decap_6
XFILLER_36_350 VGND VGND VPWR VPWR sky130_fd_sc_hd__fill_1
XFILLER_43_309 VGND VGND VPWR VPWR sky130_fd_sc_hd__fill_1
X_06686_ u_interface.fifo_data\[8\]\[7\] u_interface.fifo_data\[9\]\[7\] u_interface.fifo_data\[10\]\[7\]
+ u_interface.fifo_data\[11\]\[7\] net766 net749 VGND VGND VPWR VPWR _01254_ sky130_fd_sc_hd__mux4_1
X_09474_ net510 net714 VGND VGND VPWR VPWR _03231_ sky130_fd_sc_hd__nand2_1
XFILLER_70_139 VGND VGND VPWR VPWR sky130_fd_sc_hd__fill_1
XFILLER_34_27 VGND VGND VPWR VPWR sky130_fd_sc_hd__fill_1
X_08425_ _02209_ _02210_ _02215_ VGND VGND VPWR VPWR _02216_ sky130_fd_sc_hd__and3_1
XTAP_TAPCELL_ROW_65_1379 VGND VPWR sky130_fd_sc_hd__tapvpwrvgnd_1
XTAP_TAPCELL_ROW_65_1368 VGND VPWR sky130_fd_sc_hd__tapvpwrvgnd_1
X_08356_ net528 _02149_ net1641 VGND VGND VPWR VPWR _02150_ sky130_fd_sc_hd__a21oi_1
XFILLER_137_414 VPWR VGND VPWR VGND sky130_ef_sc_hd__decap_12
X_07307_ net1252 net376 net254 VGND VGND VPWR VPWR _00337_ sky130_fd_sc_hd__mux2_1
Xclkload4 clknet_3_4__leaf_clk VGND VGND VPWR VPWR clkload4/X sky130_fd_sc_hd__clkbuf_8
XFILLER_50_15 VPWR VGND VPWR VGND sky130_ef_sc_hd__decap_12
XFILLER_149_274 VGND VGND VPWR VPWR sky130_fd_sc_hd__decap_3
X_08287_ u_interface.u_gelu_fp32.s2_data\[11\] _02095_ VGND VGND VPWR VPWR _02098_
+ sky130_fd_sc_hd__or2_1
X_07238_ net1352 net380 net249 VGND VGND VPWR VPWR _00270_ sky130_fd_sc_hd__mux2_1
XFILLER_4_917 VGND VGND VPWR VPWR sky130_fd_sc_hd__fill_1
X_07169_ net1101 net367 net261 VGND VGND VPWR VPWR _00209_ sky130_fd_sc_hd__mux2_1
XFILLER_3_405 VPWR VGND VPWR VGND sky130_ef_sc_hd__decap_12
XFILLER_145_491 VGND VGND VPWR VPWR sky130_fd_sc_hd__fill_2
XFILLER_3_449 VPWR VGND VPWR VGND sky130_ef_sc_hd__decap_12
XFILLER_105_377 VGND VGND VPWR VPWR sky130_fd_sc_hd__decap_3
X_10180_ net609 net436 VGND VGND VPWR VPWR _03931_ sky130_fd_sc_hd__nand2_1
XFILLER_79_729 VPWR VGND VPWR VGND sky130_ef_sc_hd__decap_12
XFILLER_59_57 VPWR VGND VPWR VGND sky130_ef_sc_hd__decap_12
Xfanout230 _01519_ VGND VGND VPWR VPWR net230 sky130_fd_sc_hd__clkbuf_4
Xfanout241 net242 VGND VGND VPWR VPWR net241 sky130_fd_sc_hd__buf_4
XFILLER_59_79 VPWR VGND VPWR VGND sky130_ef_sc_hd__decap_12
Xfanout252 _01513_ VGND VGND VPWR VPWR net252 sky130_fd_sc_hd__clkbuf_8
Xfanout263 net264 VGND VGND VPWR VPWR net263 sky130_fd_sc_hd__buf_4
XFILLER_120_358 VGND VGND VPWR VPWR sky130_fd_sc_hd__fill_2
Xfanout274 net276 VGND VGND VPWR VPWR net274 sky130_fd_sc_hd__buf_2
XFILLER_87_751 VGND VGND VPWR VPWR sky130_fd_sc_hd__fill_2
Xfanout285 _01520_ VGND VGND VPWR VPWR net285 sky130_fd_sc_hd__clkbuf_8
X_13870_ clknet_leaf_22_clk net870 VGND VGND VPWR VPWR u_interface.u_gelu_fp32.u_synth_top.s2_dx\[6\]
+ sky130_fd_sc_hd__dfxtp_1
XFILLER_115_85 VGND VGND VPWR VPWR sky130_fd_sc_hd__decap_3
XFILLER_101_561 VGND VGND VPWR VPWR sky130_fd_sc_hd__decap_3
Xfanout296 net297 VGND VGND VPWR VPWR net296 sky130_fd_sc_hd__buf_2
XFILLER_75_23 VGND VGND VPWR VPWR sky130_fd_sc_hd__decap_3
XFILLER_74_401 VPWR VGND VPWR VGND sky130_ef_sc_hd__decap_12
XFILLER_47_626 VGND VGND VPWR VPWR sky130_fd_sc_hd__decap_6
X_12821_ net776 net80 VGND VGND VPWR VPWR _00979_ sky130_fd_sc_hd__and2_1
XFILLER_34_309 VGND VGND VPWR VPWR sky130_fd_sc_hd__decap_6
X_12752_ net1584 net1611 net825 VGND VGND VPWR VPWR _00934_ sky130_fd_sc_hd__mux2_1
XFILLER_42_331 VGND VGND VPWR VPWR sky130_fd_sc_hd__decap_3
X_12683_ net807 u_interface.u_gelu_fp32.u_q16_to_fp32.s3_norm_mag\[16\] _01699_ _06344_
+ VGND VGND VPWR VPWR _06345_ sky130_fd_sc_hd__a22o_1
X_11703_ net658 net666 net402 net398 VGND VGND VPWR VPWR _05440_ sky130_fd_sc_hd__and4_1
X_11634_ _05362_ _05371_ VGND VGND VPWR VPWR _05372_ sky130_fd_sc_hd__xnor2_1
X_11565_ net195 _05303_ VGND VGND VPWR VPWR _05304_ sky130_fd_sc_hd__xnor2_1
XFILLER_155_244 VGND VGND VPWR VPWR sky130_fd_sc_hd__decap_4
XFILLER_155_233 VGND VGND VPWR VPWR sky130_fd_sc_hd__fill_1
XFILLER_144_918 VGND VGND VPWR VPWR sky130_fd_sc_hd__decap_3
X_13304_ clknet_leaf_34_clk _00314_ VGND VGND VPWR VPWR u_interface.fifo_data\[8\]\[13\]
+ sky130_fd_sc_hd__dfxtp_1
X_10516_ net635 net436 VGND VGND VPWR VPWR _04264_ sky130_fd_sc_hd__and2_1
X_11496_ _05233_ _05234_ VGND VGND VPWR VPWR _05235_ sky130_fd_sc_hd__and2_1
XFILLER_7_777 VGND VGND VPWR VPWR sky130_fd_sc_hd__decap_6
XFILLER_6_221 VPWR VGND VPWR VGND sky130_ef_sc_hd__decap_12
X_13235_ clknet_leaf_34_clk _00245_ VGND VGND VPWR VPWR u_interface.fifo_data\[11\]\[13\]
+ sky130_fd_sc_hd__dfxtp_1
XFILLER_108_160 VGND VGND VPWR VPWR sky130_fd_sc_hd__fill_2
X_10447_ _04078_ _04079_ _03966_ VGND VGND VPWR VPWR _04196_ sky130_fd_sc_hd__or3b_1
XFILLER_6_276 VPWR VGND VPWR VGND sky130_ef_sc_hd__decap_12
XFILLER_6_265 VGND VGND VPWR VPWR sky130_fd_sc_hd__fill_1
XFILLER_151_461 VGND VGND VPWR VPWR sky130_fd_sc_hd__decap_4
X_10378_ net461 net682 _04125_ _04126_ VGND VGND VPWR VPWR _04127_ sky130_fd_sc_hd__a22o_1
XFILLER_69_217 VGND VGND VPWR VPWR sky130_fd_sc_hd__fill_1
X_13166_ clknet_leaf_72_clk _00176_ VGND VGND VPWR VPWR u_interface.fifo_data\[9\]\[8\]
+ sky130_fd_sc_hd__dfxtp_1
XFILLER_97_559 VGND VGND VPWR VPWR sky130_fd_sc_hd__fill_1
X_13097_ clknet_leaf_49_clk _00107_ VGND VGND VPWR VPWR u_interface.fifo_data\[15\]\[18\]
+ sky130_fd_sc_hd__dfxtp_1
X_12117_ _05810_ _05848_ VGND VGND VPWR VPWR _05849_ sky130_fd_sc_hd__xnor2_1
XFILLER_111_358 VGND VGND VPWR VPWR sky130_fd_sc_hd__fill_2
X_12048_ _05728_ _05780_ VGND VGND VPWR VPWR _05781_ sky130_fd_sc_hd__xor2_1
XFILLER_77_272 VGND VGND VPWR VPWR sky130_fd_sc_hd__decap_8
XFILLER_38_637 VGND VGND VPWR VPWR sky130_fd_sc_hd__decap_6
XPHY_EDGE_ROW_148_Left_304 VGND VGND VPWR VPWR sky130_fd_sc_hd__decap_3
XTAP_TAPCELL_ROW_144_2642 VGND VPWR sky130_fd_sc_hd__tapvpwrvgnd_1
XFILLER_92_253 VPWR VGND VPWR VGND sky130_ef_sc_hd__decap_12
X_13999_ clknet_leaf_64_clk _00925_ VGND VGND VPWR VPWR u_interface.u_gelu_fp32.u_q16_to_fp32.s3_norm_mag\[26\]
+ sky130_fd_sc_hd__dfxtp_1
XFILLER_37_169 VGND VGND VPWR VPWR sky130_fd_sc_hd__fill_2
X_06540_ u_interface.u_gelu_fp32.s1_data\[23\] u_interface.u_gelu_fp32.s1_data\[22\]
+ _01133_ _01136_ VGND VGND VPWR VPWR _01137_ sky130_fd_sc_hd__or4_1
XFILLER_80_437 VPWR VGND VPWR VGND sky130_ef_sc_hd__decap_12
XFILLER_19_895 VGND VGND VPWR VPWR sky130_fd_sc_hd__fill_1
X_08210_ _01891_ _02040_ VGND VGND VPWR VPWR _02041_ sky130_fd_sc_hd__nor2_1
XTAP_TAPCELL_ROW_47_1087 VGND VPWR sky130_fd_sc_hd__tapvpwrvgnd_1
XTAP_TAPCELL_ROW_16_584 VGND VPWR sky130_fd_sc_hd__tapvpwrvgnd_1
X_09190_ _02917_ _02947_ _02948_ VGND VGND VPWR VPWR _02949_ sky130_fd_sc_hd__and3_1
XFILLER_60_194 VGND VGND VPWR VPWR sky130_fd_sc_hd__fill_2
XTAP_TAPCELL_ROW_16_595 VGND VPWR sky130_fd_sc_hd__tapvpwrvgnd_1
XFILLER_21_559 VGND VGND VPWR VPWR sky130_fd_sc_hd__fill_1
XFILLER_119_425 VGND VGND VPWR VPWR sky130_fd_sc_hd__decap_4
X_08141_ _01977_ _01978_ net541 VGND VGND VPWR VPWR _01983_ sky130_fd_sc_hd__o21a_1
XFILLER_146_233 VGND VGND VPWR VPWR sky130_fd_sc_hd__fill_2
X_08072_ u_interface.u_gelu_fp32.u_fp32_to_q16.s3_mag\[3\] _01874_ u_interface.u_gelu_fp32.u_fp32_to_q16.s3_mag\[4\]
+ VGND VGND VPWR VPWR _01925_ sky130_fd_sc_hd__a21oi_1
XTAP_TAPCELL_ROW_60_1298 VGND VPWR sky130_fd_sc_hd__tapvpwrvgnd_1
XFILLER_134_417 VGND VGND VPWR VPWR sky130_fd_sc_hd__decap_3
XFILLER_20_29 VPWR VGND VPWR VGND sky130_ef_sc_hd__decap_12
X_07023_ net1035 net372 net269 VGND VGND VPWR VPWR _00063_ sky130_fd_sc_hd__mux2_1
XFILLER_136_29 VPWR VGND VPWR VGND sky130_ef_sc_hd__decap_12
XFILLER_1_909 VPWR VGND VPWR VGND sky130_ef_sc_hd__decap_12
XFILLER_142_494 VGND VGND VPWR VPWR sky130_fd_sc_hd__decap_4
X_08974_ _02715_ _02731_ _02732_ VGND VGND VPWR VPWR _02733_ sky130_fd_sc_hd__and3_1
XFILLER_88_537 VGND VGND VPWR VPWR sky130_fd_sc_hd__fill_1
X_07925_ u_interface.u_gelu_fp32.u_fp32_to_q16.s1_mant\[5\] u_interface.u_gelu_fp32.u_fp32_to_q16.s1_mant\[4\]
+ u_interface.u_gelu_fp32.u_fp32_to_q16.s1_mant\[7\] u_interface.u_gelu_fp32.u_fp32_to_q16.s1_mant\[6\]
+ VGND VGND VPWR VPWR _01819_ sky130_fd_sc_hd__or4_1
Xhold16 u_interface.u_gelu_fp32.s1_data\[0\] VGND VGND VPWR VPWR net881 sky130_fd_sc_hd__dlygate4sd3_1
Xhold27 u_interface.u_gelu_fp32.s1_data\[8\] VGND VGND VPWR VPWR net892 sky130_fd_sc_hd__dlygate4sd3_1
Xhold38 u_interface.u_gelu_fp32.s1_data\[25\] VGND VGND VPWR VPWR net903 sky130_fd_sc_hd__dlygate4sd3_1
XPHY_EDGE_ROW_89_Right_89 VGND VGND VPWR VPWR sky130_fd_sc_hd__decap_3
XFILLER_29_27 VPWR VGND VPWR VGND sky130_ef_sc_hd__decap_12
Xhold49 _00913_ VGND VGND VPWR VPWR net914 sky130_fd_sc_hd__dlygate4sd3_1
XFILLER_29_615 VGND VGND VPWR VPWR sky130_fd_sc_hd__fill_1
X_07856_ net340 net1479 net284 VGND VGND VPWR VPWR _00617_ sky130_fd_sc_hd__mux2_1
XFILLER_110_380 VGND VGND VPWR VPWR sky130_fd_sc_hd__fill_1
XTAP_TAPCELL_ROW_67_1408 VGND VPWR sky130_fd_sc_hd__tapvpwrvgnd_1
X_06807_ net735 _01359_ VGND VGND VPWR VPWR _01360_ sky130_fd_sc_hd__or2_1
X_07787_ net997 net350 net235 VGND VGND VPWR VPWR _00548_ sky130_fd_sc_hd__mux2_1
XFILLER_45_15 VGND VGND VPWR VPWR sky130_fd_sc_hd__decap_6
X_06738_ u_interface.fifo_data\[4\]\[13\] u_interface.fifo_data\[5\]\[13\] u_interface.fifo_data\[6\]\[13\]
+ u_interface.fifo_data\[7\]\[13\] net767 net750 VGND VGND VPWR VPWR _01300_ sky130_fd_sc_hd__mux4_1
X_09526_ net477 net481 net648 net656 VGND VGND VPWR VPWR _03283_ sky130_fd_sc_hd__and4_1
XFILLER_25_821 VPWR VGND VPWR VGND sky130_ef_sc_hd__decap_12
XFILLER_43_139 VGND VGND VPWR VPWR sky130_fd_sc_hd__fill_2
X_09457_ _02699_ _02702_ _03212_ _03213_ VGND VGND VPWR VPWR _03215_ sky130_fd_sc_hd__o211ai_4
XTAP_TAPCELL_ROW_80_1619 VGND VPWR sky130_fd_sc_hd__tapvpwrvgnd_1
XTAP_TAPCELL_ROW_80_1608 VGND VPWR sky130_fd_sc_hd__tapvpwrvgnd_1
XFILLER_25_865 VPWR VGND VPWR VGND sky130_ef_sc_hd__decap_12
XPHY_EDGE_ROW_98_Right_98 VGND VGND VPWR VPWR sky130_fd_sc_hd__decap_3
X_08408_ u_interface.u_gelu_fp32.u_synth_top.s3_mult\[22\] u_interface.u_gelu_fp32.u_synth_top.s3_b\[6\]
+ VGND VGND VPWR VPWR _02199_ sky130_fd_sc_hd__nand2_1
X_06669_ u_interface.fifo_data\[8\]\[5\] u_interface.fifo_data\[9\]\[5\] u_interface.fifo_data\[10\]\[5\]
+ u_interface.fifo_data\[11\]\[5\] net758 net741 VGND VGND VPWR VPWR _01239_ sky130_fd_sc_hd__mux4_1
XFILLER_12_515 VPWR VGND VPWR VGND sky130_ef_sc_hd__decap_12
XTAP_TAPCELL_ROW_35_893 VGND VPWR sky130_fd_sc_hd__tapvpwrvgnd_1
XFILLER_40_813 VGND VGND VPWR VPWR sky130_fd_sc_hd__fill_1
X_09388_ _03143_ _03144_ _03145_ VGND VGND VPWR VPWR _03146_ sky130_fd_sc_hd__a21oi_1
XFILLER_101_87 VGND VGND VPWR VPWR sky130_fd_sc_hd__decap_6
X_08339_ u_interface.u_gelu_fp32.s2_data\[24\] _02134_ VGND VGND VPWR VPWR _02137_
+ sky130_fd_sc_hd__or2_1
XFILLER_137_255 VGND VGND VPWR VPWR sky130_fd_sc_hd__fill_1
XFILLER_20_581 VGND VGND VPWR VPWR sky130_fd_sc_hd__decap_6
X_11350_ _05081_ _05090_ VGND VGND VPWR VPWR _05091_ sky130_fd_sc_hd__xnor2_1
XFILLER_117_3 VGND VGND VPWR VPWR sky130_fd_sc_hd__decap_4
X_10301_ _04049_ _04050_ VGND VGND VPWR VPWR _04051_ sky130_fd_sc_hd__and2b_1
XFILLER_4_725 VPWR VGND VPWR VGND sky130_ef_sc_hd__decap_12
XTAP_TAPCELL_ROW_111_2118 VGND VPWR sky130_fd_sc_hd__tapvpwrvgnd_1
XTAP_TAPCELL_ROW_111_2107 VGND VPWR sky130_fd_sc_hd__tapvpwrvgnd_1
XTAP_TAPCELL_ROW_95_1862 VGND VPWR sky130_fd_sc_hd__tapvpwrvgnd_1
XTAP_TAPCELL_ROW_95_1851 VGND VPWR sky130_fd_sc_hd__tapvpwrvgnd_1
X_11281_ net799 _05022_ VGND VGND VPWR VPWR _00825_ sky130_fd_sc_hd__nor2_1
X_13020_ net170 net165 net161 net160 net151 VGND VGND VPWR VPWR _00847_ sky130_fd_sc_hd__o2111a_1
XFILLER_152_269 VPWR VGND VPWR VGND sky130_ef_sc_hd__decap_12
XFILLER_133_461 VGND VGND VPWR VPWR sky130_fd_sc_hd__decap_8
XFILLER_126_40 VGND VGND VPWR VPWR sky130_fd_sc_hd__decap_3
X_10232_ _03868_ _03869_ _03980_ VGND VGND VPWR VPWR _03982_ sky130_fd_sc_hd__nand3_1
XFILLER_4_769 VPWR VGND VPWR VGND sky130_ef_sc_hd__decap_12
XFILLER_105_174 VPWR VGND VPWR VGND sky130_ef_sc_hd__decap_12
X_10163_ _03822_ _03828_ _03829_ VGND VGND VPWR VPWR _03914_ sky130_fd_sc_hd__a21bo_1
XFILLER_79_548 VPWR VGND VPWR VGND sky130_ef_sc_hd__decap_12
XFILLER_3_279 VGND VGND VPWR VPWR sky130_fd_sc_hd__fill_1
XFILLER_0_920 VGND VGND VPWR VPWR sky130_fd_sc_hd__fill_1
XFILLER_94_507 VGND VGND VPWR VPWR sky130_fd_sc_hd__decap_4
XFILLER_121_689 VGND VGND VPWR VPWR sky130_fd_sc_hd__decap_6
XFILLER_120_177 VGND VGND VPWR VPWR sky130_fd_sc_hd__decap_4
X_10094_ _03783_ _03784_ _03843_ _03844_ VGND VGND VPWR VPWR _03846_ sky130_fd_sc_hd__and4_1
XFILLER_86_77 VGND VGND VPWR VPWR sky130_fd_sc_hd__decap_6
XFILLER_47_412 VPWR VGND VPWR VGND sky130_ef_sc_hd__decap_12
XTAP_TAPCELL_ROW_126_2350 VGND VPWR sky130_fd_sc_hd__tapvpwrvgnd_1
XFILLER_101_391 VGND VGND VPWR VPWR sky130_fd_sc_hd__fill_1
X_13922_ clknet_leaf_6_clk net899 VGND VGND VPWR VPWR u_interface.u_gelu_fp32.u_synth_top.s1_x\[26\]
+ sky130_fd_sc_hd__dfxtp_1
XFILLER_59_294 VGND VGND VPWR VPWR sky130_fd_sc_hd__fill_1
XFILLER_19_125 VPWR VGND VPWR VGND sky130_ef_sc_hd__decap_12
X_13853_ clknet_leaf_58_clk _00863_ VGND VGND VPWR VPWR u_interface.u_gelu_fp32.u_synth_top.s3_b\[9\]
+ sky130_fd_sc_hd__dfxtp_1
XFILLER_74_253 VGND VGND VPWR VPWR sky130_fd_sc_hd__fill_2
XFILLER_62_404 VGND VGND VPWR VPWR sky130_fd_sc_hd__decap_8
XFILLER_19_93 VPWR VGND VPWR VGND sky130_ef_sc_hd__decap_12
XFILLER_19_169 VPWR VGND VPWR VGND sky130_ef_sc_hd__decap_12
XFILLER_35_629 VPWR VGND VPWR VGND sky130_ef_sc_hd__decap_12
XFILLER_90_757 VGND VGND VPWR VPWR sky130_fd_sc_hd__fill_2
X_12804_ _01790_ net294 _06418_ VGND VGND VPWR VPWR _00962_ sky130_fd_sc_hd__and3b_1
XFILLER_28_681 VPWR VGND VPWR VGND sky130_ef_sc_hd__decap_12
X_13784_ clknet_leaf_85_clk _00794_ VGND VGND VPWR VPWR u_interface.u_gelu_fp32.s2_data\[18\]
+ sky130_fd_sc_hd__dfxtp_1
X_10996_ _04720_ _04738_ VGND VGND VPWR VPWR _04740_ sky130_fd_sc_hd__xnor2_1
X_12735_ u_interface.u_gelu_fp32.u_q16_to_fp32.s2_mag\[28\] u_interface.u_gelu_fp32.u_q16_to_fp32.s2_mag\[27\]
+ net336 VGND VGND VPWR VPWR _06385_ sky130_fd_sc_hd__mux2_1
XFILLER_42_172 VPWR VGND VPWR VGND sky130_ef_sc_hd__decap_12
X_12666_ u_interface.u_gelu_fp32.u_q16_to_fp32.s1_mag\[21\] net1701 net802 VGND VGND
+ VPWR VPWR _00902_ sky130_fd_sc_hd__mux2_1
XTAP_TAPCELL_ROW_13_543 VGND VPWR sky130_fd_sc_hd__tapvpwrvgnd_1
XFILLER_30_345 VPWR VGND VPWR VGND sky130_ef_sc_hd__decap_12
X_12597_ u_interface.u_gelu_fp32.u_q16_to_fp32.s1_mag\[14\] net211 VGND VGND VPWR
+ VPWR _06300_ sky130_fd_sc_hd__and2_1
X_11617_ _05347_ _05351_ _05352_ VGND VGND VPWR VPWR _05355_ sky130_fd_sc_hd__and3_1
XFILLER_128_233 VGND VGND VPWR VPWR sky130_fd_sc_hd__decap_8
XFILLER_7_541 VPWR VGND VPWR VGND sky130_ef_sc_hd__decap_12
X_11548_ _05254_ _05286_ VGND VGND VPWR VPWR _05287_ sky130_fd_sc_hd__xnor2_2
Xhold508 u_interface.fifo_data\[15\]\[28\] VGND VGND VPWR VPWR net1373 sky130_fd_sc_hd__dlygate4sd3_1
XFILLER_143_203 VGND VGND VPWR VPWR sky130_fd_sc_hd__decap_4
XFILLER_7_585 VPWR VGND VPWR VGND sky130_ef_sc_hd__decap_12
Xhold519 _01007_ VGND VGND VPWR VPWR net1384 sky130_fd_sc_hd__dlygate4sd3_1
X_11479_ _05140_ _05142_ net180 VGND VGND VPWR VPWR _05218_ sky130_fd_sc_hd__o21a_1
X_13218_ clknet_leaf_39_clk _00228_ VGND VGND VPWR VPWR u_interface.fifo_data\[12\]\[28\]
+ sky130_fd_sc_hd__dfxtp_1
XFILLER_112_601 VPWR VGND VPWR VGND sky130_ef_sc_hd__decap_12
XFILLER_98_813 VGND VGND VPWR VPWR sky130_fd_sc_hd__decap_4
X_13149_ clknet_leaf_36_clk _00159_ VGND VGND VPWR VPWR u_interface.fifo_tlast\[8\]
+ sky130_fd_sc_hd__dfxtp_1
XFILLER_112_645 VGND VGND VPWR VPWR sky130_fd_sc_hd__decap_6
XFILLER_97_345 VGND VGND VPWR VPWR sky130_fd_sc_hd__decap_4
X_07710_ net1771 _01428_ _00504_ VGND VGND VPWR VPWR _00508_ sky130_fd_sc_hd__or3_1
XFILLER_100_829 VGND VGND VPWR VPWR sky130_fd_sc_hd__fill_1
XFILLER_97_378 VGND VGND VPWR VPWR sky130_fd_sc_hd__fill_1
XFILLER_38_401 VPWR VGND VPWR VGND sky130_ef_sc_hd__decap_12
X_08690_ net663 net502 net508 net670 VGND VGND VPWR VPWR _02449_ sky130_fd_sc_hd__a22oi_1
XFILLER_65_231 VGND VGND VPWR VPWR sky130_fd_sc_hd__fill_1
X_07641_ net803 net1783 net298 _01728_ VGND VGND VPWR VPWR _00478_ sky130_fd_sc_hd__a22o_1
XTAP_TAPCELL_ROW_49_1116 VGND VPWR sky130_fd_sc_hd__tapvpwrvgnd_1
X_07572_ net311 _01560_ VGND VGND VPWR VPWR _01683_ sky130_fd_sc_hd__and2_1
XFILLER_53_437 VGND VGND VPWR VPWR sky130_fd_sc_hd__decap_8
XTAP_TAPCELL_ROW_49_1127 VGND VPWR sky130_fd_sc_hd__tapvpwrvgnd_1
X_06523_ u_interface.fifo_count\[4\] u_interface.in_flight_count\[4\] VGND VGND VPWR
+ VPWR _01123_ sky130_fd_sc_hd__nand2_1
X_09311_ _03066_ _03069_ VGND VGND VPWR VPWR _03070_ sky130_fd_sc_hd__nand2_1
XFILLER_18_191 VGND VGND VPWR VPWR sky130_fd_sc_hd__decap_4
XTAP_TAPCELL_ROW_62_1327 VGND VPWR sky130_fd_sc_hd__tapvpwrvgnd_1
XFILLER_22_813 VPWR VGND VPWR VGND sky130_ef_sc_hd__decap_12
XFILLER_40_109 VGND VGND VPWR VPWR sky130_fd_sc_hd__decap_8
X_09242_ _02914_ _02915_ _02959_ VGND VGND VPWR VPWR _03001_ sky130_fd_sc_hd__a21oi_1
XTAP_TAPCELL_ROW_32_841 VGND VPWR sky130_fd_sc_hd__tapvpwrvgnd_1
X_09173_ _02929_ _02930_ _02928_ VGND VGND VPWR VPWR _02932_ sky130_fd_sc_hd__o21bai_1
XFILLER_21_356 VPWR VGND VPWR VGND sky130_ef_sc_hd__decap_12
XTAP_TAPCELL_ROW_32_852 VGND VPWR sky130_fd_sc_hd__tapvpwrvgnd_1
X_08124_ net313 _01967_ _01966_ VGND VGND VPWR VPWR _01969_ sky130_fd_sc_hd__o21ai_1
XFILLER_31_39 VPWR VGND VPWR VGND sky130_ef_sc_hd__decap_12
XFILLER_147_39 VGND VGND VPWR VPWR sky130_fd_sc_hd__decap_6
XFILLER_107_417 VGND VGND VPWR VPWR sky130_fd_sc_hd__fill_1
X_08055_ net314 _01909_ VGND VGND VPWR VPWR _01911_ sky130_fd_sc_hd__nor2_1
XFILLER_150_707 VGND VGND VPWR VPWR sky130_fd_sc_hd__decap_8
X_07006_ net326 net1485 net284 VGND VGND VPWR VPWR _00052_ sky130_fd_sc_hd__mux2_1
XFILLER_131_910 VGND VGND VPWR VPWR sky130_fd_sc_hd__fill_2
XTAP_TAPCELL_ROW_77_1570 VGND VPWR sky130_fd_sc_hd__tapvpwrvgnd_1
XFILLER_89_857 VGND VGND VPWR VPWR sky130_fd_sc_hd__decap_4
Xinput106 s_axis_tlast VGND VGND VPWR VPWR net106 sky130_fd_sc_hd__clkbuf_1
XTAP_TAPCELL_ROW_90_1770 VGND VPWR sky130_fd_sc_hd__tapvpwrvgnd_1
XFILLER_88_356 VGND VGND VPWR VPWR sky130_fd_sc_hd__fill_2
XFILLER_0_249 VGND VGND VPWR VPWR sky130_fd_sc_hd__decap_3
X_08957_ _02715_ VGND VGND VPWR VPWR _02716_ sky130_fd_sc_hd__inv_2
XFILLER_130_475 VGND VGND VPWR VPWR sky130_fd_sc_hd__fill_1
XTAP_TAPCELL_ROW_90_1781 VGND VPWR sky130_fd_sc_hd__tapvpwrvgnd_1
X_07908_ net775 net92 VGND VGND VPWR VPWR _00667_ sky130_fd_sc_hd__and2_1
X_08888_ _02608_ _02610_ _02609_ VGND VGND VPWR VPWR _02647_ sky130_fd_sc_hd__a21bo_1
XFILLER_56_231 VPWR VGND VPWR VGND sky130_ef_sc_hd__decap_12
X_07839_ net374 net1521 net283 VGND VGND VPWR VPWR _00600_ sky130_fd_sc_hd__mux2_1
XFILLER_57_765 VGND VGND VPWR VPWR sky130_fd_sc_hd__fill_1
XFILLER_17_629 VPWR VGND VPWR VGND sky130_ef_sc_hd__decap_12
XFILLER_71_212 VPWR VGND VPWR VGND sky130_ef_sc_hd__decap_12
X_10850_ _04593_ _04594_ _04482_ _04485_ VGND VGND VPWR VPWR _04595_ sky130_fd_sc_hd__o211a_1
XFILLER_56_286 VGND VGND VPWR VPWR sky130_fd_sc_hd__fill_2
XFILLER_16_139 VGND VGND VPWR VPWR sky130_fd_sc_hd__fill_1
X_09509_ _03163_ _03263_ _03264_ VGND VGND VPWR VPWR _03266_ sky130_fd_sc_hd__nand3b_2
X_10781_ _04518_ _04524_ _04525_ VGND VGND VPWR VPWR _04527_ sky130_fd_sc_hd__nand3_1
XFILLER_25_673 VPWR VGND VPWR VGND sky130_ef_sc_hd__decap_12
X_12520_ net191 _06244_ VGND VGND VPWR VPWR _06245_ sky130_fd_sc_hd__xnor2_1
XFILLER_24_183 VGND VGND VPWR VPWR sky130_fd_sc_hd__decap_8
XFILLER_24_194 VGND VGND VPWR VPWR sky130_fd_sc_hd__fill_2
XFILLER_40_643 VGND VGND VPWR VPWR sky130_fd_sc_hd__fill_1
XPHY_EDGE_ROW_117_Right_117 VGND VGND VPWR VPWR sky130_fd_sc_hd__decap_3
XFILLER_9_839 VGND VGND VPWR VPWR sky130_fd_sc_hd__fill_1
X_12451_ _05934_ _06173_ _06174_ _05646_ _06177_ VGND VGND VPWR VPWR _06178_ sky130_fd_sc_hd__o221a_1
XFILLER_40_687 VGND VGND VPWR VPWR sky130_fd_sc_hd__decap_4
X_11402_ _05128_ _05141_ VGND VGND VPWR VPWR _05142_ sky130_fd_sc_hd__and2b_1
XTAP_TAPCELL_ROW_10_502 VGND VPWR sky130_fd_sc_hd__tapvpwrvgnd_1
XFILLER_8_349 VPWR VGND VPWR VGND sky130_ef_sc_hd__decap_12
X_14121_ clknet_leaf_31_clk _01047_ VGND VGND VPWR VPWR u_interface.fifo_rd_ptr\[2\]
+ sky130_fd_sc_hd__dfxtp_1
X_12382_ _06004_ _06045_ _06044_ VGND VGND VPWR VPWR _06110_ sky130_fd_sc_hd__o21a_1
XFILLER_125_225 VGND VGND VPWR VPWR sky130_fd_sc_hd__fill_1
XFILLER_4_533 VPWR VGND VPWR VGND sky130_ef_sc_hd__decap_12
X_11333_ _05064_ _05072_ VGND VGND VPWR VPWR _05074_ sky130_fd_sc_hd__and2_1
XFILLER_153_567 VGND VGND VPWR VPWR sky130_fd_sc_hd__fill_2
X_14052_ clknet_leaf_16_clk _00978_ VGND VGND VPWR VPWR u_interface.u_gelu_fp32.u_fp32_to_q16.s1_mant\[14\]
+ sky130_fd_sc_hd__dfxtp_1
XFILLER_125_258 VGND VGND VPWR VPWR sky130_fd_sc_hd__decap_8
X_11264_ _05004_ _05005_ VGND VGND VPWR VPWR _05006_ sky130_fd_sc_hd__nor2_1
XFILLER_97_54 VGND VGND VPWR VPWR sky130_fd_sc_hd__fill_2
X_10215_ _03963_ _03964_ VGND VGND VPWR VPWR _03966_ sky130_fd_sc_hd__xnor2_1
X_13003_ net964 net344 net222 VGND VGND VPWR VPWR _01086_ sky130_fd_sc_hd__mux2_1
XFILLER_97_98 VGND VGND VPWR VPWR sky130_fd_sc_hd__fill_1
X_11195_ _04928_ _04936_ VGND VGND VPWR VPWR _04937_ sky130_fd_sc_hd__xor2_1
X_10146_ _03893_ _03894_ _03895_ VGND VGND VPWR VPWR _03897_ sky130_fd_sc_hd__nand3_1
XFILLER_79_389 VGND VGND VPWR VPWR sky130_fd_sc_hd__decap_3
XFILLER_79_378 VGND VGND VPWR VPWR sky130_fd_sc_hd__decap_6
X_10077_ _03823_ _03826_ _03827_ VGND VGND VPWR VPWR _03829_ sky130_fd_sc_hd__nand3_1
XFILLER_47_220 VGND VGND VPWR VPWR sky130_fd_sc_hd__decap_4
X_13905_ clknet_leaf_2_clk net886 VGND VGND VPWR VPWR u_interface.u_gelu_fp32.u_synth_top.s1_x\[9\]
+ sky130_fd_sc_hd__dfxtp_1
XFILLER_48_765 VGND VGND VPWR VPWR sky130_fd_sc_hd__decap_8
XFILLER_63_735 VGND VGND VPWR VPWR sky130_fd_sc_hd__decap_4
XTAP_TAPCELL_ROW_18_624 VGND VPWR sky130_fd_sc_hd__tapvpwrvgnd_1
XFILLER_35_437 VGND VGND VPWR VPWR sky130_fd_sc_hd__decap_8
X_13836_ clknet_leaf_78_clk _00846_ VGND VGND VPWR VPWR u_interface.u_gelu_fp32.u_synth_top.s3_mult\[54\]
+ sky130_fd_sc_hd__dfxtp_1
X_13767_ clknet_leaf_54_clk _00777_ VGND VGND VPWR VPWR u_interface.u_gelu_fp32.s2_data\[1\]
+ sky130_fd_sc_hd__dfxtp_1
XFILLER_62_289 VGND VGND VPWR VPWR sky130_fd_sc_hd__decap_6
X_10979_ net686 net443 net438 net677 VGND VGND VPWR VPWR _04723_ sky130_fd_sc_hd__a22o_1
XFILLER_15_161 VGND VGND VPWR VPWR sky130_fd_sc_hd__decap_6
XFILLER_22_109 VPWR VGND VPWR VGND sky130_ef_sc_hd__decap_12
X_12718_ _06342_ _06371_ net306 VGND VGND VPWR VPWR _06372_ sky130_fd_sc_hd__mux2_1
XTAP_TAPCELL_ROW_44_1046 VGND VPWR sky130_fd_sc_hd__tapvpwrvgnd_1
XTAP_TAPCELL_ROW_44_1035 VGND VPWR sky130_fd_sc_hd__tapvpwrvgnd_1
XTAP_TAPCELL_ROW_139_2563 VGND VPWR sky130_fd_sc_hd__tapvpwrvgnd_1
X_13698_ clknet_leaf_18_clk _00708_ VGND VGND VPWR VPWR u_interface.u_gelu_fp32.u_fp32_to_q16.s3_sign
+ sky130_fd_sc_hd__dfxtp_1
XTAP_TAPCELL_ROW_139_2552 VGND VPWR sky130_fd_sc_hd__tapvpwrvgnd_1
XFILLER_31_665 VGND VGND VPWR VPWR sky130_fd_sc_hd__decap_6
XFILLER_129_553 VGND VGND VPWR VPWR sky130_fd_sc_hd__decap_6
X_12649_ u_interface.u_gelu_fp32.u_q16_to_fp32.s1_mag\[4\] net1673 net806 VGND VGND
+ VPWR VPWR _00885_ sky130_fd_sc_hd__mux2_1
XFILLER_30_197 VPWR VGND VPWR VGND sky130_ef_sc_hd__decap_12
XFILLER_129_586 VGND VGND VPWR VPWR sky130_fd_sc_hd__fill_2
XFILLER_117_704 VGND VGND VPWR VPWR sky130_fd_sc_hd__fill_1
XFILLER_8_861 VGND VGND VPWR VPWR sky130_fd_sc_hd__decap_6
XTAP_TAPCELL_ROW_152_2774 VGND VPWR sky130_fd_sc_hd__tapvpwrvgnd_1
XTAP_TAPCELL_ROW_152_2763 VGND VPWR sky130_fd_sc_hd__tapvpwrvgnd_1
XFILLER_144_545 VGND VGND VPWR VPWR sky130_fd_sc_hd__decap_4
XFILLER_144_523 VGND VGND VPWR VPWR sky130_fd_sc_hd__decap_8
Xhold316 u_interface.fifo_data\[10\]\[23\] VGND VGND VPWR VPWR net1181 sky130_fd_sc_hd__dlygate4sd3_1
Xhold305 u_interface.fifo_data\[4\]\[31\] VGND VGND VPWR VPWR net1170 sky130_fd_sc_hd__dlygate4sd3_1
XFILLER_7_393 VPWR VGND VPWR VGND sky130_ef_sc_hd__decap_12
Xhold349 u_interface.fifo_data\[0\]\[22\] VGND VGND VPWR VPWR net1214 sky130_fd_sc_hd__dlygate4sd3_1
XFILLER_132_707 VGND VGND VPWR VPWR sky130_fd_sc_hd__decap_3
Xhold338 u_interface.fifo_data\[0\]\[30\] VGND VGND VPWR VPWR net1203 sky130_fd_sc_hd__dlygate4sd3_1
Xhold327 u_interface.fifo_data\[1\]\[6\] VGND VGND VPWR VPWR net1192 sky130_fd_sc_hd__dlygate4sd3_1
XFILLER_131_217 VGND VGND VPWR VPWR sky130_fd_sc_hd__fill_1
X_09860_ _03578_ _03611_ _03612_ VGND VGND VPWR VPWR _03614_ sky130_fd_sc_hd__nand3_1
Xfanout807 net808 VGND VGND VPWR VPWR net807 sky130_fd_sc_hd__buf_2
Xfanout829 net830 VGND VGND VPWR VPWR net829 sky130_fd_sc_hd__clkbuf_2
Xfanout818 net822 VGND VGND VPWR VPWR net818 sky130_fd_sc_hd__buf_2
XFILLER_98_654 VGND VGND VPWR VPWR sky130_fd_sc_hd__decap_8
XFILLER_140_773 VGND VGND VPWR VPWR sky130_fd_sc_hd__decap_6
X_08811_ _02567_ _02568_ _02569_ VGND VGND VPWR VPWR _02570_ sky130_fd_sc_hd__or3_1
X_09791_ net486 net696 net705 net491 VGND VGND VPWR VPWR _03545_ sky130_fd_sc_hd__a22o_1
XFILLER_85_304 VGND VGND VPWR VPWR sky130_fd_sc_hd__decap_8
X_08742_ _02486_ _02499_ _02500_ VGND VGND VPWR VPWR _02501_ sky130_fd_sc_hd__and3_1
XFILLER_112_497 VPWR VGND VPWR VGND sky130_ef_sc_hd__decap_12
XFILLER_85_337 VGND VGND VPWR VPWR sky130_fd_sc_hd__decap_8
XFILLER_26_404 VPWR VGND VPWR VGND sky130_ef_sc_hd__decap_12
X_08673_ net156 _02434_ VGND VGND VPWR VPWR _02435_ sky130_fd_sc_hd__nand2_1
XFILLER_38_242 VGND VGND VPWR VPWR sky130_fd_sc_hd__decap_8
XFILLER_38_253 VGND VGND VPWR VPWR sky130_fd_sc_hd__decap_6
XFILLER_38_264 VGND VGND VPWR VPWR sky130_fd_sc_hd__decap_6
X_07624_ u_interface.u_gelu_fp32.u_q16_to_fp32.s2_mag\[5\] u_interface.u_gelu_fp32.u_q16_to_fp32.s2_mag\[4\]
+ u_interface.u_gelu_fp32.u_q16_to_fp32.s2_mag\[3\] u_interface.u_gelu_fp32.u_q16_to_fp32.s2_mag\[2\]
+ net339 net334 VGND VGND VPWR VPWR _01715_ sky130_fd_sc_hd__mux4_1
XFILLER_81_521 VPWR VGND VPWR VGND sky130_ef_sc_hd__decap_12
XFILLER_53_201 VGND VGND VPWR VPWR sky130_fd_sc_hd__fill_2
XTAP_TAPCELL_ROW_37_922 VGND VPWR sky130_fd_sc_hd__tapvpwrvgnd_1
XTAP_TAPCELL_ROW_37_933 VGND VPWR sky130_fd_sc_hd__tapvpwrvgnd_1
XFILLER_53_256 VGND VGND VPWR VPWR sky130_fd_sc_hd__decap_8
X_07555_ net812 net1727 net304 _01670_ VGND VGND VPWR VPWR _00450_ sky130_fd_sc_hd__a22o_1
XFILLER_53_278 VGND VGND VPWR VPWR sky130_fd_sc_hd__fill_2
XFILLER_41_429 VGND VGND VPWR VPWR sky130_fd_sc_hd__decap_3
X_07486_ _01618_ _01537_ net552 VGND VGND VPWR VPWR _01619_ sky130_fd_sc_hd__mux2_1
X_06506_ u_interface.u_gelu_fp32.s1_data\[16\] VGND VGND VPWR VPWR _01106_ sky130_fd_sc_hd__inv_2
XFILLER_22_643 VGND VGND VPWR VPWR sky130_fd_sc_hd__fill_1
X_09225_ _02924_ _02983_ VGND VGND VPWR VPWR _02984_ sky130_fd_sc_hd__nor2_1
XFILLER_10_805 VGND VGND VPWR VPWR sky130_fd_sc_hd__decap_6
XFILLER_42_27 VGND VGND VPWR VPWR sky130_fd_sc_hd__fill_1
XFILLER_10_849 VPWR VGND VPWR VGND sky130_ef_sc_hd__decap_12
XFILLER_154_309 VGND VGND VPWR VPWR sky130_fd_sc_hd__decap_8
X_09156_ _02912_ _02913_ _02869_ VGND VGND VPWR VPWR _02915_ sky130_fd_sc_hd__a21bo_1
XFILLER_135_512 VGND VGND VPWR VPWR sky130_fd_sc_hd__decap_4
X_09087_ _02843_ _02844_ _02841_ VGND VGND VPWR VPWR _02846_ sky130_fd_sc_hd__a21bo_1
X_08107_ net168 _01954_ net163 VGND VGND VPWR VPWR _01955_ sky130_fd_sc_hd__a21oi_1
XFILLER_107_214 VGND VGND VPWR VPWR sky130_fd_sc_hd__decap_8
XFILLER_123_729 VGND VGND VPWR VPWR sky130_fd_sc_hd__fill_2
X_08038_ u_interface.u_gelu_fp32.u_fp32_to_q16.s3_mag\[31\] _01894_ VGND VGND VPWR
+ VPWR _01895_ sky130_fd_sc_hd__xor2_1
XTAP_TAPCELL_ROW_92_1810 VGND VPWR sky130_fd_sc_hd__tapvpwrvgnd_1
XTAP_TAPCELL_ROW_75_1529 VGND VPWR sky130_fd_sc_hd__tapvpwrvgnd_1
Xhold850 u_interface.in_flight_count\[5\] VGND VGND VPWR VPWR net1715 sky130_fd_sc_hd__dlygate4sd3_1
XFILLER_150_515 VPWR VGND VPWR VGND sky130_ef_sc_hd__decap_12
Xhold861 u_interface.u_gelu_fp32.u_fp32_to_q16.s3_mag\[8\] VGND VGND VPWR VPWR net1726
+ sky130_fd_sc_hd__dlygate4sd3_1
Xhold872 u_interface.u_gelu_fp32.u_q16_to_fp32.s3_norm_mag\[28\] VGND VGND VPWR VPWR
+ net1737 sky130_fd_sc_hd__dlygate4sd3_1
XFILLER_1_503 VGND VGND VPWR VPWR sky130_fd_sc_hd__fill_1
XFILLER_131_751 VGND VGND VPWR VPWR sky130_fd_sc_hd__fill_1
XFILLER_107_64 VPWR VGND VPWR VGND sky130_ef_sc_hd__decap_12
Xhold883 u_interface.u_gelu_fp32.u_q16_to_fp32.s3_norm_mag\[20\] VGND VGND VPWR VPWR
+ net1748 sky130_fd_sc_hd__dlygate4sd3_1
Xhold894 u_interface.u_gelu_fp32.u_q16_to_fp32.s3_norm_mag\[7\] VGND VGND VPWR VPWR
+ net1759 sky130_fd_sc_hd__dlygate4sd3_1
X_10000_ net215 _03654_ _03750_ VGND VGND VPWR VPWR _03752_ sky130_fd_sc_hd__a21o_2
X_09989_ _03522_ _03629_ VGND VGND VPWR VPWR _03742_ sky130_fd_sc_hd__nand2_1
XFILLER_88_153 VPWR VGND VPWR VGND sky130_ef_sc_hd__decap_12
XFILLER_76_304 VGND VGND VPWR VPWR sky130_fd_sc_hd__decap_4
XFILLER_67_57 VGND VGND VPWR VPWR sky130_fd_sc_hd__decap_4
XFILLER_76_337 VGND VGND VPWR VPWR sky130_fd_sc_hd__decap_4
XTAP_TAPCELL_ROW_106_2028 VGND VPWR sky130_fd_sc_hd__tapvpwrvgnd_1
XFILLER_18_905 VPWR VGND VPWR VGND sky130_ef_sc_hd__decap_12
XFILLER_29_264 VPWR VGND VPWR VGND sky130_ef_sc_hd__decap_12
XTAP_TAPCELL_ROW_106_2039 VGND VPWR sky130_fd_sc_hd__tapvpwrvgnd_1
XTAP_TAPCELL_ROW_4_396 VGND VPWR sky130_fd_sc_hd__tapvpwrvgnd_1
X_11951_ net666 net389 VGND VGND VPWR VPWR _05685_ sky130_fd_sc_hd__nand2_1
X_10902_ _04644_ _04645_ _04646_ VGND VGND VPWR VPWR _04647_ sky130_fd_sc_hd__a21o_1
X_11882_ _05599_ _05616_ VGND VGND VPWR VPWR _05617_ sky130_fd_sc_hd__xnor2_1
XPHY_EDGE_ROW_103_Left_259 VGND VGND VPWR VPWR sky130_fd_sc_hd__decap_3
X_13621_ clknet_leaf_48_clk _00631_ VGND VGND VPWR VPWR u_interface.fifo_data\[13\]\[4\]
+ sky130_fd_sc_hd__dfxtp_1
X_10833_ _04471_ _04474_ VGND VGND VPWR VPWR _04578_ sky130_fd_sc_hd__nand2_1
XFILLER_44_289 VGND VGND VPWR VPWR sky130_fd_sc_hd__fill_1
X_10764_ net579 net396 VGND VGND VPWR VPWR _04510_ sky130_fd_sc_hd__nand2_1
X_13552_ clknet_leaf_76_clk _00562_ VGND VGND VPWR VPWR u_interface.fifo_data\[5\]\[31\]
+ sky130_fd_sc_hd__dfxtp_1
XFILLER_16_83 VGND VGND VPWR VPWR sky130_fd_sc_hd__fill_1
XTAP_TAPCELL_ROW_101_1950 VGND VPWR sky130_fd_sc_hd__tapvpwrvgnd_1
X_12503_ _06226_ _06227_ VGND VGND VPWR VPWR _06228_ sky130_fd_sc_hd__or2_1
XFILLER_12_153 VPWR VGND VPWR VGND sky130_ef_sc_hd__decap_12
XFILLER_13_665 VGND VGND VPWR VPWR sky130_fd_sc_hd__decap_6
X_13483_ clknet_leaf_4_clk _00493_ VGND VGND VPWR VPWR u_interface.u_gelu_fp32.u_synth_top.s2_b\[10\]
+ sky130_fd_sc_hd__dfxtp_1
X_10695_ net801 _04440_ _04441_ VGND VGND VPWR VPWR _00820_ sky130_fd_sc_hd__nor3_1
XFILLER_138_350 VGND VGND VPWR VPWR sky130_fd_sc_hd__fill_1
XFILLER_12_197 VPWR VGND VPWR VGND sky130_ef_sc_hd__decap_12
X_12434_ _06159_ _06158_ VGND VGND VPWR VPWR _06161_ sky130_fd_sc_hd__and2b_1
XFILLER_32_71 VPWR VGND VPWR VGND sky130_ef_sc_hd__decap_12
XFILLER_153_331 VGND VGND VPWR VPWR sky130_fd_sc_hd__decap_4
X_12365_ _05958_ _06028_ _06027_ VGND VGND VPWR VPWR _06093_ sky130_fd_sc_hd__a21oi_1
XFILLER_154_865 VGND VGND VPWR VPWR sky130_fd_sc_hd__decap_3
XTAP_TAPCELL_ROW_134_2482 VGND VPWR sky130_fd_sc_hd__tapvpwrvgnd_1
X_14104_ clknet_leaf_27_clk _01030_ VGND VGND VPWR VPWR u_interface.meta_tuser_pipe\[3\]
+ sky130_fd_sc_hd__dfxtp_1
XPHY_EDGE_ROW_112_Left_268 VGND VGND VPWR VPWR sky130_fd_sc_hd__decap_3
X_11316_ _05053_ _05054_ _05055_ VGND VGND VPWR VPWR _05057_ sky130_fd_sc_hd__nand3_1
XFILLER_5_853 VPWR VGND VPWR VGND sky130_ef_sc_hd__decap_12
X_14035_ clknet_leaf_71_clk _00961_ VGND VGND VPWR VPWR u_interface.core_data_out\[21\]
+ sky130_fd_sc_hd__dfxtp_1
X_12296_ _06023_ _06024_ VGND VGND VPWR VPWR _06025_ sky130_fd_sc_hd__xnor2_1
XFILLER_5_897 VPWR VGND VPWR VGND sky130_ef_sc_hd__decap_12
XFILLER_4_363 VGND VGND VPWR VPWR sky130_fd_sc_hd__fill_1
XFILLER_79_120 VGND VGND VPWR VPWR sky130_fd_sc_hd__fill_2
X_11247_ _04984_ _04988_ VGND VGND VPWR VPWR _04989_ sky130_fd_sc_hd__xnor2_1
XFILLER_122_773 VGND VGND VPWR VPWR sky130_fd_sc_hd__fill_2
XFILLER_79_164 VGND VGND VPWR VPWR sky130_fd_sc_hd__decap_4
X_11178_ _04803_ _04917_ VGND VGND VPWR VPWR _04920_ sky130_fd_sc_hd__nand2b_1
X_10129_ _03773_ _03776_ _03877_ _03878_ VGND VGND VPWR VPWR _03880_ sky130_fd_sc_hd__a211o_1
XFILLER_67_348 VGND VGND VPWR VPWR sky130_fd_sc_hd__decap_8
XFILLER_67_337 VGND VGND VPWR VPWR sky130_fd_sc_hd__fill_1
XFILLER_82_329 VGND VGND VPWR VPWR sky130_fd_sc_hd__fill_2
XFILLER_57_90 VGND VGND VPWR VPWR sky130_fd_sc_hd__decap_8
XPHY_EDGE_ROW_121_Left_277 VGND VGND VPWR VPWR sky130_fd_sc_hd__decap_3
XFILLER_91_841 VGND VGND VPWR VPWR sky130_fd_sc_hd__fill_1
XFILLER_35_223 VGND VGND VPWR VPWR sky130_fd_sc_hd__fill_1
XFILLER_90_384 VPWR VGND VPWR VGND sky130_ef_sc_hd__decap_12
X_13819_ clknet_leaf_81_clk _00829_ VGND VGND VPWR VPWR u_interface.u_gelu_fp32.u_synth_top.s3_mult\[37\]
+ sky130_fd_sc_hd__dfxtp_1
X_07340_ net374 net1513 net242 VGND VGND VPWR VPWR _00370_ sky130_fd_sc_hd__mux2_1
XFILLER_16_470 VGND VGND VPWR VPWR sky130_fd_sc_hd__decap_6
XTAP_TAPCELL_ROW_154_2803 VGND VPWR sky130_fd_sc_hd__tapvpwrvgnd_1
XFILLER_148_136 VGND VGND VPWR VPWR sky130_fd_sc_hd__decap_4
X_09010_ _02724_ _02726_ _02725_ VGND VGND VPWR VPWR _02769_ sky130_fd_sc_hd__o21ai_1
X_07271_ net1288 net385 net245 VGND VGND VPWR VPWR _00301_ sky130_fd_sc_hd__mux2_1
XPHY_EDGE_ROW_130_Left_286 VGND VGND VPWR VPWR sky130_fd_sc_hd__decap_3
Xhold124 u_interface.fifo_tlast\[4\] VGND VGND VPWR VPWR net989 sky130_fd_sc_hd__dlygate4sd3_1
XFILLER_117_556 VGND VGND VPWR VPWR sky130_fd_sc_hd__decap_4
Xhold102 u_interface.fifo_data\[12\]\[17\] VGND VGND VPWR VPWR net967 sky130_fd_sc_hd__dlygate4sd3_1
Xhold113 u_interface.u_gelu_fp32.s1_data\[17\] VGND VGND VPWR VPWR net978 sky130_fd_sc_hd__dlygate4sd3_1
Xhold135 u_interface.u_gelu_fp32.u_q16_to_fp32.s3_norm_mag\[6\] VGND VGND VPWR VPWR
+ net1000 sky130_fd_sc_hd__dlygate4sd3_1
Xhold146 u_interface.fifo_data\[2\]\[14\] VGND VGND VPWR VPWR net1011 sky130_fd_sc_hd__dlygate4sd3_1
XTAP_TAPCELL_ROW_57_1248 VGND VPWR sky130_fd_sc_hd__tapvpwrvgnd_1
Xhold157 u_interface.fifo_data\[5\]\[31\] VGND VGND VPWR VPWR net1022 sky130_fd_sc_hd__dlygate4sd3_1
Xhold168 u_interface.fifo_data\[8\]\[31\] VGND VGND VPWR VPWR net1033 sky130_fd_sc_hd__dlygate4sd3_1
XFILLER_144_29 VPWR VGND VPWR VGND sky130_ef_sc_hd__decap_12
Xfanout604 net605 VGND VGND VPWR VPWR net604 sky130_fd_sc_hd__buf_2
Xfanout615 net616 VGND VGND VPWR VPWR net615 sky130_fd_sc_hd__clkbuf_2
X_09912_ _03663_ _03664_ _03610_ VGND VGND VPWR VPWR _03665_ sky130_fd_sc_hd__a21oi_1
Xhold179 u_interface.fifo_data\[13\]\[20\] VGND VGND VPWR VPWR net1044 sky130_fd_sc_hd__dlygate4sd3_1
Xfanout637 net639 VGND VGND VPWR VPWR net637 sky130_fd_sc_hd__clkbuf_4
XFILLER_112_261 VGND VGND VPWR VPWR sky130_fd_sc_hd__fill_2
X_09843_ net454 net459 net620 net631 VGND VGND VPWR VPWR _03597_ sky130_fd_sc_hd__nand4_1
XFILLER_98_484 VPWR VGND VPWR VGND sky130_ef_sc_hd__decap_12
XFILLER_98_462 VGND VGND VPWR VPWR sky130_fd_sc_hd__decap_8
Xfanout648 net649 VGND VGND VPWR VPWR net648 sky130_fd_sc_hd__clkbuf_2
Xfanout626 net627 VGND VGND VPWR VPWR net626 sky130_fd_sc_hd__buf_2
XTAP_TAPCELL_ROW_70_1448 VGND VPWR sky130_fd_sc_hd__tapvpwrvgnd_1
XFILLER_112_294 VGND VGND VPWR VPWR sky130_fd_sc_hd__decap_4
XTAP_TAPCELL_ROW_70_1459 VGND VPWR sky130_fd_sc_hd__tapvpwrvgnd_1
Xfanout659 net661 VGND VGND VPWR VPWR net659 sky130_fd_sc_hd__buf_2
X_06986_ u_interface.fifo_wr_ptr\[3\] _01101_ VGND VGND VPWR VPWR _01509_ sky130_fd_sc_hd__nand2_1
X_09774_ net830 _03528_ VGND VGND VPWR VPWR _03529_ sky130_fd_sc_hd__nor2_1
XFILLER_67_871 VGND VGND VPWR VPWR sky130_fd_sc_hd__decap_6
XFILLER_37_27 VGND VGND VPWR VPWR sky130_fd_sc_hd__decap_6
X_08725_ _02482_ _02483_ VGND VGND VPWR VPWR _02484_ sky130_fd_sc_hd__and2b_1
XFILLER_100_489 VPWR VGND VPWR VGND sky130_ef_sc_hd__decap_12
XFILLER_67_893 VGND VGND VPWR VPWR sky130_fd_sc_hd__decap_3
XFILLER_39_595 VPWR VGND VPWR VGND sky130_ef_sc_hd__decap_12
XFILLER_66_392 VPWR VGND VPWR VGND sky130_ef_sc_hd__decap_12
X_08656_ net526 u_interface.u_gelu_fp32.u_synth_top.s3_mult\[40\] _02418_ VGND VGND
+ VPWR VPWR _02422_ sky130_fd_sc_hd__a21oi_1
XTAP_TAPCELL_ROW_1_344 VGND VPWR sky130_fd_sc_hd__tapvpwrvgnd_1
XTAP_TAPCELL_ROW_1_355 VGND VPWR sky130_fd_sc_hd__tapvpwrvgnd_1
X_08587_ net155 _02372_ net823 VGND VGND VPWR VPWR _00781_ sky130_fd_sc_hd__a21oi_1
X_07607_ net329 _01701_ VGND VGND VPWR VPWR _01702_ sky130_fd_sc_hd__nor2_1
XFILLER_53_15 VPWR VGND VPWR VGND sky130_ef_sc_hd__decap_12
XFILLER_14_418 VGND VGND VPWR VPWR sky130_fd_sc_hd__fill_2
X_07538_ net821 net1638 _01536_ _01636_ VGND VGND VPWR VPWR _00443_ sky130_fd_sc_hd__a22o_1
XTAP_TAPCELL_ROW_85_1691 VGND VPWR sky130_fd_sc_hd__tapvpwrvgnd_1
XFILLER_81_384 VGND VGND VPWR VPWR sky130_fd_sc_hd__decap_8
XFILLER_139_103 VGND VGND VPWR VPWR sky130_fd_sc_hd__decap_8
X_07469_ _01601_ _01602_ net550 VGND VGND VPWR VPWR _01603_ sky130_fd_sc_hd__mux2_1
XFILLER_139_125 VGND VGND VPWR VPWR sky130_fd_sc_hd__fill_2
XFILLER_10_613 VPWR VGND VPWR VGND sky130_ef_sc_hd__decap_12
XFILLER_155_629 VGND VGND VPWR VPWR sky130_fd_sc_hd__decap_4
X_09208_ _02928_ _02930_ _02929_ VGND VGND VPWR VPWR _02967_ sky130_fd_sc_hd__o21ai_1
XFILLER_139_169 VGND VGND VPWR VPWR sky130_fd_sc_hd__fill_2
XFILLER_136_810 VGND VGND VPWR VPWR sky130_fd_sc_hd__fill_2
X_10480_ net464 net700 net707 net468 VGND VGND VPWR VPWR _04228_ sky130_fd_sc_hd__a22oi_2
XFILLER_10_657 VPWR VGND VPWR VGND sky130_ef_sc_hd__decap_12
X_09139_ _02845_ _02884_ _02896_ VGND VGND VPWR VPWR _02898_ sky130_fd_sc_hd__a21o_1
XFILLER_5_105 VGND VGND VPWR VPWR sky130_fd_sc_hd__decap_6
XTAP_TAPCELL_ROW_20_652 VGND VPWR sky130_fd_sc_hd__tapvpwrvgnd_1
XTAP_TAPCELL_ROW_20_663 VGND VPWR sky130_fd_sc_hd__tapvpwrvgnd_1
XFILLER_108_545 VGND VGND VPWR VPWR sky130_fd_sc_hd__fill_1
XFILLER_5_149 VPWR VGND VPWR VGND sky130_ef_sc_hd__decap_12
X_12150_ _05879_ _05880_ VGND VGND VPWR VPWR _05881_ sky130_fd_sc_hd__nand2_1
XTAP_TAPCELL_ROW_116_2190 VGND VPWR sky130_fd_sc_hd__tapvpwrvgnd_1
X_11101_ _04835_ _04843_ VGND VGND VPWR VPWR _04844_ sky130_fd_sc_hd__xnor2_1
XFILLER_150_356 VGND VGND VPWR VPWR sky130_fd_sc_hd__fill_1
XFILLER_123_559 VGND VGND VPWR VPWR sky130_fd_sc_hd__fill_1
XFILLER_118_85 VGND VGND VPWR VPWR sky130_fd_sc_hd__decap_4
Xhold680 u_interface.fifo_data\[7\]\[27\] VGND VGND VPWR VPWR net1545 sky130_fd_sc_hd__dlygate4sd3_1
XTAP_TAPCELL_ROW_9_477 VGND VPWR sky130_fd_sc_hd__tapvpwrvgnd_1
XFILLER_2_867 VGND VGND VPWR VPWR sky130_fd_sc_hd__fill_1
X_12081_ _05811_ _05812_ VGND VGND VPWR VPWR _05813_ sky130_fd_sc_hd__and2b_1
Xhold691 u_interface.fifo_data\[11\]\[17\] VGND VGND VPWR VPWR net1556 sky130_fd_sc_hd__dlygate4sd3_1
XFILLER_103_261 VGND VGND VPWR VPWR sky130_fd_sc_hd__decap_4
XFILLER_77_602 VPWR VGND VPWR VGND sky130_ef_sc_hd__decap_12
X_11032_ _04648_ _04650_ VGND VGND VPWR VPWR _04776_ sky130_fd_sc_hd__nand2_1
XFILLER_49_337 VPWR VGND VPWR VGND sky130_ef_sc_hd__decap_12
XFILLER_77_668 VGND VGND VPWR VPWR sky130_fd_sc_hd__decap_4
XFILLER_65_808 VGND VGND VPWR VPWR sky130_fd_sc_hd__fill_1
XFILLER_64_307 VGND VGND VPWR VPWR sky130_fd_sc_hd__fill_1
XFILLER_94_77 VGND VGND VPWR VPWR sky130_fd_sc_hd__fill_2
XFILLER_64_318 VGND VGND VPWR VPWR sky130_fd_sc_hd__fill_1
X_12983_ net1419 net384 net221 VGND VGND VPWR VPWR _01066_ sky130_fd_sc_hd__mux2_1
XFILLER_17_212 VPWR VGND VPWR VGND sky130_ef_sc_hd__decap_12
XFILLER_18_713 VPWR VGND VPWR VGND sky130_ef_sc_hd__decap_12
XFILLER_91_148 VGND VGND VPWR VPWR sky130_fd_sc_hd__decap_3
XFILLER_73_841 VGND VGND VPWR VPWR sky130_fd_sc_hd__fill_2
XFILLER_18_757 VPWR VGND VPWR VGND sky130_ef_sc_hd__decap_12
X_11934_ _05600_ _05602_ _05601_ VGND VGND VPWR VPWR _05668_ sky130_fd_sc_hd__o21bai_1
XFILLER_150_83 VGND VGND VPWR VPWR sky130_fd_sc_hd__fill_1
XFILLER_17_267 VGND VGND VPWR VPWR sky130_fd_sc_hd__decap_4
XFILLER_27_93 VGND VGND VPWR VPWR sky130_fd_sc_hd__decap_8
XTAP_TAPCELL_ROW_28_785 VGND VPWR sky130_fd_sc_hd__tapvpwrvgnd_1
XFILLER_33_727 VGND VGND VPWR VPWR sky130_fd_sc_hd__fill_1
X_13604_ clknet_leaf_43_clk _00614_ VGND VGND VPWR VPWR u_interface.fifo_data\[3\]\[19\]
+ sky130_fd_sc_hd__dfxtp_1
X_11865_ net692 net406 VGND VGND VPWR VPWR _05600_ sky130_fd_sc_hd__nand2_1
XFILLER_32_226 VGND VGND VPWR VPWR sky130_fd_sc_hd__decap_4
X_10816_ _04560_ _04328_ VGND VGND VPWR VPWR _04561_ sky130_fd_sc_hd__nand2b_1
XFILLER_60_579 VGND VGND VPWR VPWR sky130_fd_sc_hd__fill_1
X_11796_ _05529_ _05530_ VGND VGND VPWR VPWR _05532_ sky130_fd_sc_hd__xnor2_1
XFILLER_32_259 VGND VGND VPWR VPWR sky130_fd_sc_hd__fill_1
XTAP_TAPCELL_ROW_136_2511 VGND VPWR sky130_fd_sc_hd__tapvpwrvgnd_1
X_13535_ clknet_leaf_43_clk _00545_ VGND VGND VPWR VPWR u_interface.fifo_data\[5\]\[14\]
+ sky130_fd_sc_hd__dfxtp_1
X_10747_ net660 net668 net443 net438 VGND VGND VPWR VPWR _04493_ sky130_fd_sc_hd__and4_1
XFILLER_41_793 VGND VGND VPWR VPWR sky130_fd_sc_hd__decap_8
X_10678_ _04423_ _04424_ _04220_ _04222_ VGND VGND VPWR VPWR _04425_ sky130_fd_sc_hd__o211ai_1
X_13466_ clknet_leaf_60_clk _00476_ VGND VGND VPWR VPWR u_interface.u_gelu_fp32.u_q16_to_fp32.s3_norm_mag\[6\]
+ sky130_fd_sc_hd__dfxtp_1
X_12417_ _06019_ _06143_ VGND VGND VPWR VPWR _06144_ sky130_fd_sc_hd__xor2_1
X_13397_ clknet_leaf_38_clk _00407_ VGND VGND VPWR VPWR u_interface.fifo_data\[6\]\[10\]
+ sky130_fd_sc_hd__dfxtp_1
XFILLER_154_673 VGND VGND VPWR VPWR sky130_fd_sc_hd__decap_3
X_12348_ net198 _06074_ VGND VGND VPWR VPWR _06076_ sky130_fd_sc_hd__nor2_1
XFILLER_99_237 VPWR VGND VPWR VGND sky130_ef_sc_hd__decap_12
X_12279_ net198 _06007_ VGND VGND VPWR VPWR _06008_ sky130_fd_sc_hd__and2_1
X_14018_ clknet_leaf_66_clk _00944_ VGND VGND VPWR VPWR u_interface.core_data_out\[4\]
+ sky130_fd_sc_hd__dfxtp_1
XFILLER_4_53 VPWR VGND VPWR VGND sky130_ef_sc_hd__decap_12
X_06840_ net736 _01386_ net727 VGND VGND VPWR VPWR _01389_ sky130_fd_sc_hd__o21a_1
XFILLER_122_581 VGND VGND VPWR VPWR sky130_fd_sc_hd__decap_6
XFILLER_68_635 VGND VGND VPWR VPWR sky130_fd_sc_hd__decap_8
XTAP_TAPCELL_ROW_52_1167 VGND VPWR sky130_fd_sc_hd__tapvpwrvgnd_1
XFILLER_4_97 VPWR VGND VPWR VGND sky130_ef_sc_hd__decap_12
XTAP_TAPCELL_ROW_147_2684 VGND VPWR sky130_fd_sc_hd__tapvpwrvgnd_1
XFILLER_110_765 VGND VGND VPWR VPWR sky130_fd_sc_hd__decap_4
XFILLER_95_443 VGND VGND VPWR VPWR sky130_fd_sc_hd__fill_1
XFILLER_83_605 VGND VGND VPWR VPWR sky130_fd_sc_hd__fill_1
XTAP_TAPCELL_ROW_147_2695 VGND VPWR sky130_fd_sc_hd__tapvpwrvgnd_1
X_06771_ _01327_ _01328_ net733 VGND VGND VPWR VPWR _01329_ sky130_fd_sc_hd__mux2_1
XFILLER_67_178 VGND VGND VPWR VPWR sky130_fd_sc_hd__decap_8
X_09490_ net486 net495 net671 net680 VGND VGND VPWR VPWR _03247_ sky130_fd_sc_hd__nand4_2
X_08510_ net524 u_interface.u_gelu_fp32.u_synth_top.s3_mult\[54\] VGND VGND VPWR VPWR
+ _02301_ sky130_fd_sc_hd__or2_1
X_08441_ _02191_ _02192_ _02228_ _02189_ _02188_ VGND VGND VPWR VPWR _02232_ sky130_fd_sc_hd__o311a_1
XFILLER_51_502 VGND VGND VPWR VPWR sky130_fd_sc_hd__fill_2
XFILLER_51_535 VGND VGND VPWR VPWR sky130_fd_sc_hd__decap_8
XFILLER_24_749 VGND VGND VPWR VPWR sky130_fd_sc_hd__decap_6
XFILLER_149_412 VGND VGND VPWR VPWR sky130_fd_sc_hd__decap_3
X_08372_ net521 u_interface.u_gelu_fp32.u_synth_top.s3_mult\[48\] VGND VGND VPWR VPWR
+ _02163_ sky130_fd_sc_hd__nand2_1
XFILLER_149_434 VPWR VGND VPWR VGND sky130_ef_sc_hd__decap_12
XFILLER_149_423 VGND VGND VPWR VPWR sky130_fd_sc_hd__decap_6
X_07323_ net1211 net344 net253 VGND VGND VPWR VPWR _00353_ sky130_fd_sc_hd__mux2_1
XFILLER_32_793 VPWR VGND VPWR VGND sky130_ef_sc_hd__decap_12
XFILLER_136_106 VGND VGND VPWR VPWR sky130_fd_sc_hd__decap_4
X_07254_ net1183 net348 net252 VGND VGND VPWR VPWR _00286_ sky130_fd_sc_hd__mux2_1
XFILLER_118_854 VGND VGND VPWR VPWR sky130_fd_sc_hd__decap_4
X_07185_ net1394 net574 net264 VGND VGND VPWR VPWR _00225_ sky130_fd_sc_hd__mux2_1
XFILLER_3_609 VGND VGND VPWR VPWR sky130_fd_sc_hd__decap_6
XFILLER_105_559 VGND VGND VPWR VPWR sky130_fd_sc_hd__fill_1
Xfanout423 u_interface.u_gelu_fp32.u_synth_top.s2_dx\[23\] VGND VGND VPWR VPWR net423
+ sky130_fd_sc_hd__dlymetal6s2s_1
Xfanout412 u_interface.u_gelu_fp32.u_synth_top.s2_dx\[25\] VGND VGND VPWR VPWR net412
+ sky130_fd_sc_hd__clkbuf_2
XFILLER_48_15 VGND VGND VPWR VPWR sky130_fd_sc_hd__decap_6
XTAP_TAPCELL_ROW_6_425 VGND VPWR sky130_fd_sc_hd__tapvpwrvgnd_1
Xfanout401 net402 VGND VGND VPWR VPWR net401 sky130_fd_sc_hd__clkbuf_2
XFILLER_113_581 VPWR VGND VPWR VGND sky130_ef_sc_hd__decap_12
XFILLER_86_421 VGND VGND VPWR VPWR sky130_fd_sc_hd__decap_4
Xfanout445 u_interface.u_gelu_fp32.u_synth_top.s2_dx\[18\] VGND VGND VPWR VPWR net445
+ sky130_fd_sc_hd__clkbuf_2
Xfanout456 net457 VGND VGND VPWR VPWR net456 sky130_fd_sc_hd__buf_2
Xfanout434 net437 VGND VGND VPWR VPWR net434 sky130_fd_sc_hd__clkbuf_2
XTAP_TAPCELL_ROW_6_436 VGND VPWR sky130_fd_sc_hd__tapvpwrvgnd_1
Xfanout489 net490 VGND VGND VPWR VPWR net489 sky130_fd_sc_hd__buf_2
Xfanout467 u_interface.u_gelu_fp32.u_synth_top.s2_dx\[13\] VGND VGND VPWR VPWR net467
+ sky130_fd_sc_hd__clkbuf_2
Xfanout478 u_interface.u_gelu_fp32.u_synth_top.s2_dx\[9\] VGND VGND VPWR VPWR net478
+ sky130_fd_sc_hd__buf_2
XFILLER_100_253 VPWR VGND VPWR VGND sky130_ef_sc_hd__decap_12
X_09826_ net475 net479 net672 net681 VGND VGND VPWR VPWR _03580_ sky130_fd_sc_hd__and4_1
XFILLER_74_616 VPWR VGND VPWR VGND sky130_ef_sc_hd__decap_12
X_09757_ _03509_ net173 _03366_ _03406_ VGND VGND VPWR VPWR _03512_ sky130_fd_sc_hd__o211ai_2
XFILLER_104_43 VGND VGND VPWR VPWR sky130_fd_sc_hd__decap_8
XTAP_TAPCELL_ROW_87_1720 VGND VPWR sky130_fd_sc_hd__tapvpwrvgnd_1
X_06969_ _01490_ _01492_ _01496_ VGND VGND VPWR VPWR _01497_ sky130_fd_sc_hd__a21oi_1
XFILLER_58_178 VPWR VGND VPWR VGND sky130_ef_sc_hd__decap_12
X_08708_ _02461_ _02465_ _02466_ VGND VGND VPWR VPWR _02467_ sky130_fd_sc_hd__and3_1
XFILLER_100_297 VGND VGND VPWR VPWR sky130_fd_sc_hd__fill_1
XTAP_TAPCELL_ROW_87_1731 VGND VPWR sky130_fd_sc_hd__tapvpwrvgnd_1
XFILLER_39_381 VGND VGND VPWR VPWR sky130_fd_sc_hd__fill_2
X_09688_ _03438_ _03439_ _03440_ VGND VGND VPWR VPWR _03443_ sky130_fd_sc_hd__and3_1
XFILLER_64_58 VGND VGND VPWR VPWR sky130_fd_sc_hd__fill_1
XFILLER_15_727 VGND VGND VPWR VPWR sky130_fd_sc_hd__fill_1
X_08639_ _02253_ _02256_ _02254_ VGND VGND VPWR VPWR _02409_ sky130_fd_sc_hd__a21oi_1
XTAP_TAPCELL_ROW_25_733 VGND VPWR sky130_fd_sc_hd__tapvpwrvgnd_1
XFILLER_147_3 VPWR VGND VPWR VGND sky130_ef_sc_hd__decap_12
X_11650_ _05319_ _05387_ VGND VGND VPWR VPWR _05388_ sky130_fd_sc_hd__xnor2_1
XFILLER_42_579 VGND VGND VPWR VPWR sky130_fd_sc_hd__decap_8
XFILLER_80_46 VGND VGND VPWR VPWR sky130_fd_sc_hd__decap_4
X_10601_ _04227_ _04230_ _04346_ _04347_ VGND VGND VPWR VPWR _04348_ sky130_fd_sc_hd__o211a_1
X_11581_ net185 _05318_ VGND VGND VPWR VPWR _05319_ sky130_fd_sc_hd__xor2_1
XTAP_TAPCELL_ROW_118_2230 VGND VPWR sky130_fd_sc_hd__tapvpwrvgnd_1
X_13320_ clknet_leaf_45_clk _00330_ VGND VGND VPWR VPWR u_interface.fifo_data\[8\]\[29\]
+ sky130_fd_sc_hd__dfxtp_1
X_10532_ net579 net587 net408 net405 VGND VGND VPWR VPWR _04280_ sky130_fd_sc_hd__nand4_1
XFILLER_10_421 VPWR VGND VPWR VGND sky130_ef_sc_hd__decap_12
XFILLER_13_51 VGND VGND VPWR VPWR sky130_fd_sc_hd__decap_4
XFILLER_155_426 VGND VGND VPWR VPWR sky130_fd_sc_hd__decap_4
XFILLER_127_117 VGND VGND VPWR VPWR sky130_fd_sc_hd__fill_1
XFILLER_10_465 VGND VGND VPWR VPWR sky130_fd_sc_hd__decap_8
X_13251_ clknet_leaf_45_clk _00261_ VGND VGND VPWR VPWR u_interface.fifo_data\[11\]\[29\]
+ sky130_fd_sc_hd__dfxtp_1
XFILLER_89_11 VGND VGND VPWR VPWR sky130_fd_sc_hd__fill_1
X_10463_ _04209_ _04210_ _04205_ VGND VGND VPWR VPWR _04211_ sky130_fd_sc_hd__a21o_1
XFILLER_142_109 VGND VGND VPWR VPWR sky130_fd_sc_hd__fill_2
XTAP_TAPCELL_ROW_131_2430 VGND VPWR sky130_fd_sc_hd__tapvpwrvgnd_1
X_13182_ clknet_leaf_47_clk _00192_ VGND VGND VPWR VPWR u_interface.fifo_data\[9\]\[24\]
+ sky130_fd_sc_hd__dfxtp_1
X_10394_ net603 net423 VGND VGND VPWR VPWR _04143_ sky130_fd_sc_hd__nand2_1
X_12202_ _05791_ _05792_ _05862_ VGND VGND VPWR VPWR _05933_ sky130_fd_sc_hd__or3_1
XFILLER_151_632 VGND VGND VPWR VPWR sky130_fd_sc_hd__fill_1
XFILLER_123_345 VPWR VGND VPWR VGND sky130_ef_sc_hd__decap_12
XFILLER_89_77 VGND VGND VPWR VPWR sky130_fd_sc_hd__decap_6
X_12133_ _05791_ _05792_ _05798_ VGND VGND VPWR VPWR _05865_ sky130_fd_sc_hd__o21ba_1
X_12064_ _05646_ _05796_ _05794_ VGND VGND VPWR VPWR _05797_ sky130_fd_sc_hd__o21a_1
XFILLER_150_197 VGND VGND VPWR VPWR sky130_fd_sc_hd__fill_2
XFILLER_89_281 VGND VGND VPWR VPWR sky130_fd_sc_hd__decap_3
XFILLER_77_410 VPWR VGND VPWR VGND sky130_ef_sc_hd__decap_12
X_11015_ net586 net392 _04758_ VGND VGND VPWR VPWR _04759_ sky130_fd_sc_hd__and3_1
XFILLER_77_454 VGND VGND VPWR VPWR sky130_fd_sc_hd__decap_3
XTAP_TAPCELL_ROW_129_2392 VGND VPWR sky130_fd_sc_hd__tapvpwrvgnd_1
XFILLER_64_137 VGND VGND VPWR VPWR sky130_fd_sc_hd__decap_3
XFILLER_46_852 VGND VGND VPWR VPWR sky130_fd_sc_hd__fill_1
X_12966_ _06483_ _06484_ VGND VGND VPWR VPWR _06485_ sky130_fd_sc_hd__xnor2_1
XFILLER_46_885 VGND VGND VPWR VPWR sky130_fd_sc_hd__decap_3
X_12897_ net786 net926 VGND VGND VPWR VPWR _01039_ sky130_fd_sc_hd__and2_1
XFILLER_60_321 VGND VGND VPWR VPWR sky130_fd_sc_hd__fill_1
XFILLER_33_524 VGND VGND VPWR VPWR sky130_fd_sc_hd__fill_2
X_11917_ net179 _05572_ _05575_ VGND VGND VPWR VPWR _05651_ sky130_fd_sc_hd__nor3_1
XFILLER_60_365 VPWR VGND VPWR VGND sky130_ef_sc_hd__decap_12
XFILLER_60_354 VGND VGND VPWR VPWR sky130_fd_sc_hd__decap_8
XFILLER_60_343 VGND VGND VPWR VPWR sky130_fd_sc_hd__fill_2
X_11848_ _05579_ net204 VGND VGND VPWR VPWR _05583_ sky130_fd_sc_hd__xor2_1
XFILLER_14_793 VPWR VGND VPWR VGND sky130_ef_sc_hd__decap_12
XFILLER_119_629 VGND VGND VPWR VPWR sky130_fd_sc_hd__decap_4
X_13518_ clknet_leaf_44_clk _00528_ VGND VGND VPWR VPWR u_interface.core_data_out\[29\]
+ sky130_fd_sc_hd__dfxtp_1
XFILLER_13_281 VGND VGND VPWR VPWR sky130_fd_sc_hd__decap_3
X_11779_ net710 net420 VGND VGND VPWR VPWR _05515_ sky130_fd_sc_hd__nand2_1
XFILLER_118_139 VGND VGND VPWR VPWR sky130_fd_sc_hd__fill_1
Xclkload33 clknet_leaf_19_clk VGND VGND VPWR VPWR clkload33/Y sky130_fd_sc_hd__inv_8
X_13449_ clknet_leaf_9_clk _00459_ VGND VGND VPWR VPWR u_interface.u_gelu_fp32.u_fp32_to_q16.s3_mag\[20\]
+ sky130_fd_sc_hd__dfxtp_1
Xclkload22 clknet_leaf_7_clk VGND VGND VPWR VPWR clkload22/Y sky130_fd_sc_hd__inv_6
Xclkload11 clknet_leaf_90_clk VGND VGND VPWR VPWR clkload11/Y sky130_fd_sc_hd__inv_8
XFILLER_62_3 VPWR VGND VPWR VGND sky130_ef_sc_hd__decap_12
Xclkload44 clknet_leaf_77_clk VGND VGND VPWR VPWR clkload44/Y sky130_fd_sc_hd__inv_12
Xclkload66 clknet_leaf_30_clk VGND VGND VPWR VPWR clkload66/Y sky130_fd_sc_hd__clkinv_8
Xclkload77 clknet_leaf_40_clk VGND VGND VPWR VPWR clkload77/Y sky130_fd_sc_hd__inv_6
XFILLER_127_673 VGND VGND VPWR VPWR sky130_fd_sc_hd__decap_3
XFILLER_115_813 VGND VGND VPWR VPWR sky130_fd_sc_hd__decap_6
Xclkload55 clknet_leaf_64_clk VGND VGND VPWR VPWR clkload55/Y sky130_fd_sc_hd__inv_8
XFILLER_126_172 VGND VGND VPWR VPWR sky130_fd_sc_hd__fill_1
XTAP_TAPCELL_ROW_54_1207 VGND VPWR sky130_fd_sc_hd__tapvpwrvgnd_1
XTAP_TAPCELL_ROW_149_2724 VGND VPWR sky130_fd_sc_hd__tapvpwrvgnd_1
XTAP_TAPCELL_ROW_149_2713 VGND VPWR sky130_fd_sc_hd__tapvpwrvgnd_1
X_08990_ _02748_ _02738_ VGND VGND VPWR VPWR _02749_ sky130_fd_sc_hd__and2b_1
XFILLER_88_719 VGND VGND VPWR VPWR sky130_fd_sc_hd__fill_1
X_07941_ _01811_ _01816_ _01831_ _01825_ net775 VGND VGND VPWR VPWR _01832_ sky130_fd_sc_hd__o311a_1
XFILLER_130_838 VGND VGND VPWR VPWR sky130_fd_sc_hd__fill_1
XFILLER_68_421 VGND VGND VPWR VPWR sky130_fd_sc_hd__fill_1
XFILLER_56_605 VGND VGND VPWR VPWR sky130_fd_sc_hd__decap_6
X_07872_ net980 net372 net265 VGND VGND VPWR VPWR _00633_ sky130_fd_sc_hd__mux2_1
X_09611_ net510 net714 _03233_ _03232_ VGND VGND VPWR VPWR _03367_ sky130_fd_sc_hd__a31oi_1
X_06823_ u_interface.fifo_data\[12\]\[24\] u_interface.fifo_data\[13\]\[24\] u_interface.fifo_data\[14\]\[24\]
+ u_interface.fifo_data\[15\]\[24\] net765 net748 VGND VGND VPWR VPWR _01374_ sky130_fd_sc_hd__mux4_1
XFILLER_18_29 VPWR VGND VPWR VGND sky130_ef_sc_hd__decap_12
XFILLER_28_307 VGND VGND VPWR VPWR sky130_fd_sc_hd__fill_1
X_09542_ _03281_ _03297_ VGND VGND VPWR VPWR _03299_ sky130_fd_sc_hd__and2_1
X_06754_ u_interface.fifo_data\[4\]\[15\] u_interface.fifo_data\[5\]\[15\] u_interface.fifo_data\[6\]\[15\]
+ u_interface.fifo_data\[7\]\[15\] net762 net745 VGND VGND VPWR VPWR _01314_ sky130_fd_sc_hd__mux4_1
XFILLER_83_457 VGND VGND VPWR VPWR sky130_fd_sc_hd__fill_2
XFILLER_83_446 VGND VGND VPWR VPWR sky130_fd_sc_hd__fill_2
X_06685_ u_interface.fifo_data\[12\]\[7\] u_interface.fifo_data\[13\]\[7\] u_interface.fifo_data\[14\]\[7\]
+ u_interface.fifo_data\[15\]\[7\] net770 net753 VGND VGND VPWR VPWR _01253_ sky130_fd_sc_hd__mux4_1
X_09473_ net724 _03172_ _03229_ VGND VGND VPWR VPWR _03230_ sky130_fd_sc_hd__and3_1
Xclkbuf_leaf_90_clk clknet_3_0__leaf_clk VGND VGND VPWR VPWR clknet_leaf_90_clk sky130_fd_sc_hd__clkbuf_8
XFILLER_24_524 VGND VGND VPWR VPWR sky130_fd_sc_hd__fill_1
X_08424_ u_interface.u_gelu_fp32.u_synth_top.s3_mult\[16\] u_interface.u_gelu_fp32.u_synth_top.s3_b\[0\]
+ _02212_ _02211_ VGND VGND VPWR VPWR _02215_ sky130_fd_sc_hd__a31o_1
XTAP_TAPCELL_ROW_82_1650 VGND VPWR sky130_fd_sc_hd__tapvpwrvgnd_1
XTAP_TAPCELL_ROW_65_1369 VGND VPWR sky130_fd_sc_hd__tapvpwrvgnd_1
X_08355_ u_interface.u_gelu_fp32.s2_data\[28\] _02146_ VGND VGND VPWR VPWR _02149_
+ sky130_fd_sc_hd__or2_1
XFILLER_149_253 VGND VGND VPWR VPWR sky130_fd_sc_hd__decap_8
Xclkload5 clknet_3_5__leaf_clk VGND VGND VPWR VPWR clkload5/Y sky130_fd_sc_hd__clkinvlp_4
X_07306_ net1004 net378 net253 VGND VGND VPWR VPWR _00336_ sky130_fd_sc_hd__mux2_1
XFILLER_137_426 VGND VGND VPWR VPWR sky130_fd_sc_hd__decap_3
X_08286_ _02096_ _02097_ VGND VGND VPWR VPWR _00755_ sky130_fd_sc_hd__nor2_1
XFILLER_50_38 VPWR VGND VPWR VGND sky130_ef_sc_hd__decap_12
XFILLER_50_27 VGND VGND VPWR VPWR sky130_fd_sc_hd__fill_1
X_07237_ net1085 net383 net252 VGND VGND VPWR VPWR _00269_ sky130_fd_sc_hd__mux2_1
XFILLER_3_417 VPWR VGND VPWR VGND sky130_ef_sc_hd__decap_12
X_07168_ net1341 net368 net261 VGND VGND VPWR VPWR _00208_ sky130_fd_sc_hd__mux2_1
XFILLER_105_312 VGND VGND VPWR VPWR sky130_fd_sc_hd__fill_1
X_07099_ net1340 net348 net228 VGND VGND VPWR VPWR _00139_ sky130_fd_sc_hd__mux2_1
XFILLER_59_36 VGND VGND VPWR VPWR sky130_fd_sc_hd__fill_2
Xfanout220 _01526_ VGND VGND VPWR VPWR net220 sky130_fd_sc_hd__clkbuf_4
Xfanout231 net232 VGND VGND VPWR VPWR net231 sky130_fd_sc_hd__buf_4
XFILLER_132_197 VGND VGND VPWR VPWR sky130_fd_sc_hd__fill_1
Xfanout264 _01507_ VGND VGND VPWR VPWR net264 sky130_fd_sc_hd__buf_4
Xfanout242 _01516_ VGND VGND VPWR VPWR net242 sky130_fd_sc_hd__clkbuf_4
Xfanout253 net254 VGND VGND VPWR VPWR net253 sky130_fd_sc_hd__buf_4
XFILLER_59_454 VGND VGND VPWR VPWR sky130_fd_sc_hd__decap_6
X_09809_ _03461_ _03560_ _03561_ VGND VGND VPWR VPWR _03563_ sky130_fd_sc_hd__and3_1
Xfanout297 _01792_ VGND VGND VPWR VPWR net297 sky130_fd_sc_hd__clkbuf_2
Xfanout275 net276 VGND VGND VPWR VPWR net275 sky130_fd_sc_hd__clkbuf_4
XFILLER_74_413 VGND VGND VPWR VPWR sky130_fd_sc_hd__decap_6
X_12820_ net777 net79 VGND VGND VPWR VPWR _00978_ sky130_fd_sc_hd__and2_1
XFILLER_62_608 VGND VGND VPWR VPWR sky130_fd_sc_hd__decap_4
XFILLER_55_671 VGND VGND VPWR VPWR sky130_fd_sc_hd__fill_1
XFILLER_27_351 VGND VGND VPWR VPWR sky130_fd_sc_hd__decap_8
X_12751_ net1579 u_interface.u_gelu_fp32.u_q16_to_fp32.s3_exp\[3\] net825 VGND VGND
+ VPWR VPWR _00933_ sky130_fd_sc_hd__mux2_1
X_12682_ u_interface.u_gelu_fp32.u_q16_to_fp32.s2_clz\[4\] net772 net306 VGND VGND
+ VPWR VPWR _06344_ sky130_fd_sc_hd__and3_1
XFILLER_70_641 VGND VGND VPWR VPWR sky130_fd_sc_hd__decap_3
Xclkbuf_leaf_81_clk clknet_3_4__leaf_clk VGND VGND VPWR VPWR clknet_leaf_81_clk sky130_fd_sc_hd__clkbuf_8
X_11702_ net676 net406 VGND VGND VPWR VPWR _05439_ sky130_fd_sc_hd__nand2_1
X_11633_ _05368_ _05369_ VGND VGND VPWR VPWR _05371_ sky130_fd_sc_hd__xor2_1
XFILLER_11_741 VPWR VGND VPWR VGND sky130_ef_sc_hd__decap_12
XFILLER_24_83 VGND VGND VPWR VPWR sky130_fd_sc_hd__fill_1
XFILLER_155_223 VGND VGND VPWR VPWR sky130_fd_sc_hd__fill_1
X_11564_ _05300_ _05301_ VGND VGND VPWR VPWR _05303_ sky130_fd_sc_hd__xor2_1
XFILLER_11_785 VPWR VGND VPWR VGND sky130_ef_sc_hd__decap_12
X_13303_ clknet_leaf_65_clk _00313_ VGND VGND VPWR VPWR u_interface.fifo_data\[8\]\[12\]
+ sky130_fd_sc_hd__dfxtp_1
X_10515_ _04259_ _04262_ VGND VGND VPWR VPWR _04263_ sky130_fd_sc_hd__xnor2_1
XFILLER_6_233 VPWR VGND VPWR VGND sky130_ef_sc_hd__decap_12
X_11495_ _05221_ _05232_ VGND VGND VPWR VPWR _05234_ sky130_fd_sc_hd__nand2_1
XFILLER_143_418 VGND VGND VPWR VPWR sky130_fd_sc_hd__fill_2
X_10446_ _03965_ _04078_ _04080_ VGND VGND VPWR VPWR _04195_ sky130_fd_sc_hd__o21a_1
X_13234_ clknet_leaf_65_clk _00244_ VGND VGND VPWR VPWR u_interface.fifo_data\[11\]\[12\]
+ sky130_fd_sc_hd__dfxtp_1
XFILLER_40_60 VPWR VGND VPWR VGND sky130_ef_sc_hd__decap_12
XFILLER_124_621 VPWR VGND VPWR VGND sky130_ef_sc_hd__decap_12
XFILLER_6_299 VGND VGND VPWR VPWR sky130_fd_sc_hd__decap_8
XFILLER_6_288 VGND VGND VPWR VPWR sky130_fd_sc_hd__decap_8
XFILLER_123_153 VGND VGND VPWR VPWR sky130_fd_sc_hd__decap_4
X_13165_ clknet_leaf_45_clk _00175_ VGND VGND VPWR VPWR u_interface.fifo_data\[9\]\[7\]
+ sky130_fd_sc_hd__dfxtp_1
XFILLER_97_505 VGND VGND VPWR VPWR sky130_fd_sc_hd__decap_8
X_10377_ net453 net660 net669 net457 VGND VGND VPWR VPWR _04126_ sky130_fd_sc_hd__a22o_1
XFILLER_123_197 VGND VGND VPWR VPWR sky130_fd_sc_hd__decap_6
X_13096_ clknet_leaf_53_clk _00106_ VGND VGND VPWR VPWR u_interface.fifo_data\[15\]\[17\]
+ sky130_fd_sc_hd__dfxtp_1
X_12116_ _05845_ _05846_ VGND VGND VPWR VPWR _05848_ sky130_fd_sc_hd__xnor2_1
XFILLER_66_914 VGND VGND VPWR VPWR sky130_fd_sc_hd__decap_3
X_12047_ _05777_ _05778_ VGND VGND VPWR VPWR _05780_ sky130_fd_sc_hd__xnor2_1
XTAP_TAPCELL_ROW_144_2632 VGND VPWR sky130_fd_sc_hd__tapvpwrvgnd_1
XFILLER_77_251 VGND VGND VPWR VPWR sky130_fd_sc_hd__fill_2
XTAP_TAPCELL_ROW_144_2643 VGND VPWR sky130_fd_sc_hd__tapvpwrvgnd_1
XFILLER_19_841 VPWR VGND VPWR VGND sky130_ef_sc_hd__decap_12
XFILLER_38_649 VGND VGND VPWR VPWR sky130_fd_sc_hd__fill_1
XFILLER_92_265 VGND VGND VPWR VPWR sky130_fd_sc_hd__fill_2
X_13998_ clknet_leaf_60_clk _00924_ VGND VGND VPWR VPWR u_interface.u_gelu_fp32.u_q16_to_fp32.s3_norm_mag\[25\]
+ sky130_fd_sc_hd__dfxtp_1
X_12949_ u_interface.fifo_count\[1\] _06467_ VGND VGND VPWR VPWR _06470_ sky130_fd_sc_hd__nor2_1
XFILLER_92_287 VGND VGND VPWR VPWR sky130_fd_sc_hd__fill_2
XFILLER_80_449 VGND VGND VPWR VPWR sky130_fd_sc_hd__fill_1
Xclkbuf_leaf_72_clk clknet_3_5__leaf_clk VGND VGND VPWR VPWR clknet_leaf_72_clk sky130_fd_sc_hd__clkbuf_8
XFILLER_33_354 VPWR VGND VPWR VGND sky130_ef_sc_hd__decap_12
XTAP_TAPCELL_ROW_47_1088 VGND VPWR sky130_fd_sc_hd__tapvpwrvgnd_1
X_08140_ u_interface.u_gelu_fp32.u_fp32_to_q16.s3_mag\[15\] _01883_ VGND VGND VPWR
+ VPWR _01982_ sky130_fd_sc_hd__xnor2_1
XTAP_TAPCELL_ROW_16_585 VGND VPWR sky130_fd_sc_hd__tapvpwrvgnd_1
XTAP_TAPCELL_ROW_16_596 VGND VPWR sky130_fd_sc_hd__tapvpwrvgnd_1
X_08071_ net292 _01924_ VGND VGND VPWR VPWR _00713_ sky130_fd_sc_hd__nor2_1
XTAP_TAPCELL_ROW_60_1299 VGND VPWR sky130_fd_sc_hd__tapvpwrvgnd_1
XTAP_TAPCELL_ROW_60_1288 VGND VPWR sky130_fd_sc_hd__tapvpwrvgnd_1
XFILLER_146_278 VGND VGND VPWR VPWR sky130_fd_sc_hd__decap_8
XFILLER_134_429 VGND VGND VPWR VPWR sky130_fd_sc_hd__fill_2
XFILLER_106_109 VGND VGND VPWR VPWR sky130_fd_sc_hd__decap_8
X_07022_ net1212 net374 net269 VGND VGND VPWR VPWR _00062_ sky130_fd_sc_hd__mux2_1
XFILLER_155_790 VGND VGND VPWR VPWR sky130_fd_sc_hd__decap_4
XFILLER_127_481 VGND VGND VPWR VPWR sky130_fd_sc_hd__decap_4
X_08973_ _02573_ _02714_ _02713_ VGND VGND VPWR VPWR _02732_ sky130_fd_sc_hd__a21o_1
X_07924_ u_interface.u_gelu_fp32.u_fp32_to_q16.s1_mant\[9\] u_interface.u_gelu_fp32.u_fp32_to_q16.s1_mant\[8\]
+ u_interface.u_gelu_fp32.u_fp32_to_q16.s1_mant\[11\] u_interface.u_gelu_fp32.u_fp32_to_q16.s1_mant\[10\]
+ VGND VGND VPWR VPWR _01818_ sky130_fd_sc_hd__or4_1
XFILLER_152_18 VGND VGND VPWR VPWR sky130_fd_sc_hd__decap_8
Xhold17 u_interface.u_gelu_fp32.s1_data\[11\] VGND VGND VPWR VPWR net882 sky130_fd_sc_hd__dlygate4sd3_1
XFILLER_114_197 VGND VGND VPWR VPWR sky130_fd_sc_hd__fill_1
Xhold28 u_interface.u_gelu_fp32.s1_data\[12\] VGND VGND VPWR VPWR net893 sky130_fd_sc_hd__dlygate4sd3_1
XFILLER_29_39 VPWR VGND VPWR VGND sky130_ef_sc_hd__decap_12
XFILLER_152_29 VPWR VGND VPWR VGND sky130_ef_sc_hd__decap_12
Xhold39 u_interface.u_gelu_fp32.s1_data\[30\] VGND VGND VPWR VPWR net904 sky130_fd_sc_hd__dlygate4sd3_1
XFILLER_110_392 VGND VGND VPWR VPWR sky130_fd_sc_hd__fill_2
X_07855_ net343 net1439 net282 VGND VGND VPWR VPWR _00616_ sky130_fd_sc_hd__mux2_1
X_06806_ u_interface.fifo_data\[8\]\[22\] u_interface.fifo_data\[9\]\[22\] u_interface.fifo_data\[10\]\[22\]
+ u_interface.fifo_data\[11\]\[22\] net768 net751 VGND VGND VPWR VPWR _01359_ sky130_fd_sc_hd__mux4_1
X_07786_ net1074 net352 net235 VGND VGND VPWR VPWR _00547_ sky130_fd_sc_hd__mux2_1
XFILLER_84_788 VGND VGND VPWR VPWR sky130_fd_sc_hd__fill_1
XTAP_TAPCELL_ROW_67_1409 VGND VPWR sky130_fd_sc_hd__tapvpwrvgnd_1
X_06737_ u_interface.fifo_data\[0\]\[13\] u_interface.fifo_data\[1\]\[13\] u_interface.fifo_data\[2\]\[13\]
+ u_interface.fifo_data\[3\]\[13\] net767 net750 VGND VGND VPWR VPWR _01299_ sky130_fd_sc_hd__mux4_1
X_09525_ net483 net662 VGND VGND VPWR VPWR _03282_ sky130_fd_sc_hd__nand2_1
XFILLER_71_449 VGND VGND VPWR VPWR sky130_fd_sc_hd__decap_4
XFILLER_25_833 VGND VGND VPWR VPWR sky130_fd_sc_hd__decap_6
X_09456_ _03212_ _03213_ _02699_ _02702_ VGND VGND VPWR VPWR _03214_ sky130_fd_sc_hd__a211o_1
X_06668_ _01234_ _01235_ _01238_ net317 VGND VGND VPWR VPWR net135 sky130_fd_sc_hd__a22o_1
XTAP_TAPCELL_ROW_80_1609 VGND VPWR sky130_fd_sc_hd__tapvpwrvgnd_1
Xclkbuf_leaf_63_clk clknet_3_5__leaf_clk VGND VGND VPWR VPWR clknet_leaf_63_clk sky130_fd_sc_hd__clkbuf_8
XFILLER_25_877 VPWR VGND VPWR VGND sky130_ef_sc_hd__decap_12
X_08407_ _02196_ _02197_ VGND VGND VPWR VPWR _02198_ sky130_fd_sc_hd__nand2_1
XFILLER_61_15 VPWR VGND VPWR VGND sky130_ef_sc_hd__decap_12
XFILLER_52_696 VGND VGND VPWR VPWR sky130_fd_sc_hd__decap_4
XFILLER_12_527 VGND VGND VPWR VPWR sky130_fd_sc_hd__decap_4
XFILLER_24_365 VPWR VGND VPWR VGND sky130_ef_sc_hd__decap_12
X_09387_ _02642_ _02644_ _02643_ VGND VGND VPWR VPWR _03145_ sky130_fd_sc_hd__a21bo_1
X_06599_ _01180_ u_interface.u_gelu_fp32.s1_data\[16\] _01166_ VGND VGND VPWR VPWR
+ _01181_ sky130_fd_sc_hd__or3b_1
XTAP_TAPCELL_ROW_35_894 VGND VPWR sky130_fd_sc_hd__tapvpwrvgnd_1
X_08338_ _02135_ _02136_ VGND VGND VPWR VPWR _00768_ sky130_fd_sc_hd__nor2_1
X_08269_ net534 u_interface.u_gelu_fp32.s2_data\[7\] _02083_ net805 VGND VGND VPWR
+ VPWR _02085_ sky130_fd_sc_hd__a31o_1
XFILLER_153_738 VPWR VGND VPWR VGND sky130_ef_sc_hd__decap_12
X_10300_ net610 net432 net427 net603 VGND VGND VPWR VPWR _04050_ sky130_fd_sc_hd__a22o_1
X_11280_ _04914_ _05021_ VGND VGND VPWR VPWR _05022_ sky130_fd_sc_hd__xnor2_1
XTAP_TAPCELL_ROW_111_2119 VGND VPWR sky130_fd_sc_hd__tapvpwrvgnd_1
XTAP_TAPCELL_ROW_111_2108 VGND VPWR sky130_fd_sc_hd__tapvpwrvgnd_1
XTAP_TAPCELL_ROW_95_1863 VGND VPWR sky130_fd_sc_hd__tapvpwrvgnd_1
XTAP_TAPCELL_ROW_95_1852 VGND VPWR sky130_fd_sc_hd__tapvpwrvgnd_1
X_10231_ net277 _03869_ _03980_ VGND VGND VPWR VPWR _03981_ sky130_fd_sc_hd__a21o_1
XFILLER_4_737 VPWR VGND VPWR VGND sky130_ef_sc_hd__decap_12
XFILLER_3_225 VPWR VGND VPWR VGND sky130_ef_sc_hd__decap_12
XFILLER_106_654 VGND VGND VPWR VPWR sky130_fd_sc_hd__fill_2
XFILLER_79_505 VGND VGND VPWR VPWR sky130_fd_sc_hd__fill_1
XFILLER_10_41 VPWR VGND VPWR VGND sky130_ef_sc_hd__decap_12
XFILLER_106_687 VPWR VGND VPWR VGND sky130_ef_sc_hd__decap_12
XFILLER_105_186 VGND VGND VPWR VPWR sky130_fd_sc_hd__decap_3
X_10162_ _03904_ _03910_ _03911_ VGND VGND VPWR VPWR _03913_ sky130_fd_sc_hd__nand3_1
XFILLER_10_85 VPWR VGND VPWR VGND sky130_ef_sc_hd__decap_12
XFILLER_126_85 VGND VGND VPWR VPWR sky130_fd_sc_hd__fill_1
XFILLER_105_197 VGND VGND VPWR VPWR sky130_fd_sc_hd__decap_6
X_10093_ _03783_ _03784_ _03843_ _03844_ VGND VGND VPWR VPWR _03845_ sky130_fd_sc_hd__a22oi_2
X_13921_ clknet_leaf_6_clk net903 VGND VGND VPWR VPWR u_interface.u_gelu_fp32.u_synth_top.s1_x\[25\]
+ sky130_fd_sc_hd__dfxtp_1
XTAP_TAPCELL_ROW_126_2351 VGND VPWR sky130_fd_sc_hd__tapvpwrvgnd_1
XFILLER_47_424 VGND VGND VPWR VPWR sky130_fd_sc_hd__decap_4
XFILLER_19_137 VGND VGND VPWR VPWR sky130_fd_sc_hd__decap_4
X_13852_ clknet_leaf_23_clk _00862_ VGND VGND VPWR VPWR u_interface.u_gelu_fp32.u_synth_top.s3_b\[8\]
+ sky130_fd_sc_hd__dfxtp_1
XFILLER_47_468 VGND VGND VPWR VPWR sky130_fd_sc_hd__fill_1
X_12803_ u_interface.u_gelu_fp32.u_q16_to_fp32.s3_norm_mag\[29\] u_interface.u_gelu_fp32.u_q16_to_fp32.s3_norm_mag\[28\]
+ _01788_ u_interface.u_gelu_fp32.u_q16_to_fp32.s3_norm_mag\[30\] VGND VGND VPWR VPWR
+ _06418_ sky130_fd_sc_hd__a31o_1
X_13783_ clknet_leaf_85_clk _00793_ VGND VGND VPWR VPWR u_interface.u_gelu_fp32.s2_data\[17\]
+ sky130_fd_sc_hd__dfxtp_1
XFILLER_15_310 VGND VGND VPWR VPWR sky130_fd_sc_hd__decap_8
XFILLER_16_811 VGND VGND VPWR VPWR sky130_fd_sc_hd__fill_1
XFILLER_28_693 VGND VGND VPWR VPWR sky130_fd_sc_hd__decap_6
Xclkbuf_leaf_54_clk clknet_3_1__leaf_clk VGND VGND VPWR VPWR clknet_leaf_54_clk sky130_fd_sc_hd__clkbuf_8
X_12734_ net808 net1687 _01737_ net288 _06384_ VGND VGND VPWR VPWR _00926_ sky130_fd_sc_hd__a221o_1
X_10995_ _04720_ _04736_ _04737_ VGND VGND VPWR VPWR _04739_ sky130_fd_sc_hd__or3b_1
XFILLER_15_343 VPWR VGND VPWR VGND sky130_ef_sc_hd__decap_12
XFILLER_27_181 VPWR VGND VPWR VGND sky130_ef_sc_hd__decap_12
XTAP_TAPCELL_ROW_104_1992 VGND VPWR sky130_fd_sc_hd__tapvpwrvgnd_1
XFILLER_70_493 VGND VGND VPWR VPWR sky130_fd_sc_hd__decap_3
X_12665_ u_interface.u_gelu_fp32.u_q16_to_fp32.s1_mag\[20\] net1697 net802 VGND VGND
+ VPWR VPWR _00901_ sky130_fd_sc_hd__mux2_1
XFILLER_30_324 VGND VGND VPWR VPWR sky130_fd_sc_hd__fill_2
XFILLER_42_184 VGND VGND VPWR VPWR sky130_fd_sc_hd__decap_3
X_12596_ u_interface.u_gelu_fp32.u_q16_to_fp32.s1_mag\[9\] u_interface.u_gelu_fp32.u_q16_to_fp32.s1_mag\[8\]
+ u_interface.u_gelu_fp32.u_q16_to_fp32.s1_mag\[10\] u_interface.u_gelu_fp32.u_q16_to_fp32.s1_mag\[11\]
+ VGND VGND VPWR VPWR _06299_ sky130_fd_sc_hd__or4_1
XTAP_TAPCELL_ROW_13_544 VGND VPWR sky130_fd_sc_hd__tapvpwrvgnd_1
XFILLER_30_357 VGND VGND VPWR VPWR sky130_fd_sc_hd__decap_6
X_11616_ _05351_ _05352_ _05347_ VGND VGND VPWR VPWR _05354_ sky130_fd_sc_hd__a21o_1
X_11547_ _05283_ _05284_ VGND VGND VPWR VPWR _05286_ sky130_fd_sc_hd__xnor2_2
Xhold509 u_interface.fifo_data\[0\]\[5\] VGND VGND VPWR VPWR net1374 sky130_fd_sc_hd__dlygate4sd3_1
XFILLER_7_553 VGND VGND VPWR VPWR sky130_fd_sc_hd__decap_6
X_11478_ net180 _05140_ _05142_ VGND VGND VPWR VPWR _05217_ sky130_fd_sc_hd__nor3_1
XFILLER_7_597 VPWR VGND VPWR VGND sky130_ef_sc_hd__decap_12
X_13217_ clknet_leaf_67_clk _00227_ VGND VGND VPWR VPWR u_interface.fifo_data\[12\]\[27\]
+ sky130_fd_sc_hd__dfxtp_1
X_10429_ _04140_ _04141_ _04175_ _04176_ VGND VGND VPWR VPWR _04178_ sky130_fd_sc_hd__nand4_2
XFILLER_152_782 VGND VGND VPWR VPWR sky130_fd_sc_hd__decap_4
X_13148_ clknet_leaf_34_clk _00158_ VGND VGND VPWR VPWR u_interface.fifo_tlast\[0\]
+ sky130_fd_sc_hd__dfxtp_1
XFILLER_112_613 VPWR VGND VPWR VGND sky130_ef_sc_hd__decap_12
XFILLER_97_313 VGND VGND VPWR VPWR sky130_fd_sc_hd__decap_3
XFILLER_151_281 VPWR VGND VPWR VGND sky130_ef_sc_hd__decap_12
XFILLER_98_869 VGND VGND VPWR VPWR sky130_fd_sc_hd__fill_1
XFILLER_97_357 VGND VGND VPWR VPWR sky130_fd_sc_hd__fill_2
X_13079_ clknet_leaf_62_clk _00089_ VGND VGND VPWR VPWR u_interface.fifo_data\[15\]\[0\]
+ sky130_fd_sc_hd__dfxtp_1
XFILLER_25_3 VPWR VGND VPWR VGND sky130_ef_sc_hd__decap_12
XFILLER_38_413 VGND VGND VPWR VPWR sky130_fd_sc_hd__decap_6
X_07640_ _01699_ _01727_ net307 VGND VGND VPWR VPWR _01728_ sky130_fd_sc_hd__mux2_1
XTAP_TAPCELL_ROW_49_1117 VGND VPWR sky130_fd_sc_hd__tapvpwrvgnd_1
X_07571_ net811 net1770 net304 _01682_ VGND VGND VPWR VPWR _00454_ sky130_fd_sc_hd__a22o_1
XFILLER_81_725 VGND VGND VPWR VPWR sky130_fd_sc_hd__decap_3
XFILLER_19_671 VGND VGND VPWR VPWR sky130_fd_sc_hd__fill_1
X_06522_ _01116_ _01121_ VGND VGND VPWR VPWR _01122_ sky130_fd_sc_hd__and2_1
X_09310_ _03063_ _03065_ VGND VGND VPWR VPWR _03069_ sky130_fd_sc_hd__or2_1
Xclkbuf_leaf_45_clk clknet_3_7__leaf_clk VGND VGND VPWR VPWR clknet_leaf_45_clk sky130_fd_sc_hd__clkbuf_8
XFILLER_80_246 VGND VGND VPWR VPWR sky130_fd_sc_hd__fill_1
XFILLER_53_449 VPWR VGND VPWR VGND sky130_ef_sc_hd__decap_12
XFILLER_80_279 VPWR VGND VPWR VGND sky130_ef_sc_hd__decap_12
XTAP_TAPCELL_ROW_62_1328 VGND VPWR sky130_fd_sc_hd__tapvpwrvgnd_1
XFILLER_22_825 VPWR VGND VPWR VGND sky130_ef_sc_hd__decap_12
X_09241_ _02960_ _02999_ VGND VGND VPWR VPWR _03000_ sky130_fd_sc_hd__nand2_1
XFILLER_22_869 VPWR VGND VPWR VGND sky130_ef_sc_hd__decap_12
XTAP_TAPCELL_ROW_32_842 VGND VPWR sky130_fd_sc_hd__tapvpwrvgnd_1
XFILLER_147_510 VPWR VGND VPWR VGND sky130_ef_sc_hd__decap_12
X_09172_ _02928_ _02929_ _02930_ VGND VGND VPWR VPWR _02931_ sky130_fd_sc_hd__or3_1
XFILLER_119_201 VPWR VGND VPWR VGND sky130_ef_sc_hd__decap_12
XFILLER_21_368 VPWR VGND VPWR VGND sky130_ef_sc_hd__decap_12
XTAP_TAPCELL_ROW_32_853 VGND VPWR sky130_fd_sc_hd__tapvpwrvgnd_1
X_08123_ net314 _01966_ _01967_ VGND VGND VPWR VPWR _01968_ sky130_fd_sc_hd__or3_1
XFILLER_108_919 VGND VGND VPWR VPWR sky130_fd_sc_hd__fill_2
X_08054_ net291 _01910_ VGND VGND VPWR VPWR _00710_ sky130_fd_sc_hd__nor2_1
X_07005_ net827 _01508_ _01512_ VGND VGND VPWR VPWR _01520_ sky130_fd_sc_hd__or3_2
XFILLER_115_440 VGND VGND VPWR VPWR sky130_fd_sc_hd__fill_2
XTAP_TAPCELL_ROW_77_1571 VGND VPWR sky130_fd_sc_hd__tapvpwrvgnd_1
XTAP_TAPCELL_ROW_77_1560 VGND VPWR sky130_fd_sc_hd__tapvpwrvgnd_1
XFILLER_143_793 VGND VGND VPWR VPWR sky130_fd_sc_hd__fill_1
XFILLER_142_270 VGND VGND VPWR VPWR sky130_fd_sc_hd__decap_8
XFILLER_115_484 VGND VGND VPWR VPWR sky130_fd_sc_hd__decap_3
XFILLER_1_729 VPWR VGND VPWR VGND sky130_ef_sc_hd__decap_12
Xinput107 s_axis_tuser VGND VGND VPWR VPWR net107 sky130_fd_sc_hd__clkbuf_1
XFILLER_130_421 VPWR VGND VPWR VGND sky130_ef_sc_hd__decap_12
XTAP_TAPCELL_ROW_90_1771 VGND VPWR sky130_fd_sc_hd__tapvpwrvgnd_1
XFILLER_88_346 VGND VGND VPWR VPWR sky130_fd_sc_hd__decap_4
XFILLER_88_335 VGND VGND VPWR VPWR sky130_fd_sc_hd__decap_3
X_08956_ _02573_ _02713_ _02714_ VGND VGND VPWR VPWR _02715_ sky130_fd_sc_hd__nand3_1
XTAP_TAPCELL_ROW_90_1782 VGND VPWR sky130_fd_sc_hd__tapvpwrvgnd_1
X_07907_ net775 net91 VGND VGND VPWR VPWR _00666_ sky130_fd_sc_hd__and2_1
X_08887_ _02642_ _02643_ _02644_ VGND VGND VPWR VPWR _02646_ sky130_fd_sc_hd__nand3_1
XFILLER_56_15 VGND VGND VPWR VPWR sky130_fd_sc_hd__decap_6
XTAP_TAPCELL_ROW_108_2070 VGND VPWR sky130_fd_sc_hd__tapvpwrvgnd_1
X_07838_ net376 net1496 net283 VGND VGND VPWR VPWR _00599_ sky130_fd_sc_hd__mux2_1
XFILLER_84_541 VGND VGND VPWR VPWR sky130_fd_sc_hd__decap_3
XFILLER_56_243 VGND VGND VPWR VPWR sky130_fd_sc_hd__decap_4
XPHY_EDGE_ROW_16_Left_172 VGND VGND VPWR VPWR sky130_fd_sc_hd__decap_3
XFILLER_29_479 VGND VGND VPWR VPWR sky130_fd_sc_hd__fill_1
XFILLER_112_32 VPWR VGND VPWR VGND sky130_ef_sc_hd__decap_12
Xclkbuf_leaf_36_clk clknet_3_6__leaf_clk VGND VGND VPWR VPWR clknet_leaf_36_clk sky130_fd_sc_hd__clkbuf_8
X_09508_ _03263_ _03264_ _03163_ VGND VGND VPWR VPWR _03265_ sky130_fd_sc_hd__a21bo_1
X_07769_ net1542 net297 VGND VGND VPWR VPWR _00530_ sky130_fd_sc_hd__and2_1
XFILLER_25_641 VPWR VGND VPWR VGND sky130_ef_sc_hd__decap_12
XTAP_TAPCELL_ROW_121_2270 VGND VPWR sky130_fd_sc_hd__tapvpwrvgnd_1
XFILLER_71_268 VPWR VGND VPWR VGND sky130_ef_sc_hd__decap_12
X_10780_ _04524_ _04525_ _04518_ VGND VGND VPWR VPWR _04526_ sky130_fd_sc_hd__a21o_1
XFILLER_25_685 VPWR VGND VPWR VGND sky130_ef_sc_hd__decap_12
X_09439_ _03188_ _03194_ _03195_ VGND VGND VPWR VPWR _03197_ sky130_fd_sc_hd__nand3_1
X_12450_ _06120_ _06175_ _06176_ VGND VGND VPWR VPWR _06177_ sky130_fd_sc_hd__and3b_1
X_11401_ _05129_ _05139_ VGND VGND VPWR VPWR _05141_ sky130_fd_sc_hd__xnor2_1
XTAP_TAPCELL_ROW_10_503 VGND VPWR sky130_fd_sc_hd__tapvpwrvgnd_1
XPHY_EDGE_ROW_25_Left_181 VGND VGND VPWR VPWR sky130_fd_sc_hd__decap_3
XFILLER_40_699 VGND VGND VPWR VPWR sky130_fd_sc_hd__fill_1
X_14120_ clknet_leaf_31_clk _01046_ VGND VGND VPWR VPWR u_interface.fifo_rd_ptr\[1\]
+ sky130_fd_sc_hd__dfxtp_1
XFILLER_4_501 VPWR VGND VPWR VGND sky130_ef_sc_hd__decap_12
X_12381_ _06071_ _06107_ VGND VGND VPWR VPWR _06109_ sky130_fd_sc_hd__xor2_1
XFILLER_21_51 VGND VGND VPWR VPWR sky130_fd_sc_hd__decap_4
X_11332_ _05064_ _05072_ VGND VGND VPWR VPWR _05073_ sky130_fd_sc_hd__nor2_1
XFILLER_153_579 VGND VGND VPWR VPWR sky130_fd_sc_hd__fill_1
X_14051_ clknet_leaf_16_clk _00977_ VGND VGND VPWR VPWR u_interface.u_gelu_fp32.u_fp32_to_q16.s1_mant\[13\]
+ sky130_fd_sc_hd__dfxtp_1
X_11263_ _04830_ _04888_ _04887_ VGND VGND VPWR VPWR _05005_ sky130_fd_sc_hd__a21o_1
XFILLER_4_545 VPWR VGND VPWR VGND sky130_ef_sc_hd__decap_12
X_13002_ net1353 net346 net223 VGND VGND VPWR VPWR _01085_ sky130_fd_sc_hd__mux2_1
X_10214_ _03964_ _03963_ VGND VGND VPWR VPWR _03965_ sky130_fd_sc_hd__nand2b_1
X_11194_ _04929_ _04933_ VGND VGND VPWR VPWR _04936_ sky130_fd_sc_hd__xnor2_1
XFILLER_4_589 VPWR VGND VPWR VGND sky130_ef_sc_hd__decap_12
X_10145_ _03894_ _03895_ _03893_ VGND VGND VPWR VPWR _03896_ sky130_fd_sc_hd__a21o_1
XFILLER_95_839 VGND VGND VPWR VPWR sky130_fd_sc_hd__fill_1
XFILLER_94_305 VGND VGND VPWR VPWR sky130_fd_sc_hd__decap_3
XFILLER_94_327 VGND VGND VPWR VPWR sky130_fd_sc_hd__decap_4
X_10076_ _03826_ _03827_ _03823_ VGND VGND VPWR VPWR _03828_ sky130_fd_sc_hd__a21o_1
XFILLER_48_755 VGND VGND VPWR VPWR sky130_fd_sc_hd__fill_1
XPHY_EDGE_ROW_34_Left_190 VGND VGND VPWR VPWR sky130_fd_sc_hd__decap_3
X_13904_ clknet_leaf_22_clk net892 VGND VGND VPWR VPWR u_interface.u_gelu_fp32.u_synth_top.s1_x\[8\]
+ sky130_fd_sc_hd__dfxtp_1
XFILLER_47_265 VGND VGND VPWR VPWR sky130_fd_sc_hd__decap_3
XFILLER_47_298 VGND VGND VPWR VPWR sky130_fd_sc_hd__decap_3
XTAP_TAPCELL_ROW_18_625 VGND VPWR sky130_fd_sc_hd__tapvpwrvgnd_1
X_13835_ clknet_leaf_78_clk _00845_ VGND VGND VPWR VPWR u_interface.u_gelu_fp32.u_synth_top.s3_mult\[53\]
+ sky130_fd_sc_hd__dfxtp_1
Xclkbuf_leaf_27_clk clknet_3_3__leaf_clk VGND VGND VPWR VPWR clknet_leaf_27_clk sky130_fd_sc_hd__clkbuf_8
XFILLER_90_544 VGND VGND VPWR VPWR sky130_fd_sc_hd__fill_2
XFILLER_35_449 VGND VGND VPWR VPWR sky130_fd_sc_hd__decap_8
X_13766_ clknet_leaf_54_clk _00776_ VGND VGND VPWR VPWR u_interface.u_gelu_fp32.s2_data\[0\]
+ sky130_fd_sc_hd__dfxtp_1
X_10978_ net677 net686 net443 net438 VGND VGND VPWR VPWR _04722_ sky130_fd_sc_hd__and4_1
X_13697_ clknet_leaf_13_clk net1218 VGND VGND VPWR VPWR u_interface.u_gelu_fp32.u_fp32_to_q16.s3_is_zero
+ sky130_fd_sc_hd__dfxtp_1
X_12717_ _06370_ _06364_ _06356_ _06349_ net332 net328 VGND VGND VPWR VPWR _06371_
+ sky130_fd_sc_hd__mux4_1
XTAP_TAPCELL_ROW_44_1047 VGND VPWR sky130_fd_sc_hd__tapvpwrvgnd_1
XTAP_TAPCELL_ROW_44_1036 VGND VPWR sky130_fd_sc_hd__tapvpwrvgnd_1
XFILLER_148_329 VGND VGND VPWR VPWR sky130_fd_sc_hd__decap_3
XTAP_TAPCELL_ROW_139_2564 VGND VPWR sky130_fd_sc_hd__tapvpwrvgnd_1
XTAP_TAPCELL_ROW_139_2553 VGND VPWR sky130_fd_sc_hd__tapvpwrvgnd_1
X_12648_ net1704 u_interface.u_gelu_fp32.u_q16_to_fp32.s2_mag\[3\] net806 VGND VGND
+ VPWR VPWR _00884_ sky130_fd_sc_hd__mux2_1
X_12579_ net23 net27 net26 _06282_ VGND VGND VPWR VPWR _06283_ sky130_fd_sc_hd__or4_2
XFILLER_117_727 VGND VGND VPWR VPWR sky130_fd_sc_hd__fill_1
XFILLER_11_390 VGND VGND VPWR VPWR sky130_fd_sc_hd__fill_2
XTAP_TAPCELL_ROW_152_2775 VGND VPWR sky130_fd_sc_hd__tapvpwrvgnd_1
XTAP_TAPCELL_ROW_152_2764 VGND VPWR sky130_fd_sc_hd__tapvpwrvgnd_1
XFILLER_116_215 VGND VGND VPWR VPWR sky130_fd_sc_hd__fill_1
Xhold317 u_interface.fifo_data\[9\]\[29\] VGND VGND VPWR VPWR net1182 sky130_fd_sc_hd__dlygate4sd3_1
Xhold306 u_interface.fifo_data\[10\]\[0\] VGND VGND VPWR VPWR net1171 sky130_fd_sc_hd__dlygate4sd3_1
XFILLER_7_383 VGND VGND VPWR VPWR sky130_fd_sc_hd__fill_1
Xhold339 u_interface.fifo_data\[10\]\[15\] VGND VGND VPWR VPWR net1204 sky130_fd_sc_hd__dlygate4sd3_1
Xhold328 u_interface.fifo_data\[8\]\[2\] VGND VGND VPWR VPWR net1193 sky130_fd_sc_hd__dlygate4sd3_1
Xfanout819 net820 VGND VGND VPWR VPWR net819 sky130_fd_sc_hd__clkbuf_4
X_08810_ net613 net488 net493 net622 VGND VGND VPWR VPWR _02569_ sky130_fd_sc_hd__a22oi_1
XFILLER_97_110 VGND VGND VPWR VPWR sky130_fd_sc_hd__fill_2
Xfanout808 net809 VGND VGND VPWR VPWR net808 sky130_fd_sc_hd__buf_2
X_09790_ net486 net491 net696 net705 VGND VGND VPWR VPWR _03544_ sky130_fd_sc_hd__nand4_2
XFILLER_98_699 VGND VGND VPWR VPWR sky130_fd_sc_hd__fill_1
X_08741_ _02491_ _02497_ _02498_ VGND VGND VPWR VPWR _02500_ sky130_fd_sc_hd__nand3_1
XTAP_TAPCELL_ROW_72_1490 VGND VPWR sky130_fd_sc_hd__tapvpwrvgnd_1
XFILLER_27_917 VGND VGND VPWR VPWR sky130_fd_sc_hd__fill_1
X_08672_ _02275_ _02433_ VGND VGND VPWR VPWR _02434_ sky130_fd_sc_hd__xnor2_1
X_07623_ net803 net1603 net298 _01714_ VGND VGND VPWR VPWR _00474_ sky130_fd_sc_hd__a22o_1
XFILLER_26_29 VPWR VGND VPWR VGND sky130_ef_sc_hd__decap_12
XFILLER_26_416 VGND VGND VPWR VPWR sky130_fd_sc_hd__decap_4
XTAP_TAPCELL_ROW_37_923 VGND VPWR sky130_fd_sc_hd__tapvpwrvgnd_1
XTAP_TAPCELL_ROW_37_934 VGND VPWR sky130_fd_sc_hd__tapvpwrvgnd_1
Xclkbuf_leaf_18_clk clknet_3_3__leaf_clk VGND VGND VPWR VPWR clknet_leaf_18_clk sky130_fd_sc_hd__clkbuf_8
XFILLER_81_533 VGND VGND VPWR VPWR sky130_fd_sc_hd__decap_8
XPHY_EDGE_ROW_5_Right_5 VGND VGND VPWR VPWR sky130_fd_sc_hd__decap_3
X_07554_ _01668_ _01669_ net310 VGND VGND VPWR VPWR _01670_ sky130_fd_sc_hd__mux2_1
XFILLER_50_920 VGND VGND VPWR VPWR sky130_fd_sc_hd__fill_1
X_07485_ _01579_ _01582_ net554 VGND VGND VPWR VPWR _01618_ sky130_fd_sc_hd__mux2_1
X_06505_ net535 VGND VGND VPWR VPWR _01105_ sky130_fd_sc_hd__inv_2
X_09224_ _02880_ _02923_ _02922_ VGND VGND VPWR VPWR _02983_ sky130_fd_sc_hd__o21ba_1
XTAP_TAPCELL_ROW_79_1600 VGND VPWR sky130_fd_sc_hd__tapvpwrvgnd_1
XFILLER_22_699 VGND VGND VPWR VPWR sky130_fd_sc_hd__fill_1
X_09155_ _02869_ _02912_ _02913_ VGND VGND VPWR VPWR _02914_ sky130_fd_sc_hd__nand3b_1
X_09086_ _02841_ _02843_ _02844_ VGND VGND VPWR VPWR _02845_ sky130_fd_sc_hd__nand3_1
X_08106_ _01952_ _01953_ VGND VGND VPWR VPWR _01954_ sky130_fd_sc_hd__xor2_1
X_08037_ u_interface.u_gelu_fp32.u_fp32_to_q16.s3_mag\[30\] _01893_ VGND VGND VPWR
+ VPWR _01894_ sky130_fd_sc_hd__nand2_1
XFILLER_107_248 VGND VGND VPWR VPWR sky130_fd_sc_hd__fill_2
XFILLER_101_7 VGND VGND VPWR VPWR sky130_fd_sc_hd__fill_1
XTAP_TAPCELL_ROW_92_1811 VGND VPWR sky130_fd_sc_hd__tapvpwrvgnd_1
XTAP_TAPCELL_ROW_92_1800 VGND VPWR sky130_fd_sc_hd__tapvpwrvgnd_1
XFILLER_122_218 VPWR VGND VPWR VGND sky130_ef_sc_hd__decap_12
Xhold862 u_interface.u_gelu_fp32.u_fp32_to_q16.s3_mag\[11\] VGND VGND VPWR VPWR net1727
+ sky130_fd_sc_hd__dlygate4sd3_1
Xhold840 _00884_ VGND VGND VPWR VPWR net1705 sky130_fd_sc_hd__dlygate4sd3_1
Xhold873 u_interface.u_gelu_fp32.u_q16_to_fp32.s3_norm_mag\[26\] VGND VGND VPWR VPWR
+ net1738 sky130_fd_sc_hd__dlygate4sd3_1
Xhold851 u_interface.u_gelu_fp32.u_q16_to_fp32.s1_mag\[23\] VGND VGND VPWR VPWR net1716
+ sky130_fd_sc_hd__dlygate4sd3_1
XFILLER_103_432 VGND VGND VPWR VPWR sky130_fd_sc_hd__fill_1
Xhold884 u_interface.u_gelu_fp32.u_synth_top.s2_b\[13\] VGND VGND VPWR VPWR net1749
+ sky130_fd_sc_hd__dlygate4sd3_1
Xhold895 _01774_ VGND VGND VPWR VPWR net1760 sky130_fd_sc_hd__dlygate4sd3_1
XFILLER_1_559 VGND VGND VPWR VPWR sky130_fd_sc_hd__fill_1
XFILLER_107_76 VGND VGND VPWR VPWR sky130_fd_sc_hd__decap_8
X_09988_ _03738_ _03739_ VGND VGND VPWR VPWR _03741_ sky130_fd_sc_hd__xnor2_2
XFILLER_88_165 VPWR VGND VPWR VGND sky130_ef_sc_hd__decap_12
X_08939_ _02696_ _02697_ _02625_ VGND VGND VPWR VPWR _02698_ sky130_fd_sc_hd__a21o_1
XFILLER_76_327 VGND VGND VPWR VPWR sky130_fd_sc_hd__decap_6
XFILLER_67_69 VPWR VGND VPWR VGND sky130_ef_sc_hd__decap_12
XPHY_EDGE_ROW_150_Right_150 VGND VGND VPWR VPWR sky130_fd_sc_hd__decap_3
XTAP_TAPCELL_ROW_106_2029 VGND VPWR sky130_fd_sc_hd__tapvpwrvgnd_1
XFILLER_85_850 VGND VGND VPWR VPWR sky130_fd_sc_hd__decap_4
XFILLER_57_552 VGND VGND VPWR VPWR sky130_fd_sc_hd__decap_8
X_11950_ net658 net387 VGND VGND VPWR VPWR _05684_ sky130_fd_sc_hd__and2b_1
XFILLER_18_917 VGND VGND VPWR VPWR sky130_fd_sc_hd__decap_4
XTAP_TAPCELL_ROW_123_2310 VGND VPWR sky130_fd_sc_hd__tapvpwrvgnd_1
XFILLER_84_371 VGND VGND VPWR VPWR sky130_fd_sc_hd__fill_1
X_10901_ _04407_ _04530_ _04534_ VGND VGND VPWR VPWR _04646_ sky130_fd_sc_hd__a21o_1
XTAP_TAPCELL_ROW_4_397 VGND VPWR sky130_fd_sc_hd__tapvpwrvgnd_1
XFILLER_29_276 VGND VGND VPWR VPWR sky130_fd_sc_hd__decap_4
XFILLER_83_57 VGND VGND VPWR VPWR sky130_fd_sc_hd__decap_3
XFILLER_72_533 VGND VGND VPWR VPWR sky130_fd_sc_hd__decap_3
XFILLER_17_449 VGND VGND VPWR VPWR sky130_fd_sc_hd__decap_6
X_11881_ _05614_ _05615_ VGND VGND VPWR VPWR _05616_ sky130_fd_sc_hd__xnor2_1
XFILLER_33_909 VPWR VGND VPWR VGND sky130_ef_sc_hd__decap_12
X_10832_ _04226_ _04576_ VGND VGND VPWR VPWR _04577_ sky130_fd_sc_hd__xor2_1
XFILLER_32_419 VGND VGND VPWR VPWR sky130_fd_sc_hd__fill_1
X_13620_ clknet_leaf_74_clk _00630_ VGND VGND VPWR VPWR u_interface.fifo_data\[13\]\[3\]
+ sky130_fd_sc_hd__dfxtp_1
X_13551_ clknet_leaf_68_clk _00561_ VGND VGND VPWR VPWR u_interface.fifo_data\[5\]\[30\]
+ sky130_fd_sc_hd__dfxtp_1
X_10763_ _04490_ _04506_ _04507_ VGND VGND VPWR VPWR _04509_ sky130_fd_sc_hd__nand3_2
XTAP_TAPCELL_ROW_101_1951 VGND VPWR sky130_fd_sc_hd__tapvpwrvgnd_1
XFILLER_9_615 VGND VGND VPWR VPWR sky130_fd_sc_hd__fill_1
X_12502_ _06190_ _06193_ _06225_ VGND VGND VPWR VPWR _06227_ sky130_fd_sc_hd__o21a_1
XFILLER_12_121 VPWR VGND VPWR VGND sky130_ef_sc_hd__decap_12
X_13482_ clknet_leaf_4_clk _00492_ VGND VGND VPWR VPWR u_interface.u_gelu_fp32.u_synth_top.s2_b\[11\]
+ sky130_fd_sc_hd__dfxtp_1
X_10694_ _04437_ _04439_ _04435_ VGND VGND VPWR VPWR _04441_ sky130_fd_sc_hd__a21oi_1
XFILLER_12_165 VGND VGND VPWR VPWR sky130_fd_sc_hd__decap_8
X_12433_ _06158_ _06159_ VGND VGND VPWR VPWR _06160_ sky130_fd_sc_hd__and2b_1
XFILLER_32_83 VGND VGND VPWR VPWR sky130_fd_sc_hd__fill_1
XFILLER_148_83 VGND VGND VPWR VPWR sky130_fd_sc_hd__fill_1
XFILLER_126_513 VGND VGND VPWR VPWR sky130_fd_sc_hd__decap_8
X_12364_ _05958_ _06090_ VGND VGND VPWR VPWR _06092_ sky130_fd_sc_hd__xnor2_1
XFILLER_5_821 VPWR VGND VPWR VGND sky130_ef_sc_hd__decap_12
XTAP_TAPCELL_ROW_134_2483 VGND VPWR sky130_fd_sc_hd__tapvpwrvgnd_1
XTAP_TAPCELL_ROW_134_2472 VGND VPWR sky130_fd_sc_hd__tapvpwrvgnd_1
X_14103_ clknet_leaf_27_clk _01029_ VGND VGND VPWR VPWR u_interface.meta_tuser_pipe\[4\]
+ sky130_fd_sc_hd__dfxtp_1
X_11315_ _05053_ _05054_ _05055_ VGND VGND VPWR VPWR _05056_ sky130_fd_sc_hd__a21o_1
XFILLER_5_865 VPWR VGND VPWR VGND sky130_ef_sc_hd__decap_12
XFILLER_113_218 VGND VGND VPWR VPWR sky130_fd_sc_hd__decap_6
X_14034_ clknet_leaf_63_clk _00960_ VGND VGND VPWR VPWR u_interface.core_data_out\[20\]
+ sky130_fd_sc_hd__dfxtp_1
X_12295_ net718 net395 VGND VGND VPWR VPWR _06024_ sky130_fd_sc_hd__nand2_1
X_11246_ _04985_ _04986_ VGND VGND VPWR VPWR _04988_ sky130_fd_sc_hd__xnor2_1
X_11177_ _04811_ _04826_ _04827_ VGND VGND VPWR VPWR _04919_ sky130_fd_sc_hd__a21bo_1
X_10128_ _03877_ _03878_ _03773_ _03776_ VGND VGND VPWR VPWR _03879_ sky130_fd_sc_hd__o211ai_1
XFILLER_79_176 VGND VGND VPWR VPWR sky130_fd_sc_hd__decap_4
X_10059_ net473 net682 VGND VGND VPWR VPWR _03811_ sky130_fd_sc_hd__and2_1
XFILLER_57_80 VGND VGND VPWR VPWR sky130_fd_sc_hd__decap_3
XFILLER_94_179 VGND VGND VPWR VPWR sky130_fd_sc_hd__decap_3
XFILLER_90_330 VGND VGND VPWR VPWR sky130_fd_sc_hd__decap_6
XFILLER_35_235 VGND VGND VPWR VPWR sky130_fd_sc_hd__fill_2
XFILLER_91_897 VGND VGND VPWR VPWR sky130_fd_sc_hd__decap_3
X_13818_ clknet_leaf_85_clk _00828_ VGND VGND VPWR VPWR u_interface.u_gelu_fp32.u_synth_top.s3_mult\[36\]
+ sky130_fd_sc_hd__dfxtp_1
XFILLER_35_279 VGND VGND VPWR VPWR sky130_fd_sc_hd__fill_1
XFILLER_90_396 VPWR VGND VPWR VGND sky130_ef_sc_hd__decap_12
X_13749_ clknet_leaf_87_clk _00759_ VGND VGND VPWR VPWR u_interface.u_gelu_fp32.u_q16_to_fp32.s1_mag\[15\]
+ sky130_fd_sc_hd__dfxtp_1
X_07270_ net788 net106 _01535_ VGND VGND VPWR VPWR _00300_ sky130_fd_sc_hd__and3_1
XFILLER_149_627 VGND VGND VPWR VPWR sky130_fd_sc_hd__decap_8
XFILLER_92_3 VGND VGND VPWR VPWR sky130_fd_sc_hd__decap_8
XTAP_TAPCELL_ROW_154_2804 VGND VPWR sky130_fd_sc_hd__tapvpwrvgnd_1
XFILLER_31_463 VGND VGND VPWR VPWR sky130_fd_sc_hd__fill_1
XFILLER_8_681 VPWR VGND VPWR VGND sky130_ef_sc_hd__decap_12
Xhold125 u_interface.fifo_data\[5\]\[22\] VGND VGND VPWR VPWR net990 sky130_fd_sc_hd__dlygate4sd3_1
Xhold103 u_interface.fifo_tlast\[6\] VGND VGND VPWR VPWR net968 sky130_fd_sc_hd__dlygate4sd3_1
Xhold114 u_interface.u_gelu_fp32.u_fp32_to_q16.s3_frac\[23\] VGND VGND VPWR VPWR net979
+ sky130_fd_sc_hd__dlygate4sd3_1
Xhold147 u_interface.fifo_tlast\[12\] VGND VGND VPWR VPWR net1012 sky130_fd_sc_hd__dlygate4sd3_1
XFILLER_144_365 VGND VGND VPWR VPWR sky130_fd_sc_hd__fill_1
XFILLER_132_538 VPWR VGND VPWR VGND sky130_ef_sc_hd__decap_12
Xhold158 u_interface.fifo_data\[12\]\[1\] VGND VGND VPWR VPWR net1023 sky130_fd_sc_hd__dlygate4sd3_1
XFILLER_104_218 VPWR VGND VPWR VGND sky130_ef_sc_hd__decap_12
Xclkbuf_leaf_7_clk clknet_3_2__leaf_clk VGND VGND VPWR VPWR clknet_leaf_7_clk sky130_fd_sc_hd__clkbuf_8
X_09911_ _03652_ _03653_ _03662_ VGND VGND VPWR VPWR _03664_ sky130_fd_sc_hd__nand3_1
XTAP_TAPCELL_ROW_57_1249 VGND VPWR sky130_fd_sc_hd__tapvpwrvgnd_1
Xhold136 u_interface.fifo_data\[9\]\[3\] VGND VGND VPWR VPWR net1001 sky130_fd_sc_hd__dlygate4sd3_1
XFILLER_144_398 VGND VGND VPWR VPWR sky130_fd_sc_hd__decap_4
Xfanout605 net606 VGND VGND VPWR VPWR net605 sky130_fd_sc_hd__buf_2
Xhold169 u_interface.fifo_data\[1\]\[9\] VGND VGND VPWR VPWR net1034 sky130_fd_sc_hd__dlygate4sd3_1
Xfanout638 net639 VGND VGND VPWR VPWR net638 sky130_fd_sc_hd__dlymetal6s2s_1
XFILLER_112_251 VGND VGND VPWR VPWR sky130_fd_sc_hd__fill_1
Xfanout616 u_interface.u_gelu_fp32.u_synth_top.s2_m\[4\] VGND VGND VPWR VPWR net616
+ sky130_fd_sc_hd__clkbuf_4
X_09842_ net607 net450 _03425_ _03424_ VGND VGND VPWR VPWR _03596_ sky130_fd_sc_hd__a31o_1
Xfanout649 u_interface.u_gelu_fp32.u_synth_top.s2_m\[8\] VGND VGND VPWR VPWR net649
+ sky130_fd_sc_hd__dlymetal6s2s_1
Xfanout627 net628 VGND VGND VPWR VPWR net627 sky130_fd_sc_hd__dlymetal6s2s_1
X_09773_ _03522_ _03527_ VGND VGND VPWR VPWR _03528_ sky130_fd_sc_hd__and2_1
XFILLER_98_496 VGND VGND VPWR VPWR sky130_fd_sc_hd__fill_2
XFILLER_86_658 VGND VGND VPWR VPWR sky130_fd_sc_hd__decap_6
XFILLER_86_636 VGND VGND VPWR VPWR sky130_fd_sc_hd__decap_8
XTAP_TAPCELL_ROW_70_1449 VGND VPWR sky130_fd_sc_hd__tapvpwrvgnd_1
X_06985_ u_interface.core_valid_out u_interface.fifo_wr_ptr\[1\] u_interface.fifo_wr_ptr\[0\]
+ VGND VGND VPWR VPWR _01508_ sky130_fd_sc_hd__nand3_1
X_08724_ net605 net476 net480 net614 VGND VGND VPWR VPWR _02483_ sky130_fd_sc_hd__a22o_1
XFILLER_54_522 VGND VGND VPWR VPWR sky130_fd_sc_hd__fill_1
XFILLER_54_511 VGND VGND VPWR VPWR sky130_fd_sc_hd__decap_6
XFILLER_54_533 VGND VGND VPWR VPWR sky130_fd_sc_hd__decap_4
X_08655_ net152 _02421_ net793 VGND VGND VPWR VPWR _00800_ sky130_fd_sc_hd__a21oi_1
XTAP_TAPCELL_ROW_1_345 VGND VPWR sky130_fd_sc_hd__tapvpwrvgnd_1
XTAP_TAPCELL_ROW_1_356 VGND VPWR sky130_fd_sc_hd__tapvpwrvgnd_1
XFILLER_15_909 VPWR VGND VPWR VGND sky130_ef_sc_hd__decap_12
XFILLER_26_246 VGND VGND VPWR VPWR sky130_fd_sc_hd__decap_3
X_08586_ net158 _02371_ VGND VGND VPWR VPWR _02372_ sky130_fd_sc_hd__nand2_1
X_07606_ _01114_ net339 net333 _01700_ VGND VGND VPWR VPWR _01701_ sky130_fd_sc_hd__a211o_1
XFILLER_53_27 VGND VGND VPWR VPWR sky130_fd_sc_hd__decap_8
X_07537_ net821 net1766 net305 _01627_ VGND VGND VPWR VPWR _00442_ sky130_fd_sc_hd__a22o_1
XTAP_TAPCELL_ROW_85_1692 VGND VPWR sky130_fd_sc_hd__tapvpwrvgnd_1
X_07468_ _01547_ _01550_ net554 VGND VGND VPWR VPWR _01602_ sky130_fd_sc_hd__mux2_1
XFILLER_10_625 VPWR VGND VPWR VGND sky130_ef_sc_hd__decap_12
X_09207_ _02933_ _02936_ _02935_ VGND VGND VPWR VPWR _02966_ sky130_fd_sc_hd__a21o_1
X_07399_ net542 net814 VGND VGND VPWR VPWR _01536_ sky130_fd_sc_hd__nor2_2
XFILLER_10_669 VPWR VGND VPWR VGND sky130_ef_sc_hd__decap_12
X_09138_ _02845_ _02884_ _02896_ VGND VGND VPWR VPWR _02897_ sky130_fd_sc_hd__nand3_1
XTAP_TAPCELL_ROW_20_653 VGND VPWR sky130_fd_sc_hd__tapvpwrvgnd_1
X_09069_ _02826_ _02827_ VGND VGND VPWR VPWR _02828_ sky130_fd_sc_hd__nand2_1
XFILLER_123_505 VGND VGND VPWR VPWR sky130_fd_sc_hd__decap_6
XFILLER_118_53 VGND VGND VPWR VPWR sky130_fd_sc_hd__decap_4
XTAP_TAPCELL_ROW_116_2191 VGND VPWR sky130_fd_sc_hd__tapvpwrvgnd_1
XFILLER_108_579 VGND VGND VPWR VPWR sky130_fd_sc_hd__fill_1
X_11100_ _04840_ _04841_ VGND VGND VPWR VPWR _04843_ sky130_fd_sc_hd__xnor2_1
XFILLER_2_813 VPWR VGND VPWR VGND sky130_ef_sc_hd__decap_12
Xhold670 u_interface.fifo_data\[3\]\[23\] VGND VGND VPWR VPWR net1535 sky130_fd_sc_hd__dlygate4sd3_1
XFILLER_89_441 VGND VGND VPWR VPWR sky130_fd_sc_hd__fill_1
Xhold681 u_interface.fifo_data\[11\]\[5\] VGND VGND VPWR VPWR net1546 sky130_fd_sc_hd__dlygate4sd3_1
X_12080_ _05746_ _05749_ net203 VGND VGND VPWR VPWR _05812_ sky130_fd_sc_hd__a21o_1
Xhold692 u_interface.fifo_data\[3\]\[26\] VGND VGND VPWR VPWR net1557 sky130_fd_sc_hd__dlygate4sd3_1
XFILLER_77_614 VGND VGND VPWR VPWR sky130_fd_sc_hd__fill_2
X_11031_ _04719_ _04774_ VGND VGND VPWR VPWR _04775_ sky130_fd_sc_hd__xnor2_1
XTAP_TAPCELL_ROW_9_478 VGND VPWR sky130_fd_sc_hd__tapvpwrvgnd_1
XFILLER_103_273 VGND VGND VPWR VPWR sky130_fd_sc_hd__decap_6
XFILLER_49_349 VGND VGND VPWR VPWR sky130_fd_sc_hd__fill_1
X_12982_ net1166 net327 net219 VGND VGND VPWR VPWR _01065_ sky130_fd_sc_hd__mux2_1
XFILLER_18_725 VPWR VGND VPWR VGND sky130_ef_sc_hd__decap_12
XFILLER_45_522 VGND VGND VPWR VPWR sky130_fd_sc_hd__decap_4
XFILLER_18_769 VPWR VGND VPWR VGND sky130_ef_sc_hd__decap_12
X_11933_ _05591_ _05592_ _05590_ VGND VGND VPWR VPWR _05667_ sky130_fd_sc_hd__a21o_1
XFILLER_72_363 VGND VGND VPWR VPWR sky130_fd_sc_hd__fill_1
XFILLER_17_279 VGND VGND VPWR VPWR sky130_fd_sc_hd__fill_1
X_11864_ _05596_ _05597_ VGND VGND VPWR VPWR _05599_ sky130_fd_sc_hd__nor2_1
X_13603_ clknet_leaf_49_clk _00613_ VGND VGND VPWR VPWR u_interface.fifo_data\[3\]\[18\]
+ sky130_fd_sc_hd__dfxtp_1
X_10815_ _04226_ _04467_ _04466_ VGND VGND VPWR VPWR _04560_ sky130_fd_sc_hd__a21oi_1
XTAP_TAPCELL_ROW_28_786 VGND VPWR sky130_fd_sc_hd__tapvpwrvgnd_1
XFILLER_13_430 VGND VGND VPWR VPWR sky130_fd_sc_hd__fill_1
X_11795_ net650 net391 _05529_ VGND VGND VPWR VPWR _05531_ sky130_fd_sc_hd__and3_1
XTAP_TAPCELL_ROW_136_2512 VGND VPWR sky130_fd_sc_hd__tapvpwrvgnd_1
X_13534_ clknet_leaf_34_clk _00544_ VGND VGND VPWR VPWR u_interface.fifo_data\[5\]\[13\]
+ sky130_fd_sc_hd__dfxtp_1
X_10746_ net678 net448 VGND VGND VPWR VPWR _04492_ sky130_fd_sc_hd__nand2_1
XFILLER_41_783 VGND VGND VPWR VPWR sky130_fd_sc_hd__fill_1
XFILLER_146_608 VGND VGND VPWR VPWR sky130_fd_sc_hd__fill_1
X_10677_ _04302_ _04304_ _04420_ _04421_ VGND VGND VPWR VPWR _04424_ sky130_fd_sc_hd__a211oi_1
X_13465_ clknet_leaf_61_clk _00475_ VGND VGND VPWR VPWR u_interface.u_gelu_fp32.u_q16_to_fp32.s3_norm_mag\[5\]
+ sky130_fd_sc_hd__dfxtp_1
XFILLER_139_671 VGND VGND VPWR VPWR sky130_fd_sc_hd__fill_1
XFILLER_127_822 VGND VGND VPWR VPWR sky130_fd_sc_hd__decap_8
X_12416_ _06141_ _06142_ VGND VGND VPWR VPWR _06143_ sky130_fd_sc_hd__nand2_1
X_13396_ clknet_leaf_83_clk _00406_ VGND VGND VPWR VPWR u_interface.fifo_data\[6\]\[9\]
+ sky130_fd_sc_hd__dfxtp_1
XFILLER_153_162 VGND VGND VPWR VPWR sky130_fd_sc_hd__decap_6
XFILLER_5_673 VPWR VGND VPWR VGND sky130_ef_sc_hd__decap_12
X_12347_ net198 _06074_ VGND VGND VPWR VPWR _06075_ sky130_fd_sc_hd__and2_1
XFILLER_142_869 VGND VGND VPWR VPWR sky130_fd_sc_hd__decap_4
XFILLER_141_335 VGND VGND VPWR VPWR sky130_fd_sc_hd__fill_1
XFILLER_114_538 VGND VGND VPWR VPWR sky130_fd_sc_hd__decap_8
XFILLER_99_249 VPWR VGND VPWR VGND sky130_ef_sc_hd__decap_12
X_12278_ net200 _06005_ VGND VGND VPWR VPWR _06007_ sky130_fd_sc_hd__xnor2_1
X_14017_ clknet_leaf_69_clk _00943_ VGND VGND VPWR VPWR u_interface.core_data_out\[3\]
+ sky130_fd_sc_hd__dfxtp_1
XFILLER_4_65 VPWR VGND VPWR VGND sky130_ef_sc_hd__decap_12
X_11229_ _04969_ _04970_ VGND VGND VPWR VPWR _04971_ sky130_fd_sc_hd__and2b_1
XFILLER_67_113 VGND VGND VPWR VPWR sky130_fd_sc_hd__fill_2
XTAP_TAPCELL_ROW_52_1168 VGND VPWR sky130_fd_sc_hd__tapvpwrvgnd_1
XTAP_TAPCELL_ROW_147_2685 VGND VPWR sky130_fd_sc_hd__tapvpwrvgnd_1
X_06770_ u_interface.fifo_data\[4\]\[17\] u_interface.fifo_data\[5\]\[17\] u_interface.fifo_data\[6\]\[17\]
+ u_interface.fifo_data\[7\]\[17\] net764 net747 VGND VGND VPWR VPWR _01328_ sky130_fd_sc_hd__mux4_1
XFILLER_83_617 VGND VGND VPWR VPWR sky130_fd_sc_hd__decap_3
XFILLER_76_680 VGND VGND VPWR VPWR sky130_fd_sc_hd__fill_1
XFILLER_36_544 VGND VGND VPWR VPWR sky130_fd_sc_hd__decap_4
X_08440_ u_interface.u_gelu_fp32.u_synth_top.s3_mult\[26\] u_interface.u_gelu_fp32.u_synth_top.s3_b\[10\]
+ _02230_ VGND VGND VPWR VPWR _02231_ sky130_fd_sc_hd__a21oi_1
XFILLER_23_205 VGND VGND VPWR VPWR sky130_fd_sc_hd__decap_8
XFILLER_91_683 VGND VGND VPWR VPWR sky130_fd_sc_hd__decap_8
XFILLER_90_193 VGND VGND VPWR VPWR sky130_fd_sc_hd__decap_3
X_08371_ net524 u_interface.u_gelu_fp32.u_synth_top.s3_mult\[61\] VGND VGND VPWR VPWR
+ _02162_ sky130_fd_sc_hd__xnor2_1
XFILLER_149_446 VGND VGND VPWR VPWR sky130_fd_sc_hd__fill_2
X_07322_ net1122 net346 net256 VGND VGND VPWR VPWR _00352_ sky130_fd_sc_hd__mux2_1
XFILLER_31_271 VGND VGND VPWR VPWR sky130_fd_sc_hd__fill_2
X_07253_ net1100 net350 net252 VGND VGND VPWR VPWR _00285_ sky130_fd_sc_hd__mux2_1
X_07184_ net1271 net575 net264 VGND VGND VPWR VPWR _00224_ sky130_fd_sc_hd__mux2_1
XFILLER_145_652 VGND VGND VPWR VPWR sky130_fd_sc_hd__fill_1
XFILLER_155_29 VGND VGND VPWR VPWR sky130_fd_sc_hd__fill_2
XFILLER_145_663 VGND VGND VPWR VPWR sky130_fd_sc_hd__fill_1
XFILLER_144_162 VGND VGND VPWR VPWR sky130_fd_sc_hd__fill_2
XFILLER_133_825 VGND VGND VPWR VPWR sky130_fd_sc_hd__decap_6
XFILLER_105_527 VPWR VGND VPWR VGND sky130_ef_sc_hd__decap_12
XFILLER_2_109 VPWR VGND VPWR VGND sky130_ef_sc_hd__decap_12
Xfanout413 u_interface.u_gelu_fp32.u_synth_top.s2_dx\[25\] VGND VGND VPWR VPWR net413
+ sky130_fd_sc_hd__buf_2
XTAP_TAPCELL_ROW_6_426 VGND VPWR sky130_fd_sc_hd__tapvpwrvgnd_1
Xfanout402 net403 VGND VGND VPWR VPWR net402 sky130_fd_sc_hd__clkbuf_2
XFILLER_113_593 VPWR VGND VPWR VGND sky130_ef_sc_hd__decap_12
XFILLER_101_711 VGND VGND VPWR VPWR sky130_fd_sc_hd__fill_1
X_09825_ net482 net688 VGND VGND VPWR VPWR _03579_ sky130_fd_sc_hd__nand2_1
Xfanout457 u_interface.u_gelu_fp32.u_synth_top.s2_dx\[15\] VGND VGND VPWR VPWR net457
+ sky130_fd_sc_hd__buf_2
Xfanout446 u_interface.u_gelu_fp32.u_synth_top.s2_dx\[18\] VGND VGND VPWR VPWR net446
+ sky130_fd_sc_hd__buf_2
XTAP_TAPCELL_ROW_6_437 VGND VPWR sky130_fd_sc_hd__tapvpwrvgnd_1
Xfanout435 net437 VGND VGND VPWR VPWR net435 sky130_fd_sc_hd__dlymetal6s2s_1
Xfanout424 net425 VGND VGND VPWR VPWR net424 sky130_fd_sc_hd__buf_2
Xfanout479 u_interface.u_gelu_fp32.u_synth_top.s2_dx\[9\] VGND VGND VPWR VPWR net479
+ sky130_fd_sc_hd__clkbuf_2
XFILLER_100_232 VPWR VGND VPWR VGND sky130_ef_sc_hd__decap_12
XFILLER_98_293 VPWR VGND VPWR VGND sky130_ef_sc_hd__decap_12
Xfanout468 net469 VGND VGND VPWR VPWR net468 sky130_fd_sc_hd__buf_2
XFILLER_59_658 VGND VGND VPWR VPWR sky130_fd_sc_hd__decap_8
X_09756_ net175 _03468_ _03506_ _03507_ VGND VGND VPWR VPWR _03511_ sky130_fd_sc_hd__or4_1
XFILLER_100_265 VGND VGND VPWR VPWR sky130_fd_sc_hd__decap_8
XTAP_TAPCELL_ROW_87_1721 VGND VPWR sky130_fd_sc_hd__tapvpwrvgnd_1
X_06968_ _01494_ _01495_ _01477_ VGND VGND VPWR VPWR _01496_ sky130_fd_sc_hd__or3b_1
XFILLER_74_628 VGND VGND VPWR VPWR sky130_fd_sc_hd__decap_4
XFILLER_73_105 VGND VGND VPWR VPWR sky130_fd_sc_hd__decap_6
XFILLER_58_168 VGND VGND VPWR VPWR sky130_fd_sc_hd__decap_3
X_08707_ _02450_ _02455_ _02460_ VGND VGND VPWR VPWR _02466_ sky130_fd_sc_hd__o21ai_1
X_09687_ _03438_ _03439_ _03440_ VGND VGND VPWR VPWR _03442_ sky130_fd_sc_hd__a21o_1
XFILLER_104_88 VGND VGND VPWR VPWR sky130_fd_sc_hd__decap_8
XFILLER_104_55 VGND VGND VPWR VPWR sky130_fd_sc_hd__fill_2
XTAP_TAPCELL_ROW_87_1732 VGND VPWR sky130_fd_sc_hd__tapvpwrvgnd_1
XFILLER_64_15 VPWR VGND VPWR VGND sky130_ef_sc_hd__decap_12
X_06899_ _01439_ _01440_ VGND VGND VPWR VPWR _00033_ sky130_fd_sc_hd__xnor2_1
X_08638_ net153 _02408_ net794 VGND VGND VPWR VPWR _00796_ sky130_fd_sc_hd__a21oi_1
XFILLER_70_856 VGND VGND VPWR VPWR sky130_fd_sc_hd__decap_3
XTAP_TAPCELL_ROW_25_734 VGND VPWR sky130_fd_sc_hd__tapvpwrvgnd_1
XFILLER_70_878 VGND VGND VPWR VPWR sky130_fd_sc_hd__decap_8
X_08569_ _02318_ net156 VGND VGND VPWR VPWR _02360_ sky130_fd_sc_hd__or2_1
XFILLER_80_36 VGND VGND VPWR VPWR sky130_fd_sc_hd__fill_1
X_10600_ _04344_ _04345_ _04343_ VGND VGND VPWR VPWR _04347_ sky130_fd_sc_hd__a21bo_1
X_11580_ net179 _05316_ VGND VGND VPWR VPWR _05318_ sky130_fd_sc_hd__xor2_1
XFILLER_23_783 VGND VGND VPWR VPWR sky130_fd_sc_hd__fill_1
XFILLER_155_405 VGND VGND VPWR VPWR sky130_fd_sc_hd__decap_4
XTAP_TAPCELL_ROW_118_2231 VGND VPWR sky130_fd_sc_hd__tapvpwrvgnd_1
XTAP_TAPCELL_ROW_118_2220 VGND VPWR sky130_fd_sc_hd__tapvpwrvgnd_1
X_10531_ net579 net586 net409 net405 VGND VGND VPWR VPWR _04279_ sky130_fd_sc_hd__and4_1
XFILLER_10_433 VGND VGND VPWR VPWR sky130_fd_sc_hd__fill_1
X_13250_ clknet_leaf_39_clk _00260_ VGND VGND VPWR VPWR u_interface.fifo_data\[11\]\[28\]
+ sky130_fd_sc_hd__dfxtp_1
XFILLER_109_822 VGND VGND VPWR VPWR sky130_fd_sc_hd__decap_3
XFILLER_10_477 VGND VGND VPWR VPWR sky130_fd_sc_hd__fill_1
XFILLER_155_449 VGND VGND VPWR VPWR sky130_fd_sc_hd__fill_2
X_10462_ _03979_ _04207_ _04208_ VGND VGND VPWR VPWR _04210_ sky130_fd_sc_hd__nand3_1
X_12201_ _05793_ _05794_ _05864_ VGND VGND VPWR VPWR _05932_ sky130_fd_sc_hd__or3_1
XFILLER_135_162 VGND VGND VPWR VPWR sky130_fd_sc_hd__decap_6
XFILLER_135_151 VGND VGND VPWR VPWR sky130_fd_sc_hd__fill_2
XTAP_TAPCELL_ROW_131_2431 VGND VPWR sky130_fd_sc_hd__tapvpwrvgnd_1
XFILLER_124_803 VGND VGND VPWR VPWR sky130_fd_sc_hd__fill_1
X_13181_ clknet_leaf_46_clk _00191_ VGND VGND VPWR VPWR u_interface.fifo_data\[9\]\[23\]
+ sky130_fd_sc_hd__dfxtp_1
X_10393_ net580 net408 VGND VGND VPWR VPWR _04142_ sky130_fd_sc_hd__nand2_1
XFILLER_124_869 VGND VGND VPWR VPWR sky130_fd_sc_hd__decap_3
XFILLER_97_709 VGND VGND VPWR VPWR sky130_fd_sc_hd__fill_1
X_12132_ _05862_ _05863_ VGND VGND VPWR VPWR _05864_ sky130_fd_sc_hd__or2_1
XFILLER_123_357 VPWR VGND VPWR VGND sky130_ef_sc_hd__decap_12
XFILLER_2_643 VGND VGND VPWR VPWR sky130_fd_sc_hd__fill_1
X_12063_ _05795_ VGND VGND VPWR VPWR _05796_ sky130_fd_sc_hd__inv_2
XFILLER_150_176 VGND VGND VPWR VPWR sky130_fd_sc_hd__fill_1
XFILLER_77_422 VGND VGND VPWR VPWR sky130_fd_sc_hd__fill_1
X_11014_ net579 net388 VGND VGND VPWR VPWR _04758_ sky130_fd_sc_hd__and2b_1
XFILLER_49_113 VGND VGND VPWR VPWR sky130_fd_sc_hd__decap_8
XPHY_EDGE_ROW_8_Left_164 VGND VGND VPWR VPWR sky130_fd_sc_hd__decap_3
XTAP_TAPCELL_ROW_129_2393 VGND VPWR sky130_fd_sc_hd__tapvpwrvgnd_1
X_12965_ _06476_ _06479_ VGND VGND VPWR VPWR _06484_ sky130_fd_sc_hd__nor2_1
XFILLER_64_149 VPWR VGND VPWR VGND sky130_ef_sc_hd__decap_12
XFILLER_46_831 VGND VGND VPWR VPWR sky130_fd_sc_hd__fill_1
XFILLER_80_609 VPWR VGND VPWR VGND sky130_ef_sc_hd__decap_12
XFILLER_18_555 VGND VGND VPWR VPWR sky130_fd_sc_hd__fill_1
X_11916_ net184 _05569_ _05568_ VGND VGND VPWR VPWR _05650_ sky130_fd_sc_hd__a21o_1
X_12896_ net786 net925 VGND VGND VPWR VPWR _01038_ sky130_fd_sc_hd__and2_1
XFILLER_21_709 VPWR VGND VPWR VGND sky130_ef_sc_hd__decap_12
X_11847_ net214 _05581_ VGND VGND VPWR VPWR _05582_ sky130_fd_sc_hd__xnor2_1
XFILLER_60_377 VGND VGND VPWR VPWR sky130_fd_sc_hd__decap_6
X_11778_ net692 net701 net415 net410 VGND VGND VPWR VPWR _05514_ sky130_fd_sc_hd__nand4_1
XFILLER_146_405 VGND VGND VPWR VPWR sky130_fd_sc_hd__fill_2
X_13517_ clknet_leaf_35_clk _00527_ VGND VGND VPWR VPWR u_interface.core_data_out\[28\]
+ sky130_fd_sc_hd__dfxtp_1
X_10729_ _04473_ _04474_ _04470_ VGND VGND VPWR VPWR _04475_ sky130_fd_sc_hd__a21o_1
Xclkload34 clknet_leaf_20_clk VGND VGND VPWR VPWR clkload34/Y sky130_fd_sc_hd__inv_12
X_13448_ clknet_leaf_9_clk _00458_ VGND VGND VPWR VPWR u_interface.u_gelu_fp32.u_fp32_to_q16.s3_mag\[19\]
+ sky130_fd_sc_hd__dfxtp_1
Xclkload23 clknet_leaf_8_clk VGND VGND VPWR VPWR clkload23/Y sky130_fd_sc_hd__inv_16
Xclkload12 clknet_leaf_23_clk VGND VGND VPWR VPWR clkload12/Y sky130_fd_sc_hd__inv_12
XFILLER_9_297 VGND VGND VPWR VPWR sky130_fd_sc_hd__fill_1
Xclkload67 clknet_leaf_31_clk VGND VGND VPWR VPWR clkload67/Y sky130_fd_sc_hd__bufinv_16
XFILLER_127_685 VGND VGND VPWR VPWR sky130_fd_sc_hd__decap_4
Xclkload78 clknet_leaf_41_clk VGND VGND VPWR VPWR clkload78/Y sky130_fd_sc_hd__inv_8
X_13379_ clknet_leaf_44_clk _00389_ VGND VGND VPWR VPWR u_interface.fifo_data\[7\]\[24\]
+ sky130_fd_sc_hd__dfxtp_1
Xclkload56 clknet_leaf_65_clk VGND VGND VPWR VPWR clkload56/Y sky130_fd_sc_hd__inv_8
XFILLER_55_3 VPWR VGND VPWR VGND sky130_ef_sc_hd__decap_12
Xclkload45 clknet_leaf_78_clk VGND VGND VPWR VPWR clkload45/Y sky130_fd_sc_hd__inv_6
XTAP_TAPCELL_ROW_149_2725 VGND VPWR sky130_fd_sc_hd__tapvpwrvgnd_1
XTAP_TAPCELL_ROW_149_2714 VGND VPWR sky130_fd_sc_hd__tapvpwrvgnd_1
XFILLER_141_154 VPWR VGND VPWR VGND sky130_ef_sc_hd__decap_12
X_07940_ u_interface.u_gelu_fp32.u_fp32_to_q16.s1_exp\[3\] _01810_ VGND VGND VPWR
+ VPWR _01831_ sky130_fd_sc_hd__nor2_1
XFILLER_142_699 VGND VGND VPWR VPWR sky130_fd_sc_hd__fill_1
XFILLER_68_411 VGND VGND VPWR VPWR sky130_fd_sc_hd__decap_8
XFILLER_110_541 VPWR VGND VPWR VGND sky130_ef_sc_hd__decap_12
X_07871_ net1331 net374 net265 VGND VGND VPWR VPWR _00632_ sky130_fd_sc_hd__mux2_1
XFILLER_29_809 VPWR VGND VPWR VGND sky130_ef_sc_hd__decap_12
X_09610_ _03365_ VGND VGND VPWR VPWR _03366_ sky130_fd_sc_hd__inv_2
X_06822_ net734 _01372_ VGND VGND VPWR VPWR _01373_ sky130_fd_sc_hd__or2_1
XFILLER_68_477 VGND VGND VPWR VPWR sky130_fd_sc_hd__decap_6
X_09541_ _03281_ _03297_ VGND VGND VPWR VPWR _03298_ sky130_fd_sc_hd__nor2_1
X_06753_ u_interface.fifo_data\[0\]\[15\] u_interface.fifo_data\[1\]\[15\] u_interface.fifo_data\[2\]\[15\]
+ u_interface.fifo_data\[3\]\[15\] net761 net744 VGND VGND VPWR VPWR _01313_ sky130_fd_sc_hd__mux4_1
XTAP_TAPCELL_ROW_69_1440 VGND VPWR sky130_fd_sc_hd__tapvpwrvgnd_1
XFILLER_64_661 VGND VGND VPWR VPWR sky130_fd_sc_hd__fill_1
XFILLER_36_363 VGND VGND VPWR VPWR sky130_fd_sc_hd__fill_1
X_09472_ net515 net519 VGND VGND VPWR VPWR _03229_ sky130_fd_sc_hd__or2_1
X_06684_ _01247_ _01249_ _01252_ net316 VGND VGND VPWR VPWR net137 sky130_fd_sc_hd__a22o_1
XFILLER_37_897 VGND VGND VPWR VPWR sky130_fd_sc_hd__decap_4
X_08423_ u_interface.u_gelu_fp32.u_synth_top.s3_mult\[16\] u_interface.u_gelu_fp32.u_synth_top.s3_b\[0\]
+ _02212_ VGND VGND VPWR VPWR _02214_ sky130_fd_sc_hd__and3_1
XTAP_TAPCELL_ROW_82_1651 VGND VPWR sky130_fd_sc_hd__tapvpwrvgnd_1
XTAP_TAPCELL_ROW_82_1640 VGND VPWR sky130_fd_sc_hd__tapvpwrvgnd_1
XFILLER_34_29 VPWR VGND VPWR VGND sky130_ef_sc_hd__decap_12
X_08354_ _02147_ _02148_ VGND VGND VPWR VPWR _00772_ sky130_fd_sc_hd__nor2_1
X_07305_ net1208 net380 net253 VGND VGND VPWR VPWR _00335_ sky130_fd_sc_hd__mux2_1
XFILLER_137_438 VGND VGND VPWR VPWR sky130_fd_sc_hd__decap_8
Xclkload6 clknet_3_6__leaf_clk VGND VGND VPWR VPWR clkload6/Y sky130_fd_sc_hd__inv_6
XFILLER_109_107 VGND VGND VPWR VPWR sky130_fd_sc_hd__fill_2
X_08285_ net532 u_interface.u_gelu_fp32.s2_data\[11\] _02095_ net801 VGND VGND VPWR
+ VPWR _02097_ sky130_fd_sc_hd__a31o_1
XFILLER_137_449 VPWR VGND VPWR VGND sky130_ef_sc_hd__decap_12
X_07236_ net1380 net384 net249 VGND VGND VPWR VPWR _00268_ sky130_fd_sc_hd__mux2_1
XFILLER_133_611 VGND VGND VPWR VPWR sky130_fd_sc_hd__decap_4
X_07167_ net1357 net371 net263 VGND VGND VPWR VPWR _00207_ sky130_fd_sc_hd__mux2_1
XFILLER_117_140 VGND VGND VPWR VPWR sky130_fd_sc_hd__fill_2
XTAP_TAPCELL_ROW_113_2150 VGND VPWR sky130_fd_sc_hd__tapvpwrvgnd_1
XFILLER_59_15 VGND VGND VPWR VPWR sky130_fd_sc_hd__decap_4
XFILLER_3_429 VPWR VGND VPWR VGND sky130_ef_sc_hd__decap_12
XFILLER_133_666 VGND VGND VPWR VPWR sky130_fd_sc_hd__decap_6
X_07098_ net1064 net350 net228 VGND VGND VPWR VPWR _00138_ sky130_fd_sc_hd__mux2_1
XFILLER_106_869 VGND VGND VPWR VPWR sky130_fd_sc_hd__decap_6
Xfanout232 _01519_ VGND VGND VPWR VPWR net232 sky130_fd_sc_hd__clkbuf_8
Xfanout210 _01525_ VGND VGND VPWR VPWR net210 sky130_fd_sc_hd__buf_4
XFILLER_121_839 VGND VGND VPWR VPWR sky130_fd_sc_hd__fill_1
XFILLER_120_338 VGND VGND VPWR VPWR sky130_fd_sc_hd__fill_2
XFILLER_78_219 VPWR VGND VPWR VGND sky130_ef_sc_hd__decap_12
Xfanout221 net222 VGND VGND VPWR VPWR net221 sky130_fd_sc_hd__buf_4
Xfanout243 net244 VGND VGND VPWR VPWR net243 sky130_fd_sc_hd__buf_4
Xfanout254 _01511_ VGND VGND VPWR VPWR net254 sky130_fd_sc_hd__clkbuf_4
Xfanout265 _01505_ VGND VGND VPWR VPWR net265 sky130_fd_sc_hd__buf_4
X_09808_ _03560_ _03561_ _03461_ VGND VGND VPWR VPWR _03562_ sky130_fd_sc_hd__a21oi_1
Xfanout298 _01695_ VGND VGND VPWR VPWR net298 sky130_fd_sc_hd__buf_2
XFILLER_59_477 VGND VGND VPWR VPWR sky130_fd_sc_hd__decap_8
X_09739_ _03492_ _03493_ _03483_ VGND VGND VPWR VPWR _03494_ sky130_fd_sc_hd__a21oi_1
XFILLER_15_503 VGND VGND VPWR VPWR sky130_fd_sc_hd__fill_1
X_12750_ net1510 net1534 net825 VGND VGND VPWR VPWR _00932_ sky130_fd_sc_hd__mux2_1
XFILLER_43_845 VGND VGND VPWR VPWR sky130_fd_sc_hd__fill_1
XFILLER_43_834 VGND VGND VPWR VPWR sky130_fd_sc_hd__decap_6
XFILLER_91_57 VPWR VGND VPWR VGND sky130_ef_sc_hd__decap_12
X_12681_ u_interface.u_gelu_fp32.u_q16_to_fp32.s2_clz\[4\] net773 VGND VGND VPWR VPWR
+ _06343_ sky130_fd_sc_hd__and2_1
X_11701_ _05436_ _05437_ VGND VGND VPWR VPWR _05438_ sky130_fd_sc_hd__or2_1
X_11632_ _05368_ _05369_ VGND VGND VPWR VPWR _05370_ sky130_fd_sc_hd__and2_1
XFILLER_30_539 VGND VGND VPWR VPWR sky130_fd_sc_hd__decap_4
XFILLER_155_202 VGND VGND VPWR VPWR sky130_fd_sc_hd__decap_4
X_13302_ clknet_leaf_52_clk _00312_ VGND VGND VPWR VPWR u_interface.fifo_data\[8\]\[11\]
+ sky130_fd_sc_hd__dfxtp_1
X_11563_ _05300_ _05301_ VGND VGND VPWR VPWR _05302_ sky130_fd_sc_hd__nor2_1
XFILLER_11_753 VPWR VGND VPWR VGND sky130_ef_sc_hd__decap_12
X_10514_ _04260_ _04261_ VGND VGND VPWR VPWR _04262_ sky130_fd_sc_hd__and2b_1
X_11494_ _05221_ _05232_ VGND VGND VPWR VPWR _05233_ sky130_fd_sc_hd__or2_1
XFILLER_11_797 VPWR VGND VPWR VGND sky130_ef_sc_hd__decap_12
XFILLER_155_279 VGND VGND VPWR VPWR sky130_fd_sc_hd__fill_1
X_13233_ clknet_leaf_51_clk _00243_ VGND VGND VPWR VPWR u_interface.fifo_data\[11\]\[11\]
+ sky130_fd_sc_hd__dfxtp_1
X_10445_ _04192_ _04193_ VGND VGND VPWR VPWR _04194_ sky130_fd_sc_hd__or2_1
XFILLER_6_245 VGND VGND VPWR VPWR sky130_fd_sc_hd__decap_6
XFILLER_40_72 VPWR VGND VPWR VGND sky130_ef_sc_hd__decap_12
XFILLER_124_633 VGND VGND VPWR VPWR sky130_fd_sc_hd__decap_3
X_13164_ clknet_leaf_72_clk _00174_ VGND VGND VPWR VPWR u_interface.fifo_data\[9\]\[6\]
+ sky130_fd_sc_hd__dfxtp_1
X_10376_ net453 net457 net660 net669 VGND VGND VPWR VPWR _04125_ sky130_fd_sc_hd__nand4_1
X_12115_ _05846_ _05845_ VGND VGND VPWR VPWR _05847_ sky130_fd_sc_hd__and2b_1
X_13095_ clknet_leaf_31_clk _00105_ VGND VGND VPWR VPWR u_interface.fifo_data\[15\]\[16\]
+ sky130_fd_sc_hd__dfxtp_1
XFILLER_78_753 VGND VGND VPWR VPWR sky130_fd_sc_hd__decap_3
XFILLER_77_230 VGND VGND VPWR VPWR sky130_fd_sc_hd__decap_4
XFILLER_66_904 VGND VGND VPWR VPWR sky130_fd_sc_hd__fill_1
X_12046_ _05777_ _05778_ VGND VGND VPWR VPWR _05779_ sky130_fd_sc_hd__or2_1
XTAP_TAPCELL_ROW_144_2644 VGND VPWR sky130_fd_sc_hd__tapvpwrvgnd_1
XTAP_TAPCELL_ROW_144_2633 VGND VPWR sky130_fd_sc_hd__tapvpwrvgnd_1
XFILLER_92_233 VPWR VGND VPWR VGND sky130_ef_sc_hd__decap_12
XFILLER_1_55 VGND VGND VPWR VPWR sky130_fd_sc_hd__fill_1
XFILLER_81_918 VGND VGND VPWR VPWR sky130_fd_sc_hd__decap_3
X_13997_ clknet_leaf_64_clk _00923_ VGND VGND VPWR VPWR u_interface.u_gelu_fp32.u_q16_to_fp32.s3_norm_mag\[24\]
+ sky130_fd_sc_hd__dfxtp_1
XFILLER_19_853 VPWR VGND VPWR VGND sky130_ef_sc_hd__decap_12
XFILLER_34_801 VGND VGND VPWR VPWR sky130_fd_sc_hd__decap_8
X_12948_ net1785 _06468_ _06469_ VGND VGND VPWR VPWR _01059_ sky130_fd_sc_hd__o21a_1
XFILLER_19_897 VPWR VGND VPWR VGND sky130_ef_sc_hd__decap_12
X_12879_ _06279_ _06434_ net829 VGND VGND VPWR VPWR _01021_ sky130_fd_sc_hd__a21oi_1
XFILLER_45_182 VPWR VGND VPWR VGND sky130_ef_sc_hd__decap_12
XFILLER_34_867 VGND VGND VPWR VPWR sky130_fd_sc_hd__fill_1
XFILLER_60_141 VPWR VGND VPWR VGND sky130_ef_sc_hd__decap_12
XTAP_TAPCELL_ROW_47_1089 VGND VPWR sky130_fd_sc_hd__tapvpwrvgnd_1
XFILLER_33_366 VPWR VGND VPWR VGND sky130_ef_sc_hd__decap_12
XTAP_TAPCELL_ROW_16_586 VGND VPWR sky130_fd_sc_hd__tapvpwrvgnd_1
XTAP_TAPCELL_ROW_16_597 VGND VPWR sky130_fd_sc_hd__tapvpwrvgnd_1
X_08070_ net541 _01923_ net169 VGND VGND VPWR VPWR _01924_ sky130_fd_sc_hd__mux2_1
XFILLER_119_449 VGND VGND VPWR VPWR sky130_fd_sc_hd__decap_8
XTAP_TAPCELL_ROW_60_1289 VGND VPWR sky130_fd_sc_hd__tapvpwrvgnd_1
X_07021_ net1323 net376 net269 VGND VGND VPWR VPWR _00061_ sky130_fd_sc_hd__mux2_1
X_08972_ _02723_ _02730_ VGND VGND VPWR VPWR _02731_ sky130_fd_sc_hd__nand2_1
X_07923_ u_interface.u_gelu_fp32.u_fp32_to_q16.s1_mant\[13\] u_interface.u_gelu_fp32.u_fp32_to_q16.s1_mant\[12\]
+ u_interface.u_gelu_fp32.u_fp32_to_q16.s1_mant\[15\] u_interface.u_gelu_fp32.u_fp32_to_q16.s1_mant\[14\]
+ VGND VGND VPWR VPWR _01817_ sky130_fd_sc_hd__or4_1
Xhold18 u_interface.u_gelu_fp32.s1_data\[4\] VGND VGND VPWR VPWR net883 sky130_fd_sc_hd__dlygate4sd3_1
Xhold29 u_interface.u_gelu_fp32.s1_data\[29\] VGND VGND VPWR VPWR net894 sky130_fd_sc_hd__dlygate4sd3_1
XFILLER_84_701 VGND VGND VPWR VPWR sky130_fd_sc_hd__decap_3
X_07854_ net344 net1482 net282 VGND VGND VPWR VPWR _00615_ sky130_fd_sc_hd__mux2_1
XFILLER_29_617 VPWR VGND VPWR VGND sky130_ef_sc_hd__decap_12
X_06805_ u_interface.fifo_data\[12\]\[22\] u_interface.fifo_data\[13\]\[22\] u_interface.fifo_data\[14\]\[22\]
+ u_interface.fifo_data\[15\]\[22\] net768 net751 VGND VGND VPWR VPWR _01358_ sky130_fd_sc_hd__mux4_1
XFILLER_68_296 VPWR VGND VPWR VGND sky130_ef_sc_hd__decap_12
XFILLER_28_138 VGND VGND VPWR VPWR sky130_fd_sc_hd__fill_2
X_07785_ net1350 net354 net234 VGND VGND VPWR VPWR _00546_ sky130_fd_sc_hd__mux2_1
XFILLER_28_149 VGND VGND VPWR VPWR sky130_fd_sc_hd__decap_3
X_06736_ net322 _01295_ net727 VGND VGND VPWR VPWR _01298_ sky130_fd_sc_hd__o21a_1
X_09524_ _03157_ _03279_ VGND VGND VPWR VPWR _03281_ sky130_fd_sc_hd__xnor2_1
XFILLER_45_39 VPWR VGND VPWR VGND sky130_ef_sc_hd__decap_12
X_09455_ _02703_ _03210_ _03211_ VGND VGND VPWR VPWR _03213_ sky130_fd_sc_hd__or3_2
X_06667_ _01236_ _01237_ net731 VGND VGND VPWR VPWR _01238_ sky130_fd_sc_hd__mux2_1
X_08406_ u_interface.u_gelu_fp32.u_synth_top.s3_mult\[23\] u_interface.u_gelu_fp32.u_synth_top.s3_b\[7\]
+ VGND VGND VPWR VPWR _02197_ sky130_fd_sc_hd__or2_1
XFILLER_24_377 VGND VGND VPWR VPWR sky130_fd_sc_hd__decap_4
XFILLER_24_388 VPWR VGND VPWR VGND sky130_ef_sc_hd__decap_12
XFILLER_25_889 VGND VGND VPWR VPWR sky130_fd_sc_hd__decap_6
X_09386_ _03140_ _03141_ _03142_ VGND VGND VPWR VPWR _03144_ sky130_fd_sc_hd__nand3_1
X_06598_ _01106_ _01166_ _01177_ _01180_ VGND VGND VPWR VPWR _00017_ sky130_fd_sc_hd__a211oi_1
XFILLER_61_27 VGND VGND VPWR VPWR sky130_fd_sc_hd__fill_1
XTAP_TAPCELL_ROW_35_895 VGND VPWR sky130_fd_sc_hd__tapvpwrvgnd_1
X_08337_ net529 net1642 _02134_ net797 VGND VGND VPWR VPWR _02136_ sky130_fd_sc_hd__a31o_1
X_08268_ net534 _02083_ net1666 VGND VGND VPWR VPWR _02084_ sky130_fd_sc_hd__a21oi_1
XPHY_EDGE_ROW_89_Left_245 VGND VGND VPWR VPWR sky130_fd_sc_hd__decap_3
X_07219_ net570 net1538 net258 VGND VGND VPWR VPWR _00259_ sky130_fd_sc_hd__mux2_1
XTAP_TAPCELL_ROW_111_2109 VGND VPWR sky130_fd_sc_hd__tapvpwrvgnd_1
X_08199_ _02030_ _02031_ VGND VGND VPWR VPWR _02032_ sky130_fd_sc_hd__xnor2_1
XTAP_TAPCELL_ROW_95_1853 VGND VPWR sky130_fd_sc_hd__tapvpwrvgnd_1
X_10230_ net482 net715 _03890_ _03889_ VGND VGND VPWR VPWR _03980_ sky130_fd_sc_hd__a31o_1
XFILLER_4_749 VGND VGND VPWR VPWR sky130_fd_sc_hd__decap_6
XFILLER_152_249 VGND VGND VPWR VPWR sky130_fd_sc_hd__decap_3
XFILLER_10_53 VPWR VGND VPWR VGND sky130_ef_sc_hd__decap_12
XFILLER_3_237 VPWR VGND VPWR VGND sky130_ef_sc_hd__decap_12
XFILLER_133_485 VPWR VGND VPWR VGND sky130_ef_sc_hd__decap_12
XFILLER_106_699 VGND VGND VPWR VPWR sky130_fd_sc_hd__fill_1
X_10161_ _03910_ _03911_ _03904_ VGND VGND VPWR VPWR _03912_ sky130_fd_sc_hd__a21o_1
XFILLER_10_97 VPWR VGND VPWR VGND sky130_ef_sc_hd__decap_12
XFILLER_121_669 VGND VGND VPWR VPWR sky130_fd_sc_hd__decap_3
X_10092_ _03723_ _03841_ _03842_ VGND VGND VPWR VPWR _03844_ sky130_fd_sc_hd__or3_2
XFILLER_120_157 VPWR VGND VPWR VGND sky130_ef_sc_hd__decap_12
X_13920_ clknet_leaf_6_clk net901 VGND VGND VPWR VPWR u_interface.u_gelu_fp32.u_synth_top.s1_x\[24\]
+ sky130_fd_sc_hd__dfxtp_1
XFILLER_19_105 VGND VGND VPWR VPWR sky130_fd_sc_hd__decap_6
XFILLER_74_222 VPWR VGND VPWR VGND sky130_ef_sc_hd__decap_12
XFILLER_47_436 VGND VGND VPWR VPWR sky130_fd_sc_hd__fill_2
XFILLER_19_51 VGND VGND VPWR VPWR sky130_fd_sc_hd__decap_4
XFILLER_142_85 VGND VGND VPWR VPWR sky130_fd_sc_hd__decap_8
XTAP_TAPCELL_ROW_126_2352 VGND VPWR sky130_fd_sc_hd__tapvpwrvgnd_1
XPHY_EDGE_ROW_98_Left_254 VGND VGND VPWR VPWR sky130_fd_sc_hd__decap_3
X_13851_ clknet_leaf_58_clk _00861_ VGND VGND VPWR VPWR u_interface.u_gelu_fp32.u_synth_top.s3_b\[7\]
+ sky130_fd_sc_hd__dfxtp_1
XFILLER_90_715 VGND VGND VPWR VPWR sky130_fd_sc_hd__decap_4
XFILLER_74_244 VGND VGND VPWR VPWR sky130_fd_sc_hd__decap_8
XFILLER_63_918 VGND VGND VPWR VPWR sky130_fd_sc_hd__decap_3
X_12802_ net1778 _01789_ _06417_ VGND VGND VPWR VPWR _00961_ sky130_fd_sc_hd__a21oi_1
XFILLER_74_277 VPWR VGND VPWR VGND sky130_ef_sc_hd__decap_12
X_13782_ clknet_leaf_86_clk _00792_ VGND VGND VPWR VPWR u_interface.u_gelu_fp32.s2_data\[16\]
+ sky130_fd_sc_hd__dfxtp_1
X_10994_ _04736_ _04737_ VGND VGND VPWR VPWR _04738_ sky130_fd_sc_hd__and2b_1
X_12733_ net280 _06354_ _06383_ _01696_ VGND VGND VPWR VPWR _06384_ sky130_fd_sc_hd__a22o_1
XFILLER_16_867 VGND VGND VPWR VPWR sky130_fd_sc_hd__fill_1
XFILLER_27_193 VPWR VGND VPWR VGND sky130_ef_sc_hd__decap_12
XFILLER_15_355 VPWR VGND VPWR VGND sky130_ef_sc_hd__decap_12
XFILLER_35_83 VGND VGND VPWR VPWR sky130_fd_sc_hd__fill_1
XTAP_TAPCELL_ROW_104_1993 VGND VPWR sky130_fd_sc_hd__tapvpwrvgnd_1
X_12664_ net1708 u_interface.u_gelu_fp32.u_q16_to_fp32.s2_mag\[19\] net802 VGND VGND
+ VPWR VPWR _00900_ sky130_fd_sc_hd__mux2_1
X_12595_ _06293_ _06297_ VGND VGND VPWR VPWR _06298_ sky130_fd_sc_hd__nor2_1
XTAP_TAPCELL_ROW_13_545 VGND VPWR sky130_fd_sc_hd__tapvpwrvgnd_1
X_11615_ _05351_ _05352_ _05347_ VGND VGND VPWR VPWR _05353_ sky130_fd_sc_hd__a21oi_1
XFILLER_128_246 VGND VGND VPWR VPWR sky130_fd_sc_hd__decap_6
XFILLER_128_224 VGND VGND VPWR VPWR sky130_fd_sc_hd__fill_2
XFILLER_11_561 VPWR VGND VPWR VGND sky130_ef_sc_hd__decap_12
X_11546_ _05284_ _05283_ VGND VGND VPWR VPWR _05285_ sky130_fd_sc_hd__and2b_1
XFILLER_137_780 VGND VGND VPWR VPWR sky130_fd_sc_hd__decap_4
X_13216_ clknet_leaf_41_clk _00226_ VGND VGND VPWR VPWR u_interface.fifo_data\[12\]\[26\]
+ sky130_fd_sc_hd__dfxtp_1
X_11477_ net185 _05126_ _05125_ VGND VGND VPWR VPWR _05216_ sky130_fd_sc_hd__a21o_1
X_10428_ _04140_ _04141_ _04175_ _04176_ VGND VGND VPWR VPWR _04177_ sky130_fd_sc_hd__a22o_1
X_13147_ clknet_leaf_36_clk _00157_ VGND VGND VPWR VPWR u_interface.fifo_tlast\[10\]
+ sky130_fd_sc_hd__dfxtp_1
XFILLER_124_485 VGND VGND VPWR VPWR sky130_fd_sc_hd__decap_3
XFILLER_124_474 VGND VGND VPWR VPWR sky130_fd_sc_hd__fill_2
XFILLER_112_625 VGND VGND VPWR VPWR sky130_fd_sc_hd__decap_8
X_10359_ net474 net715 net722 net478 VGND VGND VPWR VPWR _04108_ sky130_fd_sc_hd__a22o_1
XFILLER_151_293 VPWR VGND VPWR VGND sky130_ef_sc_hd__decap_12
XFILLER_111_113 VGND VGND VPWR VPWR sky130_fd_sc_hd__decap_8
X_13078_ clknet_leaf_75_clk _00088_ VGND VGND VPWR VPWR u_interface.fifo_data\[14\]\[31\]
+ sky130_fd_sc_hd__dfxtp_1
XFILLER_111_157 VGND VGND VPWR VPWR sky130_fd_sc_hd__decap_8
X_12029_ net675 net393 _05687_ _05686_ VGND VGND VPWR VPWR _05762_ sky130_fd_sc_hd__a31o_1
XFILLER_65_211 VGND VGND VPWR VPWR sky130_fd_sc_hd__decap_4
XFILLER_18_3 VPWR VGND VPWR VGND sky130_ef_sc_hd__decap_12
XFILLER_53_406 VGND VGND VPWR VPWR sky130_fd_sc_hd__decap_3
X_07570_ _01540_ _01681_ net311 VGND VGND VPWR VPWR _01682_ sky130_fd_sc_hd__mux2_1
XFILLER_80_225 VGND VGND VPWR VPWR sky130_fd_sc_hd__fill_1
XTAP_TAPCELL_ROW_49_1118 VGND VPWR sky130_fd_sc_hd__tapvpwrvgnd_1
X_06521_ u_interface.fifo_count\[4\] u_interface.in_flight_count\[4\] VGND VGND VPWR
+ VPWR _01121_ sky130_fd_sc_hd__or2_1
XFILLER_80_236 VGND VGND VPWR VPWR sky130_fd_sc_hd__fill_1
X_09240_ _02958_ _02961_ _02998_ VGND VGND VPWR VPWR _02999_ sky130_fd_sc_hd__nand3_1
XTAP_TAPCELL_ROW_62_1329 VGND VPWR sky130_fd_sc_hd__tapvpwrvgnd_1
XFILLER_61_461 VGND VGND VPWR VPWR sky130_fd_sc_hd__fill_2
XFILLER_22_837 VPWR VGND VPWR VGND sky130_ef_sc_hd__decap_12
X_09171_ net605 net501 net506 net613 VGND VGND VPWR VPWR _02930_ sky130_fd_sc_hd__a22oi_2
XTAP_TAPCELL_ROW_32_843 VGND VPWR sky130_fd_sc_hd__tapvpwrvgnd_1
XTAP_TAPCELL_ROW_32_854 VGND VPWR sky130_fd_sc_hd__tapvpwrvgnd_1
XFILLER_147_522 VPWR VGND VPWR VGND sky130_ef_sc_hd__decap_12
XFILLER_119_213 VGND VGND VPWR VPWR sky130_fd_sc_hd__decap_8
X_08122_ _01957_ _01958_ _01962_ VGND VGND VPWR VPWR _01967_ sky130_fd_sc_hd__and3_1
XFILLER_30_881 VPWR VGND VPWR VGND sky130_ef_sc_hd__decap_12
X_08053_ net541 _01909_ net169 VGND VGND VPWR VPWR _01910_ sky130_fd_sc_hd__mux2_1
X_07004_ net1367 net326 net231 VGND VGND VPWR VPWR _00051_ sky130_fd_sc_hd__mux2_1
XFILLER_116_920 VGND VGND VPWR VPWR sky130_fd_sc_hd__fill_1
XPHY_EDGE_ROW_131_Right_131 VGND VGND VPWR VPWR sky130_fd_sc_hd__decap_3
XTAP_TAPCELL_ROW_77_1572 VGND VPWR sky130_fd_sc_hd__tapvpwrvgnd_1
XTAP_TAPCELL_ROW_77_1561 VGND VPWR sky130_fd_sc_hd__tapvpwrvgnd_1
Xinput108 s_axis_tvalid VGND VGND VPWR VPWR net108 sky130_fd_sc_hd__clkbuf_1
X_08955_ _02566_ _02572_ _02571_ VGND VGND VPWR VPWR _02714_ sky130_fd_sc_hd__a21o_1
XFILLER_130_433 VGND VGND VPWR VPWR sky130_fd_sc_hd__decap_6
XFILLER_102_135 VGND VGND VPWR VPWR sky130_fd_sc_hd__decap_4
X_07906_ net775 net90 VGND VGND VPWR VPWR _00665_ sky130_fd_sc_hd__and2_1
XFILLER_130_477 VGND VGND VPWR VPWR sky130_fd_sc_hd__decap_8
XTAP_TAPCELL_ROW_90_1783 VGND VPWR sky130_fd_sc_hd__tapvpwrvgnd_1
XTAP_TAPCELL_ROW_90_1772 VGND VPWR sky130_fd_sc_hd__tapvpwrvgnd_1
XFILLER_29_403 VPWR VGND VPWR VGND sky130_ef_sc_hd__decap_12
X_08886_ _02643_ _02644_ _02642_ VGND VGND VPWR VPWR _02645_ sky130_fd_sc_hd__a21o_1
XTAP_TAPCELL_ROW_108_2060 VGND VPWR sky130_fd_sc_hd__tapvpwrvgnd_1
XFILLER_56_49 VGND VGND VPWR VPWR sky130_fd_sc_hd__decap_3
X_07837_ net379 net1518 net282 VGND VGND VPWR VPWR _00598_ sky130_fd_sc_hd__mux2_1
XFILLER_17_609 VGND VGND VPWR VPWR sky130_fd_sc_hd__decap_6
XFILLER_29_447 VGND VGND VPWR VPWR sky130_fd_sc_hd__fill_1
XTAP_TAPCELL_ROW_108_2071 VGND VPWR sky130_fd_sc_hd__tapvpwrvgnd_1
X_07768_ net1714 _01803_ _01804_ VGND VGND VPWR VPWR _00529_ sky130_fd_sc_hd__a21oi_1
X_09507_ _03243_ _03260_ _03261_ VGND VGND VPWR VPWR _03264_ sky130_fd_sc_hd__or3_2
XFILLER_112_44 VPWR VGND VPWR VGND sky130_ef_sc_hd__decap_12
X_06719_ net322 _01282_ VGND VGND VPWR VPWR _01283_ sky130_fd_sc_hd__or2_1
XFILLER_72_15 VPWR VGND VPWR VGND sky130_ef_sc_hd__decap_12
XFILLER_71_225 VGND VGND VPWR VPWR sky130_fd_sc_hd__decap_3
XFILLER_25_653 VPWR VGND VPWR VGND sky130_ef_sc_hd__decap_12
XTAP_TAPCELL_ROW_121_2271 VGND VPWR sky130_fd_sc_hd__tapvpwrvgnd_1
X_07699_ _01428_ _01755_ VGND VGND VPWR VPWR _01763_ sky130_fd_sc_hd__or2_1
XFILLER_72_48 VGND VGND VPWR VPWR sky130_fd_sc_hd__decap_8
XFILLER_24_141 VGND VGND VPWR VPWR sky130_fd_sc_hd__decap_8
XFILLER_40_601 VPWR VGND VPWR VGND sky130_ef_sc_hd__decap_12
X_09438_ _03194_ _03195_ _03188_ VGND VGND VPWR VPWR _03196_ sky130_fd_sc_hd__a21o_1
XFILLER_25_697 VPWR VGND VPWR VGND sky130_ef_sc_hd__decap_12
X_09369_ _03001_ _03003_ _03005_ VGND VGND VPWR VPWR _03128_ sky130_fd_sc_hd__or3_1
XFILLER_138_533 VGND VGND VPWR VPWR sky130_fd_sc_hd__decap_6
X_11400_ _05129_ _05139_ VGND VGND VPWR VPWR _05140_ sky130_fd_sc_hd__and2b_1
X_12380_ _06071_ _06107_ VGND VGND VPWR VPWR _06108_ sky130_fd_sc_hd__or2_1
XFILLER_153_503 VGND VGND VPWR VPWR sky130_fd_sc_hd__fill_1
XFILLER_20_380 VPWR VGND VPWR VGND sky130_ef_sc_hd__decap_12
X_11331_ _05065_ _05070_ VGND VGND VPWR VPWR _05072_ sky130_fd_sc_hd__xor2_1
XFILLER_119_780 VGND VGND VPWR VPWR sky130_fd_sc_hd__fill_1
XFILLER_4_513 VPWR VGND VPWR VGND sky130_ef_sc_hd__decap_12
X_14050_ clknet_leaf_17_clk _00976_ VGND VGND VPWR VPWR u_interface.u_gelu_fp32.u_fp32_to_q16.s1_mant\[12\]
+ sky130_fd_sc_hd__dfxtp_1
X_11262_ _04945_ _05003_ VGND VGND VPWR VPWR _05004_ sky130_fd_sc_hd__xor2_2
XFILLER_4_557 VPWR VGND VPWR VGND sky130_ef_sc_hd__decap_12
XFILLER_121_411 VPWR VGND VPWR VGND sky130_ef_sc_hd__decap_12
XFILLER_121_400 VGND VGND VPWR VPWR sky130_fd_sc_hd__fill_1
XFILLER_106_474 VGND VGND VPWR VPWR sky130_fd_sc_hd__fill_2
X_13001_ net1129 net348 net224 VGND VGND VPWR VPWR _01084_ sky130_fd_sc_hd__mux2_1
X_10213_ _03854_ _03856_ VGND VGND VPWR VPWR _03964_ sky130_fd_sc_hd__and2b_1
X_11193_ _04929_ _04934_ VGND VGND VPWR VPWR _04935_ sky130_fd_sc_hd__nor2_1
X_10144_ net465 net673 net682 net469 VGND VGND VPWR VPWR _03895_ sky130_fd_sc_hd__a22o_1
XFILLER_0_741 VPWR VGND VPWR VGND sky130_ef_sc_hd__decap_12
XFILLER_153_51 VGND VGND VPWR VPWR sky130_fd_sc_hd__decap_4
XFILLER_121_477 VGND VGND VPWR VPWR sky130_fd_sc_hd__decap_6
XFILLER_95_818 VGND VGND VPWR VPWR sky130_fd_sc_hd__fill_1
XFILLER_67_509 VGND VGND VPWR VPWR sky130_fd_sc_hd__fill_1
X_10075_ net463 net657 _03824_ _03825_ VGND VGND VPWR VPWR _03827_ sky130_fd_sc_hd__nand4_1
XFILLER_87_391 VGND VGND VPWR VPWR sky130_fd_sc_hd__fill_1
XFILLER_48_723 VGND VGND VPWR VPWR sky130_fd_sc_hd__fill_1
XFILLER_0_785 VPWR VGND VPWR VGND sky130_ef_sc_hd__decap_12
X_13903_ clknet_leaf_22_clk net880 VGND VGND VPWR VPWR u_interface.u_gelu_fp32.u_synth_top.s1_x\[7\]
+ sky130_fd_sc_hd__dfxtp_1
XFILLER_47_233 VPWR VGND VPWR VGND sky130_ef_sc_hd__decap_12
XFILLER_46_60 VGND VGND VPWR VPWR sky130_fd_sc_hd__fill_1
XTAP_TAPCELL_ROW_18_626 VGND VPWR sky130_fd_sc_hd__tapvpwrvgnd_1
X_13834_ clknet_leaf_78_clk _00844_ VGND VGND VPWR VPWR u_interface.u_gelu_fp32.u_synth_top.s3_mult\[52\]
+ sky130_fd_sc_hd__dfxtp_1
X_13765_ clknet_leaf_27_clk _00775_ VGND VGND VPWR VPWR u_interface.u_gelu_fp32.s2_valid
+ sky130_fd_sc_hd__dfxtp_1
X_10977_ net694 net448 VGND VGND VPWR VPWR _04721_ sky130_fd_sc_hd__nand2_1
XFILLER_149_809 VGND VGND VPWR VPWR sky130_fd_sc_hd__decap_4
X_13696_ clknet_leaf_13_clk net931 VGND VGND VPWR VPWR u_interface.u_gelu_fp32.u_fp32_to_q16.s3_overflow
+ sky130_fd_sc_hd__dfxtp_1
XFILLER_70_280 VGND VGND VPWR VPWR sky130_fd_sc_hd__decap_6
X_12716_ u_interface.u_gelu_fp32.u_q16_to_fp32.s2_mag\[24\] u_interface.u_gelu_fp32.u_q16_to_fp32.s2_mag\[23\]
+ net337 VGND VGND VPWR VPWR _06370_ sky130_fd_sc_hd__mux2_1
XTAP_TAPCELL_ROW_44_1037 VGND VPWR sky130_fd_sc_hd__tapvpwrvgnd_1
XFILLER_15_174 VPWR VGND VPWR VGND sky130_ef_sc_hd__decap_12
XTAP_TAPCELL_ROW_139_2565 VGND VPWR sky130_fd_sc_hd__tapvpwrvgnd_1
XTAP_TAPCELL_ROW_139_2554 VGND VPWR sky130_fd_sc_hd__tapvpwrvgnd_1
X_12647_ u_interface.u_gelu_fp32.u_q16_to_fp32.s1_mag\[2\] net1688 net806 VGND VGND
+ VPWR VPWR _00883_ sky130_fd_sc_hd__mux2_1
XFILLER_12_881 VPWR VGND VPWR VGND sky130_ef_sc_hd__decap_12
X_12578_ net15 net20 net22 net21 VGND VGND VPWR VPWR _06282_ sky130_fd_sc_hd__or4_2
XFILLER_7_340 VPWR VGND VPWR VGND sky130_ef_sc_hd__decap_12
XTAP_TAPCELL_ROW_152_2765 VGND VPWR sky130_fd_sc_hd__tapvpwrvgnd_1
XFILLER_116_227 VGND VGND VPWR VPWR sky130_fd_sc_hd__fill_1
XFILLER_116_205 VGND VGND VPWR VPWR sky130_fd_sc_hd__decap_6
Xhold307 u_interface.fifo_data\[10\]\[9\] VGND VGND VPWR VPWR net1172 sky130_fd_sc_hd__dlygate4sd3_1
X_11529_ net650 net402 net398 net642 VGND VGND VPWR VPWR _05268_ sky130_fd_sc_hd__a22oi_1
Xhold329 u_interface.fifo_data\[1\]\[29\] VGND VGND VPWR VPWR net1194 sky130_fd_sc_hd__dlygate4sd3_1
Xhold318 u_interface.fifo_data\[0\]\[18\] VGND VGND VPWR VPWR net1183 sky130_fd_sc_hd__dlygate4sd3_1
XFILLER_125_783 VGND VGND VPWR VPWR sky130_fd_sc_hd__fill_1
XTAP_TAPCELL_ROW_59_1280 VGND VPWR sky130_fd_sc_hd__tapvpwrvgnd_1
XFILLER_112_444 VPWR VGND VPWR VGND sky130_ef_sc_hd__decap_12
XFILLER_112_411 VGND VGND VPWR VPWR sky130_fd_sc_hd__fill_1
XFILLER_98_645 VGND VGND VPWR VPWR sky130_fd_sc_hd__decap_6
Xfanout809 net2 VGND VGND VPWR VPWR net809 sky130_fd_sc_hd__buf_2
XFILLER_112_477 VGND VGND VPWR VPWR sky130_fd_sc_hd__decap_6
XFILLER_98_689 VGND VGND VPWR VPWR sky130_fd_sc_hd__fill_2
XTAP_TAPCELL_ROW_72_1480 VGND VPWR sky130_fd_sc_hd__tapvpwrvgnd_1
X_08740_ _02497_ _02498_ _02491_ VGND VGND VPWR VPWR _02499_ sky130_fd_sc_hd__a21o_1
XFILLER_97_199 VGND VGND VPWR VPWR sky130_fd_sc_hd__decap_4
XTAP_TAPCELL_ROW_72_1491 VGND VPWR sky130_fd_sc_hd__tapvpwrvgnd_1
XFILLER_94_840 VGND VGND VPWR VPWR sky130_fd_sc_hd__fill_1
X_08671_ _02280_ _02333_ _02277_ VGND VGND VPWR VPWR _02433_ sky130_fd_sc_hd__o21ai_1
XFILLER_93_372 VGND VGND VPWR VPWR sky130_fd_sc_hd__fill_1
X_07622_ net331 _01712_ _01713_ net307 VGND VGND VPWR VPWR _01714_ sky130_fd_sc_hd__o211a_1
XFILLER_66_597 VGND VGND VPWR VPWR sky130_fd_sc_hd__fill_2
XTAP_TAPCELL_ROW_37_924 VGND VPWR sky130_fd_sc_hd__tapvpwrvgnd_1
XFILLER_38_277 VGND VGND VPWR VPWR sky130_fd_sc_hd__decap_8
XFILLER_19_491 VGND VGND VPWR VPWR sky130_fd_sc_hd__decap_3
XTAP_TAPCELL_ROW_37_935 VGND VPWR sky130_fd_sc_hd__tapvpwrvgnd_1
X_07553_ _01623_ _01617_ net544 VGND VGND VPWR VPWR _01669_ sky130_fd_sc_hd__mux2_1
XFILLER_22_601 VPWR VGND VPWR VGND sky130_ef_sc_hd__decap_12
X_07484_ _01615_ _01616_ net552 VGND VGND VPWR VPWR _01617_ sky130_fd_sc_hd__mux2_1
X_06504_ net827 VGND VGND VPWR VPWR _01104_ sky130_fd_sc_hd__inv_2
XFILLER_21_111 VGND VGND VPWR VPWR sky130_fd_sc_hd__fill_1
XFILLER_34_494 VGND VGND VPWR VPWR sky130_fd_sc_hd__fill_2
X_09223_ _02979_ _02980_ _02965_ VGND VGND VPWR VPWR _02982_ sky130_fd_sc_hd__a21o_1
XFILLER_22_645 VPWR VGND VPWR VGND sky130_ef_sc_hd__decap_12
XFILLER_42_29 VGND VGND VPWR VPWR sky130_fd_sc_hd__fill_1
X_09154_ _02861_ _02870_ _02909_ _02911_ VGND VGND VPWR VPWR _02913_ sky130_fd_sc_hd__o211ai_1
XTAP_TAPCELL_ROW_79_1601 VGND VPWR sky130_fd_sc_hd__tapvpwrvgnd_1
XFILLER_147_330 VGND VGND VPWR VPWR sky130_fd_sc_hd__decap_6
X_08105_ _01942_ _01943_ _01948_ net313 VGND VGND VPWR VPWR _01953_ sky130_fd_sc_hd__a31o_1
X_09085_ _02788_ _02835_ _02840_ VGND VGND VPWR VPWR _02844_ sky130_fd_sc_hd__a21o_1
Xinput90 s_axis_tdata[24] VGND VGND VPWR VPWR net90 sky130_fd_sc_hd__clkbuf_1
XFILLER_135_569 VGND VGND VPWR VPWR sky130_fd_sc_hd__decap_4
X_08036_ u_interface.u_gelu_fp32.u_fp32_to_q16.s3_mag\[29\] _01892_ VGND VGND VPWR
+ VPWR _01893_ sky130_fd_sc_hd__and2_1
XTAP_TAPCELL_ROW_92_1812 VGND VPWR sky130_fd_sc_hd__tapvpwrvgnd_1
XTAP_TAPCELL_ROW_92_1801 VGND VPWR sky130_fd_sc_hd__tapvpwrvgnd_1
Xhold830 _00894_ VGND VGND VPWR VPWR net1695 sky130_fd_sc_hd__dlygate4sd3_1
XFILLER_107_11 VGND VGND VPWR VPWR sky130_fd_sc_hd__fill_2
Xhold841 u_interface.u_gelu_fp32.u_q16_to_fp32.s3_norm_mag\[12\] VGND VGND VPWR VPWR
+ net1706 sky130_fd_sc_hd__dlygate4sd3_1
Xhold852 _00904_ VGND VGND VPWR VPWR net1717 sky130_fd_sc_hd__dlygate4sd3_1
XFILLER_1_505 VPWR VGND VPWR VGND sky130_ef_sc_hd__decap_12
Xhold863 u_interface.u_gelu_fp32.s2_data\[30\] VGND VGND VPWR VPWR net1728 sky130_fd_sc_hd__dlygate4sd3_1
Xhold885 u_interface.in_flight_count\[0\] VGND VGND VPWR VPWR net1750 sky130_fd_sc_hd__dlygate4sd3_1
Xhold874 u_interface.u_gelu_fp32.u_fp32_to_q16.s3_frac\[26\] VGND VGND VPWR VPWR net1739
+ sky130_fd_sc_hd__dlygate4sd3_1
XFILLER_115_271 VGND VGND VPWR VPWR sky130_fd_sc_hd__fill_1
XFILLER_107_33 VGND VGND VPWR VPWR sky130_fd_sc_hd__fill_2
Xhold896 u_interface.u_gelu_fp32.u_synth_top.s2_b\[10\] VGND VGND VPWR VPWR net1761
+ sky130_fd_sc_hd__dlygate4sd3_1
XFILLER_88_122 VGND VGND VPWR VPWR sky130_fd_sc_hd__fill_2
XFILLER_107_99 VGND VGND VPWR VPWR sky130_fd_sc_hd__fill_1
XFILLER_103_466 VPWR VGND VPWR VGND sky130_ef_sc_hd__decap_12
X_09987_ _03738_ _03739_ VGND VGND VPWR VPWR _03740_ sky130_fd_sc_hd__and2b_1
XFILLER_89_689 VPWR VGND VPWR VGND sky130_ef_sc_hd__decap_12
XFILLER_89_667 VGND VGND VPWR VPWR sky130_fd_sc_hd__decap_4
XFILLER_67_15 VPWR VGND VPWR VGND sky130_ef_sc_hd__decap_12
X_08938_ _02676_ _02693_ _02694_ VGND VGND VPWR VPWR _02697_ sky130_fd_sc_hd__or3_2
XFILLER_88_177 VPWR VGND VPWR VGND sky130_ef_sc_hd__decap_12
XFILLER_69_380 VGND VGND VPWR VPWR sky130_fd_sc_hd__fill_1
XFILLER_29_200 VGND VGND VPWR VPWR sky130_fd_sc_hd__fill_2
X_08869_ _02552_ _02553_ _02578_ _02597_ VGND VGND VPWR VPWR _02628_ sky130_fd_sc_hd__a211o_1
XFILLER_69_391 VGND VGND VPWR VPWR sky130_fd_sc_hd__fill_1
XTAP_TAPCELL_ROW_123_2311 VGND VPWR sky130_fd_sc_hd__tapvpwrvgnd_1
XTAP_TAPCELL_ROW_123_2300 VGND VPWR sky130_fd_sc_hd__tapvpwrvgnd_1
XFILLER_85_895 VGND VGND VPWR VPWR sky130_fd_sc_hd__fill_1
XFILLER_72_501 VGND VGND VPWR VPWR sky130_fd_sc_hd__fill_1
X_10900_ _04615_ _04616_ _04642_ _04643_ VGND VGND VPWR VPWR _04645_ sky130_fd_sc_hd__nand4_1
XTAP_TAPCELL_ROW_4_398 VGND VPWR sky130_fd_sc_hd__tapvpwrvgnd_1
XFILLER_83_36 VPWR VGND VPWR VGND sky130_ef_sc_hd__decap_12
XFILLER_44_247 VGND VGND VPWR VPWR sky130_fd_sc_hd__fill_1
X_11880_ _05527_ _05536_ _05535_ VGND VGND VPWR VPWR _05615_ sky130_fd_sc_hd__a21boi_1
XFILLER_60_707 VGND VGND VPWR VPWR sky130_fd_sc_hd__fill_1
X_10831_ _04574_ _04575_ VGND VGND VPWR VPWR _04576_ sky130_fd_sc_hd__xnor2_1
XFILLER_16_41 VPWR VGND VPWR VGND sky130_ef_sc_hd__decap_12
X_13550_ clknet_leaf_45_clk _00560_ VGND VGND VPWR VPWR u_interface.fifo_data\[5\]\[29\]
+ sky130_fd_sc_hd__dfxtp_1
X_10762_ _04506_ _04507_ _04490_ VGND VGND VPWR VPWR _04508_ sky130_fd_sc_hd__a21o_1
XPHY_EDGE_ROW_11_Right_11 VGND VGND VPWR VPWR sky130_fd_sc_hd__decap_3
XFILLER_16_85 VPWR VGND VPWR VGND sky130_ef_sc_hd__decap_12
XTAP_TAPCELL_ROW_101_1952 VGND VPWR sky130_fd_sc_hd__tapvpwrvgnd_1
X_13481_ clknet_leaf_4_clk _00491_ VGND VGND VPWR VPWR u_interface.u_gelu_fp32.u_synth_top.s2_b\[12\]
+ sky130_fd_sc_hd__dfxtp_1
X_12501_ _06190_ _06193_ _06225_ VGND VGND VPWR VPWR _06226_ sky130_fd_sc_hd__nor3_1
XFILLER_12_133 VGND VGND VPWR VPWR sky130_fd_sc_hd__decap_6
X_10693_ _04435_ _04437_ _04439_ VGND VGND VPWR VPWR _04440_ sky130_fd_sc_hd__and3_1
X_12432_ _06105_ _06106_ _06108_ VGND VGND VPWR VPWR _06159_ sky130_fd_sc_hd__o21a_1
XFILLER_40_475 VGND VGND VPWR VPWR sky130_fd_sc_hd__fill_1
XFILLER_138_341 VGND VGND VPWR VPWR sky130_fd_sc_hd__fill_2
XFILLER_12_188 VGND VGND VPWR VPWR sky130_fd_sc_hd__decap_8
XFILLER_32_62 VGND VGND VPWR VPWR sky130_fd_sc_hd__fill_1
XFILLER_139_897 VGND VGND VPWR VPWR sky130_fd_sc_hd__decap_6
X_12363_ _05958_ _06090_ VGND VGND VPWR VPWR _06091_ sky130_fd_sc_hd__nand2_1
XFILLER_5_833 VGND VGND VPWR VPWR sky130_fd_sc_hd__decap_6
XTAP_TAPCELL_ROW_134_2484 VGND VPWR sky130_fd_sc_hd__tapvpwrvgnd_1
XTAP_TAPCELL_ROW_134_2473 VGND VPWR sky130_fd_sc_hd__tapvpwrvgnd_1
X_14102_ clknet_leaf_27_clk _01028_ VGND VGND VPWR VPWR u_interface.meta_tuser_pipe\[5\]
+ sky130_fd_sc_hd__dfxtp_1
X_11314_ _04952_ _04954_ _04953_ VGND VGND VPWR VPWR _05055_ sky130_fd_sc_hd__a21bo_1
X_12294_ _06020_ _06021_ VGND VGND VPWR VPWR _06023_ sky130_fd_sc_hd__xnor2_1
XFILLER_4_321 VPWR VGND VPWR VGND sky130_ef_sc_hd__decap_12
X_14033_ clknet_leaf_43_clk _00959_ VGND VGND VPWR VPWR u_interface.core_data_out\[19\]
+ sky130_fd_sc_hd__dfxtp_1
XFILLER_5_877 VPWR VGND VPWR VGND sky130_ef_sc_hd__decap_12
XFILLER_4_365 VPWR VGND VPWR VGND sky130_ef_sc_hd__decap_12
X_11245_ net602 u_interface.u_gelu_fp32.u_synth_top.s2_dx\[30\] _04985_ VGND VGND
+ VPWR VPWR _04987_ sky130_fd_sc_hd__and3_1
XPHY_EDGE_ROW_20_Right_20 VGND VGND VPWR VPWR sky130_fd_sc_hd__decap_3
XFILLER_121_230 VGND VGND VPWR VPWR sky130_fd_sc_hd__fill_2
XFILLER_95_615 VGND VGND VPWR VPWR sky130_fd_sc_hd__fill_1
XFILLER_79_144 VGND VGND VPWR VPWR sky130_fd_sc_hd__decap_3
XFILLER_68_829 VGND VGND VPWR VPWR sky130_fd_sc_hd__decap_3
X_11176_ _04801_ _04805_ _04917_ VGND VGND VPWR VPWR _04918_ sky130_fd_sc_hd__o21ai_1
XFILLER_94_103 VPWR VGND VPWR VGND sky130_ef_sc_hd__decap_12
X_10127_ _03864_ _03875_ _03876_ VGND VGND VPWR VPWR _03878_ sky130_fd_sc_hd__and3_1
XFILLER_67_328 VGND VGND VPWR VPWR sky130_fd_sc_hd__fill_2
X_10058_ _03806_ _03809_ VGND VGND VPWR VPWR _03810_ sky130_fd_sc_hd__xnor2_1
XFILLER_48_531 VGND VGND VPWR VPWR sky130_fd_sc_hd__fill_1
XFILLER_63_501 VGND VGND VPWR VPWR sky130_fd_sc_hd__decap_3
XFILLER_35_225 VGND VGND VPWR VPWR sky130_fd_sc_hd__decap_4
X_13817_ clknet_leaf_85_clk _00827_ VGND VGND VPWR VPWR u_interface.u_gelu_fp32.u_synth_top.s3_mult\[35\]
+ sky130_fd_sc_hd__dfxtp_1
XFILLER_51_729 VGND VGND VPWR VPWR sky130_fd_sc_hd__decap_6
X_13748_ clknet_leaf_87_clk _00758_ VGND VGND VPWR VPWR u_interface.u_gelu_fp32.u_q16_to_fp32.s1_mag\[14\]
+ sky130_fd_sc_hd__dfxtp_1
XFILLER_31_431 VPWR VGND VPWR VGND sky130_ef_sc_hd__decap_12
XFILLER_31_453 VGND VGND VPWR VPWR sky130_fd_sc_hd__fill_1
XTAP_TAPCELL_ROW_154_2805 VGND VPWR sky130_fd_sc_hd__tapvpwrvgnd_1
X_13679_ clknet_leaf_12_clk _00689_ VGND VGND VPWR VPWR u_interface.u_gelu_fp32.u_fp32_to_q16.s3_frac\[15\]
+ sky130_fd_sc_hd__dfxtp_1
XFILLER_85_3 VPWR VGND VPWR VGND sky130_ef_sc_hd__decap_12
XFILLER_145_801 VGND VGND VPWR VPWR sky130_fd_sc_hd__fill_1
XFILLER_129_363 VGND VGND VPWR VPWR sky130_fd_sc_hd__decap_4
XFILLER_117_536 VPWR VGND VPWR VGND sky130_ef_sc_hd__decap_12
Xhold126 u_interface.fifo_tlast\[2\] VGND VGND VPWR VPWR net991 sky130_fd_sc_hd__dlygate4sd3_1
Xhold104 u_interface.u_gelu_fp32.u_fp32_to_q16.s3_frac\[21\] VGND VGND VPWR VPWR net969
+ sky130_fd_sc_hd__dlygate4sd3_1
XFILLER_8_693 VGND VGND VPWR VPWR sky130_fd_sc_hd__decap_6
XFILLER_7_181 VPWR VGND VPWR VGND sky130_ef_sc_hd__decap_12
Xhold115 u_interface.fifo_data\[13\]\[6\] VGND VGND VPWR VPWR net980 sky130_fd_sc_hd__dlygate4sd3_1
Xhold159 u_interface.fifo_data\[14\]\[22\] VGND VGND VPWR VPWR net1024 sky130_fd_sc_hd__dlygate4sd3_1
Xhold148 u_interface.fifo_data\[10\]\[16\] VGND VGND VPWR VPWR net1013 sky130_fd_sc_hd__dlygate4sd3_1
Xhold137 u_interface.fifo_data\[5\]\[13\] VGND VGND VPWR VPWR net1002 sky130_fd_sc_hd__dlygate4sd3_1
X_09910_ _03652_ _03653_ _03662_ VGND VGND VPWR VPWR _03663_ sky130_fd_sc_hd__a21o_1
XTAP_TAPCELL_ROW_74_1520 VGND VPWR sky130_fd_sc_hd__tapvpwrvgnd_1
Xfanout606 net607 VGND VGND VPWR VPWR net606 sky130_fd_sc_hd__buf_2
XFILLER_113_742 VGND VGND VPWR VPWR sky130_fd_sc_hd__fill_2
Xfanout639 net640 VGND VGND VPWR VPWR net639 sky130_fd_sc_hd__buf_2
XFILLER_112_230 VGND VGND VPWR VPWR sky130_fd_sc_hd__fill_1
X_09841_ _03448_ _03451_ VGND VGND VPWR VPWR _03595_ sky130_fd_sc_hd__nand2_1
Xfanout628 net632 VGND VGND VPWR VPWR net628 sky130_fd_sc_hd__clkbuf_2
Xfanout617 net624 VGND VGND VPWR VPWR net617 sky130_fd_sc_hd__buf_2
X_06984_ net1143 net327 net263 VGND VGND VPWR VPWR _00043_ sky130_fd_sc_hd__mux2_1
XFILLER_140_583 VGND VGND VPWR VPWR sky130_fd_sc_hd__decap_4
X_09772_ _03524_ _03526_ VGND VGND VPWR VPWR _03527_ sky130_fd_sc_hd__nand2_1
XFILLER_85_125 VGND VGND VPWR VPWR sky130_fd_sc_hd__decap_6
XFILLER_85_103 VGND VGND VPWR VPWR sky130_fd_sc_hd__fill_1
XFILLER_58_339 VGND VGND VPWR VPWR sky130_fd_sc_hd__fill_1
X_08723_ net605 net614 net476 net480 VGND VGND VPWR VPWR _02482_ sky130_fd_sc_hd__and4_1
XFILLER_100_447 VPWR VGND VPWR VGND sky130_ef_sc_hd__decap_12
XFILLER_39_542 VGND VGND VPWR VPWR sky130_fd_sc_hd__fill_1
X_08654_ net156 _02420_ VGND VGND VPWR VPWR _02421_ sky130_fd_sc_hd__nand2_1
XTAP_TAPCELL_ROW_1_346 VGND VPWR sky130_fd_sc_hd__tapvpwrvgnd_1
XTAP_TAPCELL_ROW_1_357 VGND VPWR sky130_fd_sc_hd__tapvpwrvgnd_1
XFILLER_26_214 VPWR VGND VPWR VGND sky130_ef_sc_hd__decap_12
X_08585_ _02204_ _02221_ VGND VGND VPWR VPWR _02371_ sky130_fd_sc_hd__xnor2_1
X_07605_ net338 u_interface.u_gelu_fp32.u_q16_to_fp32.s2_mag\[1\] VGND VGND VPWR VPWR
+ _01700_ sky130_fd_sc_hd__nor2_1
XFILLER_82_898 VGND VGND VPWR VPWR sky130_fd_sc_hd__decap_4
X_07536_ net821 net1670 net305 _01614_ VGND VGND VPWR VPWR _00441_ sky130_fd_sc_hd__a22o_1
XTAP_TAPCELL_ROW_85_1693 VGND VPWR sky130_fd_sc_hd__tapvpwrvgnd_1
XFILLER_53_39 VPWR VGND VPWR VGND sky130_ef_sc_hd__decap_12
X_09206_ net630 net639 net514 net518 VGND VGND VPWR VPWR _02965_ sky130_fd_sc_hd__and4_1
X_07467_ _01544_ _01546_ net555 VGND VGND VPWR VPWR _01601_ sky130_fd_sc_hd__mux2_1
XFILLER_139_149 VGND VGND VPWR VPWR sky130_fd_sc_hd__fill_1
X_07398_ net1138 net562 net237 VGND VGND VPWR VPWR _00428_ sky130_fd_sc_hd__mux2_1
XFILLER_10_637 VGND VGND VPWR VPWR sky130_fd_sc_hd__decap_6
X_09137_ _02893_ _02894_ _02891_ VGND VGND VPWR VPWR _02896_ sky130_fd_sc_hd__a21bo_1
XFILLER_108_503 VGND VGND VPWR VPWR sky130_fd_sc_hd__fill_1
XTAP_TAPCELL_ROW_20_654 VGND VPWR sky130_fd_sc_hd__tapvpwrvgnd_1
X_09068_ _02772_ _02774_ VGND VGND VPWR VPWR _02827_ sky130_fd_sc_hd__xnor2_2
XFILLER_135_377 VPWR VGND VPWR VGND sky130_ef_sc_hd__decap_12
X_08019_ u_interface.u_gelu_fp32.u_fp32_to_q16.s3_mag\[5\] _01875_ VGND VGND VPWR
+ VPWR _01876_ sky130_fd_sc_hd__and2_1
XTAP_TAPCELL_ROW_116_2192 VGND VPWR sky130_fd_sc_hd__tapvpwrvgnd_1
XFILLER_2_825 VPWR VGND VPWR VGND sky130_ef_sc_hd__decap_12
Xhold671 u_interface.fifo_data\[11\]\[26\] VGND VGND VPWR VPWR net1536 sky130_fd_sc_hd__dlygate4sd3_1
Xhold660 u_interface.u_gelu_fp32.u_fp32_to_q16.s3_frac\[6\] VGND VGND VPWR VPWR net1525
+ sky130_fd_sc_hd__dlygate4sd3_1
XFILLER_78_36 VPWR VGND VPWR VGND sky130_ef_sc_hd__decap_12
XFILLER_150_369 VPWR VGND VPWR VGND sky130_ef_sc_hd__decap_12
XFILLER_131_561 VGND VGND VPWR VPWR sky130_fd_sc_hd__fill_1
Xhold693 u_interface.fifo_data\[4\]\[23\] VGND VGND VPWR VPWR net1558 sky130_fd_sc_hd__dlygate4sd3_1
X_11030_ _04771_ _04772_ VGND VGND VPWR VPWR _04774_ sky130_fd_sc_hd__xnor2_1
Xhold682 u_interface.fifo_data\[7\]\[8\] VGND VGND VPWR VPWR net1547 sky130_fd_sc_hd__dlygate4sd3_1
XTAP_TAPCELL_ROW_9_479 VGND VPWR sky130_fd_sc_hd__tapvpwrvgnd_1
XFILLER_1_335 VGND VGND VPWR VPWR sky130_fd_sc_hd__fill_1
XFILLER_2_869 VPWR VGND VPWR VGND sky130_ef_sc_hd__decap_12
XFILLER_89_486 VGND VGND VPWR VPWR sky130_fd_sc_hd__fill_2
XFILLER_134_75 VGND VGND VPWR VPWR sky130_fd_sc_hd__fill_1
X_12981_ _06496_ _06497_ VGND VGND VPWR VPWR _01064_ sky130_fd_sc_hd__nor2_1
XFILLER_17_225 VGND VGND VPWR VPWR sky130_fd_sc_hd__decap_8
XFILLER_18_737 VPWR VGND VPWR VGND sky130_ef_sc_hd__decap_12
XFILLER_27_51 VGND VGND VPWR VPWR sky130_fd_sc_hd__decap_4
X_11932_ net202 _05665_ VGND VGND VPWR VPWR _05666_ sky130_fd_sc_hd__xnor2_1
XFILLER_150_41 VPWR VGND VPWR VGND sky130_ef_sc_hd__decap_12
XFILLER_60_504 VPWR VGND VPWR VGND sky130_ef_sc_hd__decap_12
X_11863_ _05587_ _05595_ VGND VGND VPWR VPWR _05598_ sky130_fd_sc_hd__nand2_1
XTAP_TAPCELL_ROW_28_776 VGND VPWR sky130_fd_sc_hd__tapvpwrvgnd_1
XFILLER_33_729 VPWR VGND VPWR VGND sky130_ef_sc_hd__decap_12
X_13602_ clknet_leaf_26_clk _00612_ VGND VGND VPWR VPWR u_interface.fifo_data\[3\]\[17\]
+ sky130_fd_sc_hd__dfxtp_1
X_10814_ _04448_ _04450_ VGND VGND VPWR VPWR _04559_ sky130_fd_sc_hd__nand2_1
XFILLER_26_781 VPWR VGND VPWR VGND sky130_ef_sc_hd__decap_12
XTAP_TAPCELL_ROW_28_787 VGND VPWR sky130_fd_sc_hd__tapvpwrvgnd_1
X_11794_ net650 net391 VGND VGND VPWR VPWR _05530_ sky130_fd_sc_hd__nand2_1
XTAP_TAPCELL_ROW_136_2513 VGND VPWR sky130_fd_sc_hd__tapvpwrvgnd_1
X_13533_ clknet_leaf_63_clk _00543_ VGND VGND VPWR VPWR u_interface.fifo_data\[5\]\[12\]
+ sky130_fd_sc_hd__dfxtp_1
X_10745_ _04398_ _04403_ _04404_ VGND VGND VPWR VPWR _04491_ sky130_fd_sc_hd__a21bo_1
XFILLER_43_72 VGND VGND VPWR VPWR sky130_fd_sc_hd__decap_8
X_10676_ _04420_ _04421_ _04302_ _04304_ VGND VGND VPWR VPWR _04423_ sky130_fd_sc_hd__o211a_1
X_13464_ clknet_leaf_60_clk _00474_ VGND VGND VPWR VPWR u_interface.u_gelu_fp32.u_q16_to_fp32.s3_norm_mag\[4\]
+ sky130_fd_sc_hd__dfxtp_1
XFILLER_9_446 VGND VGND VPWR VPWR sky130_fd_sc_hd__fill_2
X_13395_ clknet_leaf_71_clk _00405_ VGND VGND VPWR VPWR u_interface.fifo_data\[6\]\[8\]
+ sky130_fd_sc_hd__dfxtp_1
X_12415_ _06089_ _06091_ _06140_ VGND VGND VPWR VPWR _06142_ sky130_fd_sc_hd__a21o_1
XFILLER_154_642 VGND VGND VPWR VPWR sky130_fd_sc_hd__fill_2
XFILLER_127_845 VGND VGND VPWR VPWR sky130_fd_sc_hd__fill_1
XFILLER_5_641 VPWR VGND VPWR VGND sky130_ef_sc_hd__decap_12
X_12346_ net200 _06072_ VGND VGND VPWR VPWR _06074_ sky130_fd_sc_hd__xnor2_1
XFILLER_127_889 VGND VGND VPWR VPWR sky130_fd_sc_hd__decap_6
XFILLER_114_506 VGND VGND VPWR VPWR sky130_fd_sc_hd__fill_2
XFILLER_153_185 VGND VGND VPWR VPWR sky130_fd_sc_hd__fill_1
XFILLER_5_685 VPWR VGND VPWR VGND sky130_ef_sc_hd__decap_12
X_12277_ net200 _06005_ VGND VGND VPWR VPWR _06006_ sky130_fd_sc_hd__nor2_1
XFILLER_141_369 VPWR VGND VPWR VGND sky130_ef_sc_hd__decap_12
X_14016_ clknet_leaf_70_clk _00942_ VGND VGND VPWR VPWR u_interface.core_data_out\[2\]
+ sky130_fd_sc_hd__dfxtp_1
XFILLER_4_195 VGND VGND VPWR VPWR sky130_fd_sc_hd__fill_1
XFILLER_4_77 VGND VGND VPWR VPWR sky130_fd_sc_hd__decap_6
X_11228_ net651 net416 net412 net643 VGND VGND VPWR VPWR _04970_ sky130_fd_sc_hd__a22o_1
XFILLER_95_423 VGND VGND VPWR VPWR sky130_fd_sc_hd__fill_1
X_11159_ _04793_ _04900_ VGND VGND VPWR VPWR _04902_ sky130_fd_sc_hd__xnor2_1
XTAP_TAPCELL_ROW_52_1169 VGND VPWR sky130_fd_sc_hd__tapvpwrvgnd_1
XTAP_TAPCELL_ROW_147_2686 VGND VPWR sky130_fd_sc_hd__tapvpwrvgnd_1
XFILLER_67_169 VGND VGND VPWR VPWR sky130_fd_sc_hd__fill_2
XFILLER_48_361 VGND VGND VPWR VPWR sky130_fd_sc_hd__decap_3
XFILLER_36_501 VGND VGND VPWR VPWR sky130_fd_sc_hd__decap_6
XFILLER_82_139 VGND VGND VPWR VPWR sky130_fd_sc_hd__fill_1
XFILLER_91_673 VGND VGND VPWR VPWR sky130_fd_sc_hd__decap_3
XFILLER_36_556 VGND VGND VPWR VPWR sky130_fd_sc_hd__fill_1
X_08370_ net524 u_interface.u_gelu_fp32.u_synth_top.s3_mult\[60\] VGND VGND VPWR VPWR
+ _02161_ sky130_fd_sc_hd__xnor2_1
XFILLER_36_589 VPWR VGND VPWR VGND sky130_ef_sc_hd__decap_12
X_07321_ net1330 net349 net254 VGND VGND VPWR VPWR _00351_ sky130_fd_sc_hd__mux2_1
XFILLER_51_559 VGND VGND VPWR VPWR sky130_fd_sc_hd__fill_1
X_07252_ net1176 net353 net251 VGND VGND VPWR VPWR _00284_ sky130_fd_sc_hd__mux2_1
Xclkbuf_3_2__f_clk clknet_0_clk VGND VGND VPWR VPWR clknet_3_2__leaf_clk sky130_fd_sc_hd__clkbuf_16
XFILLER_145_620 VGND VGND VPWR VPWR sky130_fd_sc_hd__fill_2
X_07183_ net1262 net578 net264 VGND VGND VPWR VPWR _00223_ sky130_fd_sc_hd__mux2_1
XFILLER_145_642 VGND VGND VPWR VPWR sky130_fd_sc_hd__fill_1
XPHY_EDGE_ROW_52_Left_208 VGND VGND VPWR VPWR sky130_fd_sc_hd__decap_3
XFILLER_144_141 VGND VGND VPWR VPWR sky130_fd_sc_hd__decap_3
XFILLER_132_303 VGND VGND VPWR VPWR sky130_fd_sc_hd__decap_4
XFILLER_105_517 VGND VGND VPWR VPWR sky130_fd_sc_hd__decap_3
XFILLER_117_399 VGND VGND VPWR VPWR sky130_fd_sc_hd__decap_4
XFILLER_105_539 VGND VGND VPWR VPWR sky130_fd_sc_hd__decap_3
Xfanout414 u_interface.u_gelu_fp32.u_synth_top.s2_dx\[25\] VGND VGND VPWR VPWR net414
+ sky130_fd_sc_hd__dlymetal6s2s_1
Xfanout403 u_interface.u_gelu_fp32.u_synth_top.s2_dx\[27\] VGND VGND VPWR VPWR net403
+ sky130_fd_sc_hd__clkbuf_2
XFILLER_113_561 VGND VGND VPWR VPWR sky130_fd_sc_hd__decap_4
X_09824_ _03576_ _03577_ VGND VGND VPWR VPWR _03578_ sky130_fd_sc_hd__nor2_1
Xfanout447 u_interface.u_gelu_fp32.u_synth_top.s2_dx\[18\] VGND VGND VPWR VPWR net447
+ sky130_fd_sc_hd__dlymetal6s2s_1
Xfanout436 net437 VGND VGND VPWR VPWR net436 sky130_fd_sc_hd__buf_2
XFILLER_58_103 VGND VGND VPWR VPWR sky130_fd_sc_hd__decap_4
Xfanout425 net426 VGND VGND VPWR VPWR net425 sky130_fd_sc_hd__clkbuf_2
XTAP_TAPCELL_ROW_6_438 VGND VPWR sky130_fd_sc_hd__tapvpwrvgnd_1
XTAP_TAPCELL_ROW_6_427 VGND VPWR sky130_fd_sc_hd__tapvpwrvgnd_1
Xfanout458 net459 VGND VGND VPWR VPWR net458 sky130_fd_sc_hd__buf_2
Xfanout469 u_interface.u_gelu_fp32.u_synth_top.s2_dx\[12\] VGND VGND VPWR VPWR net469
+ sky130_fd_sc_hd__buf_2
XFILLER_58_147 VGND VGND VPWR VPWR sky130_fd_sc_hd__fill_1
X_09755_ net175 _03468_ _03506_ _03507_ VGND VGND VPWR VPWR _03510_ sky130_fd_sc_hd__nor4_1
X_06967_ u_interface.u_gelu_fp32.u_synth_top.s1_x\[26\] u_interface.u_gelu_fp32.u_synth_top.s1_x\[27\]
+ u_interface.u_gelu_fp32.u_synth_top.s1_x\[28\] u_interface.u_gelu_fp32.u_synth_top.s1_x\[29\]
+ net273 VGND VGND VPWR VPWR _01495_ sky130_fd_sc_hd__o41a_1
XFILLER_67_670 VGND VGND VPWR VPWR sky130_fd_sc_hd__fill_2
XFILLER_55_810 VPWR VGND VPWR VGND sky130_ef_sc_hd__decap_12
XFILLER_39_361 VGND VGND VPWR VPWR sky130_fd_sc_hd__decap_4
X_08706_ _02464_ VGND VGND VPWR VPWR _02465_ sky130_fd_sc_hd__inv_2
X_09686_ _03438_ _03439_ _03440_ VGND VGND VPWR VPWR _03441_ sky130_fd_sc_hd__a21oi_1
X_06898_ _01130_ _01432_ _01433_ VGND VGND VPWR VPWR _01440_ sky130_fd_sc_hd__a21boi_2
XTAP_TAPCELL_ROW_87_1733 VGND VPWR sky130_fd_sc_hd__tapvpwrvgnd_1
XTAP_TAPCELL_ROW_87_1722 VGND VPWR sky130_fd_sc_hd__tapvpwrvgnd_1
XFILLER_67_681 VPWR VGND VPWR VGND sky130_ef_sc_hd__decap_12
XFILLER_66_180 VGND VGND VPWR VPWR sky130_fd_sc_hd__decap_4
XFILLER_64_27 VGND VGND VPWR VPWR sky130_fd_sc_hd__fill_1
XPHY_EDGE_ROW_61_Left_217 VGND VGND VPWR VPWR sky130_fd_sc_hd__decap_3
XFILLER_55_832 VGND VGND VPWR VPWR sky130_fd_sc_hd__decap_8
XFILLER_70_802 VGND VGND VPWR VPWR sky130_fd_sc_hd__decap_3
X_08637_ net157 _02407_ VGND VGND VPWR VPWR _02408_ sky130_fd_sc_hd__nand2_1
XFILLER_81_183 VPWR VGND VPWR VGND sky130_ef_sc_hd__decap_12
XFILLER_54_386 VPWR VGND VPWR VGND sky130_ef_sc_hd__decap_12
XFILLER_15_729 VPWR VGND VPWR VGND sky130_ef_sc_hd__decap_12
XFILLER_42_537 VPWR VGND VPWR VGND sky130_ef_sc_hd__decap_12
XFILLER_154_6 VPWR VGND VPWR VGND sky130_ef_sc_hd__decap_12
XTAP_TAPCELL_ROW_25_735 VGND VPWR sky130_fd_sc_hd__tapvpwrvgnd_1
X_08568_ _02319_ _02323_ _02358_ _02353_ VGND VGND VPWR VPWR _02359_ sky130_fd_sc_hd__o31ai_1
X_07519_ net551 net557 _01556_ net547 VGND VGND VPWR VPWR _01649_ sky130_fd_sc_hd__o31a_1
XFILLER_80_15 VPWR VGND VPWR VGND sky130_ef_sc_hd__decap_12
X_08499_ _02283_ _02288_ _02169_ VGND VGND VPWR VPWR _02290_ sky130_fd_sc_hd__a21o_1
XTAP_TAPCELL_ROW_118_2221 VGND VPWR sky130_fd_sc_hd__tapvpwrvgnd_1
X_10530_ net587 net408 net405 net579 VGND VGND VPWR VPWR _04278_ sky130_fd_sc_hd__a22o_1
XFILLER_109_834 VGND VGND VPWR VPWR sky130_fd_sc_hd__decap_6
X_10461_ _04207_ _04208_ _03979_ VGND VGND VPWR VPWR _04209_ sky130_fd_sc_hd__a21o_1
XPHY_EDGE_ROW_70_Left_226 VGND VGND VPWR VPWR sky130_fd_sc_hd__decap_3
XFILLER_136_642 VGND VGND VPWR VPWR sky130_fd_sc_hd__fill_2
XFILLER_108_344 VPWR VGND VPWR VGND sky130_ef_sc_hd__decap_12
X_12200_ _05928_ _05929_ VGND VGND VPWR VPWR _05931_ sky130_fd_sc_hd__xnor2_1
X_13180_ clknet_leaf_37_clk _00190_ VGND VGND VPWR VPWR u_interface.fifo_data\[9\]\[22\]
+ sky130_fd_sc_hd__dfxtp_1
XFILLER_136_686 VPWR VGND VPWR VGND sky130_ef_sc_hd__decap_12
XTAP_TAPCELL_ROW_131_2432 VGND VPWR sky130_fd_sc_hd__tapvpwrvgnd_1
XFILLER_124_826 VGND VGND VPWR VPWR sky130_fd_sc_hd__fill_1
XFILLER_108_377 VPWR VGND VPWR VGND sky130_ef_sc_hd__decap_12
XFILLER_89_57 VGND VGND VPWR VPWR sky130_fd_sc_hd__decap_6
X_10392_ _04107_ _04138_ _04139_ VGND VGND VPWR VPWR _04141_ sky130_fd_sc_hd__nand3_1
XFILLER_123_325 VGND VGND VPWR VPWR sky130_fd_sc_hd__decap_8
X_12131_ _05787_ _05790_ _05861_ VGND VGND VPWR VPWR _05863_ sky130_fd_sc_hd__a21oi_1
XFILLER_123_369 VPWR VGND VPWR VGND sky130_ef_sc_hd__decap_12
Xhold490 u_interface.fifo_data\[9\]\[27\] VGND VGND VPWR VPWR net1355 sky130_fd_sc_hd__dlygate4sd3_1
X_12062_ _05641_ _05721_ VGND VGND VPWR VPWR _05795_ sky130_fd_sc_hd__and2b_1
XFILLER_150_166 VGND VGND VPWR VPWR sky130_fd_sc_hd__fill_1
XFILLER_104_572 VGND VGND VPWR VPWR sky130_fd_sc_hd__decap_4
X_11013_ net595 net396 VGND VGND VPWR VPWR _04757_ sky130_fd_sc_hd__nand2_1
XFILLER_2_699 VGND VGND VPWR VPWR sky130_fd_sc_hd__fill_1
XFILLER_77_434 VGND VGND VPWR VPWR sky130_fd_sc_hd__fill_1
XTAP_TAPCELL_ROW_129_2394 VGND VPWR sky130_fd_sc_hd__tapvpwrvgnd_1
XFILLER_49_169 VGND VGND VPWR VPWR sky130_fd_sc_hd__decap_8
X_12964_ _06481_ _06482_ VGND VGND VPWR VPWR _06483_ sky130_fd_sc_hd__nand2b_1
XFILLER_18_512 VGND VGND VPWR VPWR sky130_fd_sc_hd__decap_4
X_11915_ _05633_ _05634_ _05637_ VGND VGND VPWR VPWR _05649_ sky130_fd_sc_hd__o21ai_1
X_12895_ net786 net929 VGND VGND VPWR VPWR _01037_ sky130_fd_sc_hd__and2_1
XFILLER_18_589 VPWR VGND VPWR VGND sky130_ef_sc_hd__decap_12
X_11846_ _05577_ _05580_ VGND VGND VPWR VPWR _05581_ sky130_fd_sc_hd__and2b_1
XFILLER_20_209 VGND VGND VPWR VPWR sky130_fd_sc_hd__fill_1
X_11777_ net701 net415 net410 net693 VGND VGND VPWR VPWR _05513_ sky130_fd_sc_hd__a22o_1
XPHY_EDGE_ROW_109_Left_265 VGND VGND VPWR VPWR sky130_fd_sc_hd__decap_3
X_13516_ clknet_leaf_66_clk _00526_ VGND VGND VPWR VPWR u_interface.core_data_out\[27\]
+ sky130_fd_sc_hd__dfxtp_1
X_10728_ net460 net704 _04471_ _04472_ VGND VGND VPWR VPWR _04474_ sky130_fd_sc_hd__nand4_1
XFILLER_41_592 VPWR VGND VPWR VGND sky130_ef_sc_hd__decap_12
XFILLER_146_428 VGND VGND VPWR VPWR sky130_fd_sc_hd__decap_4
Xclkload35 clknet_leaf_21_clk VGND VGND VPWR VPWR clkload35/Y sky130_fd_sc_hd__inv_16
XFILLER_127_642 VGND VGND VPWR VPWR sky130_fd_sc_hd__fill_1
Xclkload24 clknet_leaf_9_clk VGND VGND VPWR VPWR clkload24/Y sky130_fd_sc_hd__inv_8
X_13447_ clknet_leaf_10_clk _00457_ VGND VGND VPWR VPWR u_interface.u_gelu_fp32.u_fp32_to_q16.s3_mag\[18\]
+ sky130_fd_sc_hd__dfxtp_1
Xclkload13 clknet_leaf_24_clk VGND VGND VPWR VPWR clkload13/Y sky130_fd_sc_hd__inv_12
X_10659_ _04398_ _04403_ _04404_ VGND VGND VPWR VPWR _04406_ sky130_fd_sc_hd__nand3_1
XFILLER_142_601 VGND VGND VPWR VPWR sky130_fd_sc_hd__decap_6
Xclkload68 clknet_leaf_32_clk VGND VGND VPWR VPWR clkload68/Y sky130_fd_sc_hd__inv_6
XFILLER_126_141 VGND VGND VPWR VPWR sky130_fd_sc_hd__fill_2
X_13378_ clknet_leaf_44_clk _00388_ VGND VGND VPWR VPWR u_interface.fifo_data\[7\]\[23\]
+ sky130_fd_sc_hd__dfxtp_1
Xclkload57 clknet_leaf_66_clk VGND VGND VPWR VPWR clkload57/Y sky130_fd_sc_hd__inv_6
Xclkload46 clknet_leaf_79_clk VGND VGND VPWR VPWR clkload46/Y sky130_fd_sc_hd__clkinv_8
Xclkload79 clknet_leaf_44_clk VGND VGND VPWR VPWR clkload79/X sky130_fd_sc_hd__clkbuf_8
X_12329_ _06056_ _06057_ VGND VGND VPWR VPWR _06058_ sky130_fd_sc_hd__nor2_1
XTAP_TAPCELL_ROW_149_2726 VGND VPWR sky130_fd_sc_hd__tapvpwrvgnd_1
XTAP_TAPCELL_ROW_149_2715 VGND VPWR sky130_fd_sc_hd__tapvpwrvgnd_1
XFILLER_141_122 VGND VGND VPWR VPWR sky130_fd_sc_hd__decap_6
XFILLER_48_3 VPWR VGND VPWR VGND sky130_ef_sc_hd__decap_12
XFILLER_141_166 VGND VGND VPWR VPWR sky130_fd_sc_hd__fill_2
XPHY_EDGE_ROW_118_Left_274 VGND VGND VPWR VPWR sky130_fd_sc_hd__decap_3
X_07870_ net1153 net377 net265 VGND VGND VPWR VPWR _00631_ sky130_fd_sc_hd__mux2_1
XFILLER_110_575 VPWR VGND VPWR VGND sky130_ef_sc_hd__decap_12
XFILLER_110_553 VGND VGND VPWR VPWR sky130_fd_sc_hd__decap_6
X_06821_ u_interface.fifo_data\[8\]\[24\] u_interface.fifo_data\[9\]\[24\] u_interface.fifo_data\[10\]\[24\]
+ u_interface.fifo_data\[11\]\[24\] net765 net748 VGND VGND VPWR VPWR _01372_ sky130_fd_sc_hd__mux4_1
XFILLER_84_916 VGND VGND VPWR VPWR sky130_fd_sc_hd__fill_1
XFILLER_68_489 VGND VGND VPWR VPWR sky130_fd_sc_hd__fill_1
XFILLER_68_467 VGND VGND VPWR VPWR sky130_fd_sc_hd__fill_1
XFILLER_28_309 VGND VGND VPWR VPWR sky130_fd_sc_hd__decap_8
XFILLER_37_810 VGND VGND VPWR VPWR sky130_fd_sc_hd__decap_3
X_09540_ _03286_ _03296_ VGND VGND VPWR VPWR _03297_ sky130_fd_sc_hd__xnor2_1
X_06752_ net321 _01311_ net726 VGND VGND VPWR VPWR _01312_ sky130_fd_sc_hd__o21a_1
X_09471_ _03174_ _03182_ _03181_ VGND VGND VPWR VPWR _03228_ sky130_fd_sc_hd__a21oi_1
XTAP_TAPCELL_ROW_69_1441 VGND VPWR sky130_fd_sc_hd__tapvpwrvgnd_1
X_08422_ u_interface.u_gelu_fp32.u_synth_top.s3_mult\[16\] u_interface.u_gelu_fp32.u_synth_top.s3_b\[0\]
+ VGND VGND VPWR VPWR _02213_ sky130_fd_sc_hd__nand2_1
XFILLER_70_109 VPWR VGND VPWR VGND sky130_ef_sc_hd__decap_12
XFILLER_52_846 VGND VGND VPWR VPWR sky130_fd_sc_hd__fill_1
X_06683_ _01250_ _01251_ net730 VGND VGND VPWR VPWR _01252_ sky130_fd_sc_hd__mux2_1
XFILLER_24_504 VPWR VGND VPWR VGND sky130_ef_sc_hd__decap_12
XTAP_TAPCELL_ROW_82_1641 VGND VPWR sky130_fd_sc_hd__tapvpwrvgnd_1
XFILLER_51_334 VGND VGND VPWR VPWR sky130_fd_sc_hd__fill_2
XPHY_EDGE_ROW_127_Left_283 VGND VGND VPWR VPWR sky130_fd_sc_hd__decap_3
XTAP_TAPCELL_ROW_82_1652 VGND VPWR sky130_fd_sc_hd__tapvpwrvgnd_1
XFILLER_51_389 VGND VGND VPWR VPWR sky130_fd_sc_hd__decap_3
X_08353_ net529 net1629 _02146_ net798 VGND VGND VPWR VPWR _02148_ sky130_fd_sc_hd__a31o_1
X_07304_ net1205 net382 net255 VGND VGND VPWR VPWR _00334_ sky130_fd_sc_hd__mux2_1
X_08284_ net532 _02095_ net1652 VGND VGND VPWR VPWR _02096_ sky130_fd_sc_hd__a21oi_1
X_07235_ net1639 _01532_ _01534_ VGND VGND VPWR VPWR _00267_ sky130_fd_sc_hd__o21a_1
Xclkload7 clknet_leaf_0_clk VGND VGND VPWR VPWR clkload7/Y sky130_fd_sc_hd__inv_12
XFILLER_50_29 VGND VGND VPWR VPWR sky130_fd_sc_hd__decap_6
XFILLER_118_642 VGND VGND VPWR VPWR sky130_fd_sc_hd__fill_2
X_07166_ net1410 net372 net261 VGND VGND VPWR VPWR _00206_ sky130_fd_sc_hd__mux2_1
XFILLER_145_483 VGND VGND VPWR VPWR sky130_fd_sc_hd__decap_8
X_07097_ net1118 net352 net227 VGND VGND VPWR VPWR _00137_ sky130_fd_sc_hd__mux2_1
XTAP_TAPCELL_ROW_113_2151 VGND VPWR sky130_fd_sc_hd__tapvpwrvgnd_1
XTAP_TAPCELL_ROW_113_2140 VGND VPWR sky130_fd_sc_hd__tapvpwrvgnd_1
XPHY_EDGE_ROW_136_Left_292 VGND VGND VPWR VPWR sky130_fd_sc_hd__decap_3
XFILLER_133_678 VPWR VGND VPWR VGND sky130_ef_sc_hd__decap_12
XFILLER_78_209 VGND VGND VPWR VPWR sky130_fd_sc_hd__decap_3
XFILLER_99_581 VGND VGND VPWR VPWR sky130_fd_sc_hd__fill_2
Xfanout222 _01522_ VGND VGND VPWR VPWR net222 sky130_fd_sc_hd__clkbuf_4
XFILLER_87_721 VGND VGND VPWR VPWR sky130_fd_sc_hd__decap_6
Xfanout211 net212 VGND VGND VPWR VPWR net211 sky130_fd_sc_hd__clkbuf_2
Xfanout200 net201 VGND VGND VPWR VPWR net200 sky130_fd_sc_hd__clkbuf_4
Xfanout244 _01516_ VGND VGND VPWR VPWR net244 sky130_fd_sc_hd__buf_4
Xfanout255 _01511_ VGND VGND VPWR VPWR net255 sky130_fd_sc_hd__buf_4
XFILLER_115_55 VGND VGND VPWR VPWR sky130_fd_sc_hd__fill_1
Xfanout233 net234 VGND VGND VPWR VPWR net233 sky130_fd_sc_hd__buf_4
X_07999_ net548 net303 _01634_ net278 VGND VGND VPWR VPWR _01864_ sky130_fd_sc_hd__a31o_1
X_09807_ _03540_ _03557_ _03558_ VGND VGND VPWR VPWR _03561_ sky130_fd_sc_hd__or3_1
Xfanout266 _01505_ VGND VGND VPWR VPWR net266 sky130_fd_sc_hd__buf_2
Xfanout277 _03868_ VGND VGND VPWR VPWR net277 sky130_fd_sc_hd__buf_2
Xfanout288 _06343_ VGND VGND VPWR VPWR net288 sky130_fd_sc_hd__buf_2
Xfanout299 _01695_ VGND VGND VPWR VPWR net299 sky130_fd_sc_hd__buf_2
XFILLER_86_253 VPWR VGND VPWR VGND sky130_ef_sc_hd__decap_12
XFILLER_86_242 VGND VGND VPWR VPWR sky130_fd_sc_hd__fill_1
XFILLER_75_15 VGND VGND VPWR VPWR sky130_fd_sc_hd__decap_8
X_09738_ _03484_ _03490_ _03491_ VGND VGND VPWR VPWR _03493_ sky130_fd_sc_hd__nand3_1
XFILLER_101_597 VGND VGND VPWR VPWR sky130_fd_sc_hd__decap_4
XFILLER_46_128 VGND VGND VPWR VPWR sky130_fd_sc_hd__fill_1
X_09669_ net589 net601 net447 net441 VGND VGND VPWR VPWR _03424_ sky130_fd_sc_hd__and4_1
XFILLER_55_673 VGND VGND VPWR VPWR sky130_fd_sc_hd__decap_8
X_12680_ _06341_ _01745_ _01739_ _01732_ net333 net329 VGND VGND VPWR VPWR _06342_
+ sky130_fd_sc_hd__mux4_1
XFILLER_15_559 VGND VGND VPWR VPWR sky130_fd_sc_hd__fill_1
X_11700_ _05428_ _05434_ _05435_ VGND VGND VPWR VPWR _05437_ sky130_fd_sc_hd__and3_1
XFILLER_91_69 VPWR VGND VPWR VGND sky130_ef_sc_hd__decap_12
XFILLER_24_41 VPWR VGND VPWR VGND sky130_ef_sc_hd__decap_12
X_11631_ net633 net393 _05275_ _05274_ VGND VGND VPWR VPWR _05369_ sky130_fd_sc_hd__a31o_1
XPHY_EDGE_ROW_145_Right_145 VGND VGND VPWR VPWR sky130_fd_sc_hd__decap_3
X_11562_ _05123_ _05206_ _05205_ VGND VGND VPWR VPWR _05301_ sky130_fd_sc_hd__a21oi_1
XFILLER_11_721 VGND VGND VPWR VPWR sky130_fd_sc_hd__decap_6
XFILLER_24_85 VPWR VGND VPWR VGND sky130_ef_sc_hd__decap_12
X_13301_ clknet_leaf_39_clk _00311_ VGND VGND VPWR VPWR u_interface.fifo_data\[8\]\[10\]
+ sky130_fd_sc_hd__dfxtp_1
X_10513_ net653 net445 net440 net644 VGND VGND VPWR VPWR _04261_ sky130_fd_sc_hd__a22o_1
XFILLER_11_765 VPWR VGND VPWR VGND sky130_ef_sc_hd__decap_12
X_11493_ _05222_ _05231_ VGND VGND VPWR VPWR _05232_ sky130_fd_sc_hd__xor2_1
X_13232_ clknet_leaf_38_clk _00242_ VGND VGND VPWR VPWR u_interface.fifo_data\[11\]\[10\]
+ sky130_fd_sc_hd__dfxtp_1
XFILLER_108_141 VGND VGND VPWR VPWR sky130_fd_sc_hd__decap_8
X_10444_ _04191_ _04190_ VGND VGND VPWR VPWR _04193_ sky130_fd_sc_hd__and2b_1
XFILLER_136_472 VGND VGND VPWR VPWR sky130_fd_sc_hd__decap_4
XFILLER_123_111 VGND VGND VPWR VPWR sky130_fd_sc_hd__fill_1
X_10375_ net645 net449 _04045_ _04044_ VGND VGND VPWR VPWR _04124_ sky130_fd_sc_hd__a31o_1
X_13163_ clknet_leaf_70_clk _00173_ VGND VGND VPWR VPWR u_interface.fifo_data\[9\]\[5\]
+ sky130_fd_sc_hd__dfxtp_1
XFILLER_124_645 VGND VGND VPWR VPWR sky130_fd_sc_hd__decap_6
X_12114_ _05739_ _05772_ _05771_ VGND VGND VPWR VPWR _05846_ sky130_fd_sc_hd__a21oi_1
XFILLER_111_317 VGND VGND VPWR VPWR sky130_fd_sc_hd__decap_4
X_13094_ clknet_leaf_65_clk _00104_ VGND VGND VPWR VPWR u_interface.fifo_data\[15\]\[15\]
+ sky130_fd_sc_hd__dfxtp_1
X_12045_ _05660_ _05704_ _05703_ VGND VGND VPWR VPWR _05778_ sky130_fd_sc_hd__a21oi_1
XFILLER_93_724 VGND VGND VPWR VPWR sky130_fd_sc_hd__decap_4
XTAP_TAPCELL_ROW_144_2645 VGND VPWR sky130_fd_sc_hd__tapvpwrvgnd_1
XTAP_TAPCELL_ROW_144_2634 VGND VPWR sky130_fd_sc_hd__tapvpwrvgnd_1
XFILLER_93_735 VGND VGND VPWR VPWR sky130_fd_sc_hd__fill_1
XFILLER_65_437 VGND VGND VPWR VPWR sky130_fd_sc_hd__fill_2
XFILLER_19_821 VPWR VGND VPWR VGND sky130_ef_sc_hd__decap_12
XFILLER_37_117 VGND VGND VPWR VPWR sky130_fd_sc_hd__fill_1
XFILLER_93_779 VGND VGND VPWR VPWR sky130_fd_sc_hd__fill_1
XFILLER_92_245 VGND VGND VPWR VPWR sky130_fd_sc_hd__decap_6
X_13996_ clknet_leaf_55_clk _00922_ VGND VGND VPWR VPWR u_interface.u_gelu_fp32.u_q16_to_fp32.s3_norm_mag\[23\]
+ sky130_fd_sc_hd__dfxtp_1
XFILLER_19_865 VPWR VGND VPWR VGND sky130_ef_sc_hd__decap_12
X_12947_ u_interface.fifo_count\[0\] _06468_ net828 VGND VGND VPWR VPWR _06469_ sky130_fd_sc_hd__a21oi_1
XFILLER_80_429 VGND VGND VPWR VPWR sky130_fd_sc_hd__fill_1
XFILLER_80_418 VGND VGND VPWR VPWR sky130_fd_sc_hd__fill_2
XFILLER_34_813 VPWR VGND VPWR VGND sky130_ef_sc_hd__decap_12
X_12878_ net70 net1680 VGND VGND VPWR VPWR _06434_ sky130_fd_sc_hd__nand2b_1
XFILLER_45_194 VPWR VGND VPWR VGND sky130_ef_sc_hd__decap_12
XTAP_TAPCELL_ROW_64_1360 VGND VPWR sky130_fd_sc_hd__tapvpwrvgnd_1
XFILLER_60_153 VPWR VGND VPWR VGND sky130_ef_sc_hd__decap_12
X_11829_ _05478_ _05485_ _05563_ net793 VGND VGND VPWR VPWR _05565_ sky130_fd_sc_hd__a31o_1
XFILLER_33_378 VPWR VGND VPWR VGND sky130_ef_sc_hd__decap_12
XFILLER_60_197 VGND VGND VPWR VPWR sky130_fd_sc_hd__decap_8
XFILLER_14_581 VGND VGND VPWR VPWR sky130_fd_sc_hd__decap_6
XTAP_TAPCELL_ROW_16_587 VGND VPWR sky130_fd_sc_hd__tapvpwrvgnd_1
XTAP_TAPCELL_ROW_16_598 VGND VPWR sky130_fd_sc_hd__tapvpwrvgnd_1
XPHY_EDGE_ROW_112_Right_112 VGND VGND VPWR VPWR sky130_fd_sc_hd__decap_3
XFILLER_81_91 VGND VGND VPWR VPWR sky130_fd_sc_hd__decap_8
XFILLER_146_247 VGND VGND VPWR VPWR sky130_fd_sc_hd__fill_1
XFILLER_155_770 VGND VGND VPWR VPWR sky130_fd_sc_hd__decap_3
XFILLER_115_601 VPWR VGND VPWR VGND sky130_ef_sc_hd__decap_12
X_07020_ net1451 net378 net269 VGND VGND VPWR VPWR _00060_ sky130_fd_sc_hd__mux2_1
XPHY_EDGE_ROW_49_Right_49 VGND VGND VPWR VPWR sky130_fd_sc_hd__decap_3
XFILLER_142_453 VPWR VGND VPWR VGND sky130_ef_sc_hd__decap_12
XFILLER_115_667 VGND VGND VPWR VPWR sky130_fd_sc_hd__decap_4
XFILLER_88_507 VGND VGND VPWR VPWR sky130_fd_sc_hd__fill_1
X_08971_ _02723_ _02728_ _02729_ VGND VGND VPWR VPWR _02730_ sky130_fd_sc_hd__nand3_1
XFILLER_115_689 VGND VGND VPWR VPWR sky130_fd_sc_hd__fill_1
XFILLER_88_529 VGND VGND VPWR VPWR sky130_fd_sc_hd__decap_3
X_07922_ _01815_ VGND VGND VPWR VPWR _01816_ sky130_fd_sc_hd__inv_2
Xhold19 u_interface.u_gelu_fp32.s1_data\[5\] VGND VGND VPWR VPWR net884 sky130_fd_sc_hd__dlygate4sd3_1
X_07853_ net347 net1408 net284 VGND VGND VPWR VPWR _00614_ sky130_fd_sc_hd__mux2_1
XFILLER_68_253 VGND VGND VPWR VPWR sky130_fd_sc_hd__decap_8
XFILLER_29_607 VGND VGND VPWR VPWR sky130_fd_sc_hd__decap_8
XFILLER_29_629 VPWR VGND VPWR VGND sky130_ef_sc_hd__decap_12
XFILLER_111_895 VGND VGND VPWR VPWR sky130_fd_sc_hd__fill_1
XFILLER_84_757 VGND VGND VPWR VPWR sky130_fd_sc_hd__decap_6
XFILLER_68_286 VGND VGND VPWR VPWR sky130_fd_sc_hd__fill_1
X_06804_ _01352_ _01354_ _01357_ net316 VGND VGND VPWR VPWR net122 sky130_fd_sc_hd__a22o_1
X_07784_ net1188 net356 net235 VGND VGND VPWR VPWR _00545_ sky130_fd_sc_hd__mux2_1
XFILLER_71_407 VGND VGND VPWR VPWR sky130_fd_sc_hd__fill_2
XPHY_EDGE_ROW_58_Right_58 VGND VGND VPWR VPWR sky130_fd_sc_hd__decap_3
X_06735_ net735 _01296_ VGND VGND VPWR VPWR _01297_ sky130_fd_sc_hd__or2_1
X_09523_ _03157_ _03279_ VGND VGND VPWR VPWR _03280_ sky130_fd_sc_hd__and2_1
XFILLER_37_673 VGND VGND VPWR VPWR sky130_fd_sc_hd__decap_4
X_09454_ _03210_ _03211_ _02703_ VGND VGND VPWR VPWR _03212_ sky130_fd_sc_hd__o21ai_2
X_06666_ u_interface.fifo_data\[4\]\[4\] u_interface.fifo_data\[5\]\[4\] u_interface.fifo_data\[6\]\[4\]
+ u_interface.fifo_data\[7\]\[4\] net761 net744 VGND VGND VPWR VPWR _01237_ sky130_fd_sc_hd__mux4_1
XFILLER_52_654 VGND VGND VPWR VPWR sky130_fd_sc_hd__fill_2
X_09385_ _03141_ _03142_ _03140_ VGND VGND VPWR VPWR _03143_ sky130_fd_sc_hd__a21o_1
XFILLER_101_57 VPWR VGND VPWR VGND sky130_ef_sc_hd__decap_12
X_08405_ u_interface.u_gelu_fp32.u_synth_top.s3_mult\[23\] u_interface.u_gelu_fp32.u_synth_top.s3_b\[7\]
+ VGND VGND VPWR VPWR _02196_ sky130_fd_sc_hd__nand2_1
XFILLER_51_142 VPWR VGND VPWR VGND sky130_ef_sc_hd__decap_12
X_06597_ u_interface.u_gelu_fp32.s1_data\[17\] _01179_ VGND VGND VPWR VPWR _01180_
+ sky130_fd_sc_hd__nand2_1
XFILLER_51_186 VPWR VGND VPWR VGND sky130_ef_sc_hd__decap_12
X_08336_ net531 _02134_ net1642 VGND VGND VPWR VPWR _02135_ sky130_fd_sc_hd__a21oi_1
XTAP_TAPCELL_ROW_35_896 VGND VPWR sky130_fd_sc_hd__tapvpwrvgnd_1
XFILLER_137_225 VPWR VGND VPWR VGND sky130_ef_sc_hd__decap_12
X_08267_ u_interface.u_gelu_fp32.s2_data\[5\] u_interface.u_gelu_fp32.s2_data\[4\]
+ u_interface.u_gelu_fp32.s2_data\[6\] _02076_ VGND VGND VPWR VPWR _02083_ sky130_fd_sc_hd__or4_1
XFILLER_137_269 VGND VGND VPWR VPWR sky130_fd_sc_hd__decap_4
X_07218_ net572 net1536 net260 VGND VGND VPWR VPWR _00258_ sky130_fd_sc_hd__mux2_1
X_08198_ _02025_ _02026_ net539 VGND VGND VPWR VPWR _02031_ sky130_fd_sc_hd__o21a_1
XPHY_EDGE_ROW_67_Right_67 VGND VGND VPWR VPWR sky130_fd_sc_hd__decap_3
XPHY_EDGE_ROW_144_Left_300 VGND VGND VPWR VPWR sky130_fd_sc_hd__decap_3
XTAP_TAPCELL_ROW_95_1854 VGND VPWR sky130_fd_sc_hd__tapvpwrvgnd_1
X_07149_ net958 net342 net217 VGND VGND VPWR VPWR _00189_ sky130_fd_sc_hd__mux2_1
XFILLER_3_205 VPWR VGND VPWR VGND sky130_ef_sc_hd__decap_12
XFILLER_105_111 VGND VGND VPWR VPWR sky130_fd_sc_hd__fill_1
XFILLER_3_249 VPWR VGND VPWR VGND sky130_ef_sc_hd__decap_12
X_10160_ _03905_ _03908_ _03909_ VGND VGND VPWR VPWR _03911_ sky130_fd_sc_hd__nand3_1
XFILLER_10_65 VPWR VGND VPWR VGND sky130_ef_sc_hd__decap_12
XFILLER_133_497 VGND VGND VPWR VPWR sky130_fd_sc_hd__decap_6
XFILLER_126_65 VGND VGND VPWR VPWR sky130_fd_sc_hd__decap_3
XFILLER_120_125 VGND VGND VPWR VPWR sky130_fd_sc_hd__fill_2
X_10091_ _03841_ _03842_ _03723_ VGND VGND VPWR VPWR _03843_ sky130_fd_sc_hd__o21ai_2
XFILLER_120_169 VGND VGND VPWR VPWR sky130_fd_sc_hd__fill_1
XPHY_EDGE_ROW_76_Right_76 VGND VGND VPWR VPWR sky130_fd_sc_hd__decap_3
XFILLER_59_286 VGND VGND VPWR VPWR sky130_fd_sc_hd__decap_4
XTAP_TAPCELL_ROW_126_2353 VGND VPWR sky130_fd_sc_hd__tapvpwrvgnd_1
X_13850_ clknet_leaf_57_clk _00860_ VGND VGND VPWR VPWR u_interface.u_gelu_fp32.u_synth_top.s3_b\[6\]
+ sky130_fd_sc_hd__dfxtp_1
XFILLER_74_234 VGND VGND VPWR VPWR sky130_fd_sc_hd__decap_4
X_12801_ u_interface.u_gelu_fp32.u_q16_to_fp32.s3_norm_mag\[29\] _01789_ net296 VGND
+ VGND VPWR VPWR _06417_ sky130_fd_sc_hd__o21ai_1
XFILLER_74_289 VPWR VGND VPWR VGND sky130_ef_sc_hd__decap_12
X_13781_ clknet_leaf_86_clk _00791_ VGND VGND VPWR VPWR u_interface.u_gelu_fp32.s2_data\[15\]
+ sky130_fd_sc_hd__dfxtp_1
X_10993_ _04624_ _04626_ _04735_ VGND VGND VPWR VPWR _04737_ sky130_fd_sc_hd__a21o_1
XFILLER_16_813 VPWR VGND VPWR VGND sky130_ef_sc_hd__decap_12
X_12732_ _06382_ _06367_ net328 VGND VGND VPWR VPWR _06383_ sky130_fd_sc_hd__mux2_1
XFILLER_55_492 VPWR VGND VPWR VGND sky130_ef_sc_hd__decap_12
XFILLER_15_334 VGND VGND VPWR VPWR sky130_fd_sc_hd__fill_2
XFILLER_35_51 VGND VGND VPWR VPWR sky130_fd_sc_hd__decap_4
XFILLER_15_367 VPWR VGND VPWR VGND sky130_ef_sc_hd__decap_12
XTAP_TAPCELL_ROW_104_1994 VGND VPWR sky130_fd_sc_hd__tapvpwrvgnd_1
X_12663_ u_interface.u_gelu_fp32.u_q16_to_fp32.s1_mag\[18\] net1677 net802 VGND VGND
+ VPWR VPWR _00899_ sky130_fd_sc_hd__mux2_1
XFILLER_129_726 VGND VGND VPWR VPWR sky130_fd_sc_hd__fill_2
X_12594_ _06294_ _06295_ _06296_ VGND VGND VPWR VPWR _06297_ sky130_fd_sc_hd__or3_1
XTAP_TAPCELL_ROW_13_546 VGND VPWR sky130_fd_sc_hd__tapvpwrvgnd_1
X_11614_ _05348_ _05350_ net692 net420 VGND VGND VPWR VPWR _05352_ sky130_fd_sc_hd__nand4b_2
XPHY_EDGE_ROW_85_Right_85 VGND VGND VPWR VPWR sky130_fd_sc_hd__decap_3
XFILLER_11_573 VPWR VGND VPWR VGND sky130_ef_sc_hd__decap_12
X_11545_ _05171_ _05188_ _05189_ VGND VGND VPWR VPWR _05284_ sky130_fd_sc_hd__a21oi_2
XFILLER_144_718 VGND VGND VPWR VPWR sky130_fd_sc_hd__fill_1
X_11476_ net794 _05215_ VGND VGND VPWR VPWR _00827_ sky130_fd_sc_hd__nor2_1
XFILLER_109_483 VGND VGND VPWR VPWR sky130_fd_sc_hd__fill_1
XFILLER_109_461 VGND VGND VPWR VPWR sky130_fd_sc_hd__fill_1
X_13215_ clknet_leaf_47_clk _00225_ VGND VGND VPWR VPWR u_interface.fifo_data\[12\]\[25\]
+ sky130_fd_sc_hd__dfxtp_1
X_10427_ _04059_ _04173_ _04174_ VGND VGND VPWR VPWR _04176_ sky130_fd_sc_hd__or3_2
XFILLER_98_805 VGND VGND VPWR VPWR sky130_fd_sc_hd__fill_1
X_13146_ clknet_leaf_36_clk _00156_ VGND VGND VPWR VPWR u_interface.fifo_tlast\[11\]
+ sky130_fd_sc_hd__dfxtp_1
X_10358_ _04028_ _04030_ VGND VGND VPWR VPWR _04107_ sky130_fd_sc_hd__or2_1
XFILLER_97_337 VGND VGND VPWR VPWR sky130_fd_sc_hd__decap_4
X_10289_ _04037_ _04038_ VGND VGND VPWR VPWR _04039_ sky130_fd_sc_hd__nor2_1
X_13077_ clknet_leaf_68_clk _00087_ VGND VGND VPWR VPWR u_interface.fifo_data\[14\]\[30\]
+ sky130_fd_sc_hd__dfxtp_1
XFILLER_3_783 VGND VGND VPWR VPWR sky130_fd_sc_hd__fill_1
XFILLER_32_6 VPWR VGND VPWR VGND sky130_ef_sc_hd__decap_12
XFILLER_111_169 VPWR VGND VPWR VGND sky130_ef_sc_hd__decap_12
XPHY_EDGE_ROW_94_Right_94 VGND VGND VPWR VPWR sky130_fd_sc_hd__decap_3
X_12028_ _05756_ _05760_ VGND VGND VPWR VPWR _05761_ sky130_fd_sc_hd__xnor2_1
XFILLER_93_510 VPWR VGND VPWR VGND sky130_ef_sc_hd__decap_12
XFILLER_81_716 VGND VGND VPWR VPWR sky130_fd_sc_hd__fill_2
X_13979_ clknet_leaf_83_clk net1501 VGND VGND VPWR VPWR u_interface.u_gelu_fp32.u_q16_to_fp32.s2_mag\[24\]
+ sky130_fd_sc_hd__dfxtp_1
XTAP_TAPCELL_ROW_49_1119 VGND VPWR sky130_fd_sc_hd__tapvpwrvgnd_1
XFILLER_19_673 VPWR VGND VPWR VGND sky130_ef_sc_hd__decap_12
X_06520_ u_interface.fifo_count\[3\] u_interface.in_flight_count\[3\] _01118_ _01119_
+ VGND VGND VPWR VPWR _01120_ sky130_fd_sc_hd__o22a_1
XFILLER_74_790 VGND VGND VPWR VPWR sky130_fd_sc_hd__decap_8
XFILLER_34_643 VGND VGND VPWR VPWR sky130_fd_sc_hd__fill_1
XFILLER_22_805 VGND VGND VPWR VPWR sky130_fd_sc_hd__decap_6
XFILLER_22_849 VPWR VGND VPWR VGND sky130_ef_sc_hd__decap_12
XFILLER_33_175 VGND VGND VPWR VPWR sky130_fd_sc_hd__fill_1
X_09170_ net621 net512 VGND VGND VPWR VPWR _02929_ sky130_fd_sc_hd__nand2_1
XTAP_TAPCELL_ROW_32_844 VGND VPWR sky130_fd_sc_hd__tapvpwrvgnd_1
XTAP_TAPCELL_ROW_32_855 VGND VPWR sky130_fd_sc_hd__tapvpwrvgnd_1
XFILLER_147_545 VGND VGND VPWR VPWR sky130_fd_sc_hd__decap_8
XFILLER_147_534 VGND VGND VPWR VPWR sky130_fd_sc_hd__fill_1
X_08121_ u_interface.u_gelu_fp32.u_fp32_to_q16.s3_mag\[12\] _01880_ VGND VGND VPWR
+ VPWR _01966_ sky130_fd_sc_hd__xnor2_1
XFILLER_30_893 VPWR VGND VPWR VGND sky130_ef_sc_hd__decap_12
X_08052_ _01908_ u_interface.u_gelu_fp32.u_fp32_to_q16.round_bit u_interface.u_gelu_fp32.u_fp32_to_q16.s3_mag\[0\]
+ VGND VGND VPWR VPWR _01909_ sky130_fd_sc_hd__mux2_1
XFILLER_107_409 VGND VGND VPWR VPWR sky130_fd_sc_hd__fill_1
XFILLER_147_589 VPWR VGND VPWR VGND sky130_ef_sc_hd__decap_12
X_07003_ _01506_ _01515_ VGND VGND VPWR VPWR _01519_ sky130_fd_sc_hd__nor2_2
XTAP_TAPCELL_ROW_77_1573 VGND VPWR sky130_fd_sc_hd__tapvpwrvgnd_1
XTAP_TAPCELL_ROW_77_1562 VGND VPWR sky130_fd_sc_hd__tapvpwrvgnd_1
XFILLER_1_709 VPWR VGND VPWR VGND sky130_ef_sc_hd__decap_12
XFILLER_143_762 VGND VGND VPWR VPWR sky130_fd_sc_hd__decap_6
XFILLER_103_615 VGND VGND VPWR VPWR sky130_fd_sc_hd__fill_1
XFILLER_89_816 VGND VGND VPWR VPWR sky130_fd_sc_hd__fill_1
X_08954_ net583 u_interface.u_gelu_fp32.u_synth_top.s2_dx\[11\] _02712_ VGND VGND
+ VPWR VPWR _02713_ sky130_fd_sc_hd__and3_1
XFILLER_115_497 VGND VGND VPWR VPWR sky130_fd_sc_hd__decap_6
X_07905_ net775 net89 VGND VGND VPWR VPWR _00664_ sky130_fd_sc_hd__and2_1
XFILLER_102_147 VGND VGND VPWR VPWR sky130_fd_sc_hd__fill_1
XTAP_TAPCELL_ROW_90_1773 VGND VPWR sky130_fd_sc_hd__tapvpwrvgnd_1
X_08885_ net466 net605 net470 net614 VGND VGND VPWR VPWR _02644_ sky130_fd_sc_hd__a22o_1
XFILLER_97_893 VGND VGND VPWR VPWR sky130_fd_sc_hd__decap_3
XFILLER_69_584 VGND VGND VPWR VPWR sky130_fd_sc_hd__fill_2
XFILLER_29_415 VGND VGND VPWR VPWR sky130_fd_sc_hd__decap_4
XFILLER_110_191 VGND VGND VPWR VPWR sky130_fd_sc_hd__decap_4
XTAP_TAPCELL_ROW_108_2061 VGND VPWR sky130_fd_sc_hd__tapvpwrvgnd_1
X_07836_ net381 net1465 net282 VGND VGND VPWR VPWR _00597_ sky130_fd_sc_hd__mux2_1
XFILLER_45_919 VGND VGND VPWR VPWR sky130_fd_sc_hd__fill_2
X_07767_ u_interface.u_gelu_fp32.u_q16_to_fp32.s3_exp\[7\] _01803_ net295 VGND VGND
+ VPWR VPWR _01804_ sky130_fd_sc_hd__o21ai_1
XFILLER_16_109 VPWR VGND VPWR VGND sky130_ef_sc_hd__decap_12
X_09506_ _03260_ _03261_ _03243_ VGND VGND VPWR VPWR _03263_ sky130_fd_sc_hd__o21ai_1
XFILLER_112_56 VGND VGND VPWR VPWR sky130_fd_sc_hd__decap_4
X_06718_ u_interface.fifo_data\[12\]\[11\] u_interface.fifo_data\[13\]\[11\] u_interface.fifo_data\[14\]\[11\]
+ u_interface.fifo_data\[15\]\[11\] net764 net747 VGND VGND VPWR VPWR _01282_ sky130_fd_sc_hd__mux4_1
XFILLER_71_237 VGND VGND VPWR VPWR sky130_fd_sc_hd__decap_6
XTAP_TAPCELL_ROW_121_2272 VGND VPWR sky130_fd_sc_hd__tapvpwrvgnd_1
X_07698_ u_interface.u_gelu_fp32.u_synth_top.s1_hits\[18\] u_interface.u_gelu_fp32.u_synth_top.s1_hits\[2\]
+ _01188_ _01435_ VGND VGND VPWR VPWR _00501_ sky130_fd_sc_hd__or4_1
XFILLER_72_27 VGND VGND VPWR VPWR sky130_fd_sc_hd__fill_1
XFILLER_25_665 VGND VGND VPWR VPWR sky130_fd_sc_hd__decap_6
X_09437_ _03189_ _03192_ _03193_ VGND VGND VPWR VPWR _03195_ sky130_fd_sc_hd__nand3_1
X_06649_ u_interface.fifo_data\[0\]\[2\] u_interface.fifo_data\[1\]\[2\] u_interface.fifo_data\[2\]\[2\]
+ u_interface.fifo_data\[3\]\[2\] net757 net740 VGND VGND VPWR VPWR _01222_ sky130_fd_sc_hd__mux4_1
XFILLER_9_809 VPWR VGND VPWR VGND sky130_ef_sc_hd__decap_12
XFILLER_40_613 VPWR VGND VPWR VGND sky130_ef_sc_hd__decap_12
X_09368_ _02868_ _03006_ _03008_ VGND VGND VPWR VPWR _03127_ sky130_fd_sc_hd__or3_1
XFILLER_24_197 VGND VGND VPWR VPWR sky130_fd_sc_hd__decap_8
X_09299_ _03023_ _03044_ _03056_ VGND VGND VPWR VPWR _03058_ sky130_fd_sc_hd__nand3_1
X_08319_ u_interface.u_gelu_fp32.s2_data\[19\] _02119_ VGND VGND VPWR VPWR _02122_
+ sky130_fd_sc_hd__or2_1
XFILLER_138_556 VGND VGND VPWR VPWR sky130_fd_sc_hd__fill_1
XFILLER_126_718 VGND VGND VPWR VPWR sky130_fd_sc_hd__fill_1
XFILLER_20_392 VPWR VGND VPWR VGND sky130_ef_sc_hd__decap_12
X_11330_ _05065_ _05070_ VGND VGND VPWR VPWR _05071_ sky130_fd_sc_hd__nand2_1
XFILLER_138_589 VPWR VGND VPWR VGND sky130_ef_sc_hd__decap_12
XFILLER_115_3 VPWR VGND VPWR VGND sky130_ef_sc_hd__decap_12
XFILLER_4_525 VGND VGND VPWR VPWR sky130_fd_sc_hd__decap_6
XFILLER_134_740 VGND VGND VPWR VPWR sky130_fd_sc_hd__decap_3
XFILLER_106_442 VGND VGND VPWR VPWR sky130_fd_sc_hd__fill_1
X_11261_ _05000_ _05001_ VGND VGND VPWR VPWR _05003_ sky130_fd_sc_hd__xor2_2
XFILLER_137_86 VGND VGND VPWR VPWR sky130_fd_sc_hd__decap_4
XFILLER_134_784 VGND VGND VPWR VPWR sky130_fd_sc_hd__decap_8
X_13000_ net966 net350 net224 VGND VGND VPWR VPWR _01083_ sky130_fd_sc_hd__mux2_1
X_10212_ net196 _03962_ VGND VGND VPWR VPWR _03963_ sky130_fd_sc_hd__xnor2_1
XFILLER_79_304 VPWR VGND VPWR VGND sky130_ef_sc_hd__decap_12
X_11192_ _04931_ _04932_ VGND VGND VPWR VPWR _04934_ sky130_fd_sc_hd__or2_2
XFILLER_4_569 VPWR VGND VPWR VGND sky130_ef_sc_hd__decap_12
XFILLER_121_423 VPWR VGND VPWR VGND sky130_ef_sc_hd__decap_12
XFILLER_97_57 VGND VGND VPWR VPWR sky130_fd_sc_hd__fill_1
XFILLER_79_337 VPWR VGND VPWR VGND sky130_ef_sc_hd__decap_12
X_10143_ net465 net469 net673 net682 VGND VGND VPWR VPWR _03894_ sky130_fd_sc_hd__nand4_1
XFILLER_121_467 VGND VGND VPWR VPWR sky130_fd_sc_hd__decap_6
XFILLER_0_753 VGND VGND VPWR VPWR sky130_fd_sc_hd__decap_3
XFILLER_153_85 VGND VGND VPWR VPWR sky130_fd_sc_hd__decap_3
X_10074_ net463 net657 _03824_ _03825_ VGND VGND VPWR VPWR _03826_ sky130_fd_sc_hd__a22o_1
XFILLER_0_797 VGND VGND VPWR VPWR sky130_fd_sc_hd__decap_8
X_13902_ clknet_leaf_22_clk net891 VGND VGND VPWR VPWR u_interface.u_gelu_fp32.u_synth_top.s1_x\[6\]
+ sky130_fd_sc_hd__dfxtp_1
XFILLER_101_180 VPWR VGND VPWR VGND sky130_ef_sc_hd__decap_12
XFILLER_75_543 VGND VGND VPWR VPWR sky130_fd_sc_hd__fill_1
XFILLER_47_245 VPWR VGND VPWR VGND sky130_ef_sc_hd__decap_12
XFILLER_90_502 VGND VGND VPWR VPWR sky130_fd_sc_hd__fill_1
XFILLER_63_727 VGND VGND VPWR VPWR sky130_fd_sc_hd__fill_1
XFILLER_47_289 VGND VGND VPWR VPWR sky130_fd_sc_hd__fill_2
XTAP_TAPCELL_ROW_18_616 VGND VPWR sky130_fd_sc_hd__tapvpwrvgnd_1
X_13833_ clknet_leaf_78_clk _00843_ VGND VGND VPWR VPWR u_interface.u_gelu_fp32.u_synth_top.s3_mult\[51\]
+ sky130_fd_sc_hd__dfxtp_1
XFILLER_35_407 VPWR VGND VPWR VGND sky130_ef_sc_hd__decap_12
XFILLER_16_643 VGND VGND VPWR VPWR sky130_fd_sc_hd__fill_1
XTAP_TAPCELL_ROW_18_627 VGND VPWR sky130_fd_sc_hd__tapvpwrvgnd_1
X_10976_ _04603_ _04611_ _04610_ VGND VGND VPWR VPWR _04720_ sky130_fd_sc_hd__a21oi_1
X_13764_ clknet_leaf_82_clk _00774_ VGND VGND VPWR VPWR u_interface.u_gelu_fp32.u_q16_to_fp32.s1_mag\[30\]
+ sky130_fd_sc_hd__dfxtp_1
X_13695_ clknet_leaf_18_clk _00705_ VGND VGND VPWR VPWR u_interface.u_gelu_fp32.u_fp32_to_q16.round_bit
+ sky130_fd_sc_hd__dfxtp_1
X_12715_ net299 _06368_ _06369_ VGND VGND VPWR VPWR _00922_ sky130_fd_sc_hd__a21o_1
XFILLER_71_782 VGND VGND VPWR VPWR sky130_fd_sc_hd__fill_2
XTAP_TAPCELL_ROW_44_1038 VGND VPWR sky130_fd_sc_hd__tapvpwrvgnd_1
XFILLER_15_186 VGND VGND VPWR VPWR sky130_fd_sc_hd__fill_2
XFILLER_30_112 VGND VGND VPWR VPWR sky130_fd_sc_hd__fill_2
XFILLER_148_309 VPWR VGND VPWR VGND sky130_ef_sc_hd__decap_12
XTAP_TAPCELL_ROW_139_2555 VGND VPWR sky130_fd_sc_hd__tapvpwrvgnd_1
XFILLER_129_501 VGND VGND VPWR VPWR sky130_fd_sc_hd__decap_3
X_12646_ net1712 u_interface.u_gelu_fp32.u_q16_to_fp32.s2_mag\[1\] net806 VGND VGND
+ VPWR VPWR _00882_ sky130_fd_sc_hd__mux2_1
XFILLER_70_292 VPWR VGND VPWR VGND sky130_ef_sc_hd__decap_12
XFILLER_30_134 VGND VGND VPWR VPWR sky130_fd_sc_hd__fill_1
XFILLER_30_145 VPWR VGND VPWR VGND sky130_ef_sc_hd__decap_12
XTAP_TAPCELL_ROW_139_2566 VGND VPWR sky130_fd_sc_hd__tapvpwrvgnd_1
XFILLER_129_545 VGND VGND VPWR VPWR sky130_fd_sc_hd__fill_1
X_12577_ net18 net17 net19 net24 VGND VGND VPWR VPWR _06281_ sky130_fd_sc_hd__or4_2
XFILLER_7_330 VGND VGND VPWR VPWR sky130_fd_sc_hd__fill_1
XFILLER_7_55 VGND VGND VPWR VPWR sky130_fd_sc_hd__fill_1
XFILLER_12_893 VPWR VGND VPWR VGND sky130_ef_sc_hd__decap_12
XTAP_TAPCELL_ROW_152_2766 VGND VPWR sky130_fd_sc_hd__tapvpwrvgnd_1
Xhold308 u_interface.fifo_tuser\[0\] VGND VGND VPWR VPWR net1173 sky130_fd_sc_hd__dlygate4sd3_1
XFILLER_117_729 VPWR VGND VPWR VGND sky130_ef_sc_hd__decap_12
XFILLER_7_352 VGND VGND VPWR VPWR sky130_fd_sc_hd__decap_8
X_11528_ net642 net650 net403 net398 VGND VGND VPWR VPWR _05267_ sky130_fd_sc_hd__and4_1
Xhold319 u_interface.fifo_tuser\[2\] VGND VGND VPWR VPWR net1184 sky130_fd_sc_hd__dlygate4sd3_1
X_11459_ _05143_ _05198_ VGND VGND VPWR VPWR _05199_ sky130_fd_sc_hd__xor2_1
XFILLER_152_570 VGND VGND VPWR VPWR sky130_fd_sc_hd__fill_2
XFILLER_124_250 VGND VGND VPWR VPWR sky130_fd_sc_hd__fill_2
XFILLER_98_602 VGND VGND VPWR VPWR sky130_fd_sc_hd__fill_1
XTAP_TAPCELL_ROW_59_1281 VGND VPWR sky130_fd_sc_hd__tapvpwrvgnd_1
XFILLER_97_123 VGND VGND VPWR VPWR sky130_fd_sc_hd__fill_1
X_13129_ clknet_leaf_49_clk _00139_ VGND VGND VPWR VPWR u_interface.fifo_data\[2\]\[18\]
+ sky130_fd_sc_hd__dfxtp_1
XFILLER_112_456 VGND VGND VPWR VPWR sky130_fd_sc_hd__fill_1
XFILLER_30_3 VPWR VGND VPWR VGND sky130_ef_sc_hd__decap_12
XFILLER_78_381 VGND VGND VPWR VPWR sky130_fd_sc_hd__decap_4
XTAP_TAPCELL_ROW_72_1492 VGND VPWR sky130_fd_sc_hd__tapvpwrvgnd_1
XTAP_TAPCELL_ROW_72_1481 VGND VPWR sky130_fd_sc_hd__tapvpwrvgnd_1
XFILLER_39_724 VGND VGND VPWR VPWR sky130_fd_sc_hd__decap_4
X_08670_ net152 _02432_ net795 VGND VGND VPWR VPWR _00804_ sky130_fd_sc_hd__a21oi_1
XFILLER_94_885 VGND VGND VPWR VPWR sky130_fd_sc_hd__decap_3
X_07621_ net330 _01698_ VGND VGND VPWR VPWR _01713_ sky130_fd_sc_hd__nand2_1
XTAP_TAPCELL_ROW_37_925 VGND VPWR sky130_fd_sc_hd__tapvpwrvgnd_1
X_07552_ net544 _01619_ VGND VGND VPWR VPWR _01668_ sky130_fd_sc_hd__and2b_1
XFILLER_81_557 VGND VGND VPWR VPWR sky130_fd_sc_hd__decap_3
X_06503_ net1686 VGND VGND VPWR VPWR _01103_ sky130_fd_sc_hd__inv_2
X_07483_ _01574_ _01578_ net556 VGND VGND VPWR VPWR _01616_ sky130_fd_sc_hd__mux2_1
XFILLER_22_613 VPWR VGND VPWR VGND sky130_ef_sc_hd__decap_12
XFILLER_148_810 VGND VGND VPWR VPWR sky130_fd_sc_hd__fill_2
X_09222_ _02965_ _02979_ _02980_ VGND VGND VPWR VPWR _02981_ sky130_fd_sc_hd__nand3_1
XFILLER_61_281 VGND VGND VPWR VPWR sky130_fd_sc_hd__decap_4
XFILLER_22_657 VPWR VGND VPWR VGND sky130_ef_sc_hd__decap_12
XFILLER_148_821 VGND VGND VPWR VPWR sky130_fd_sc_hd__fill_2
X_09153_ _02909_ _02911_ _02861_ _02870_ VGND VGND VPWR VPWR _02912_ sky130_fd_sc_hd__a211o_1
XTAP_TAPCELL_ROW_79_1602 VGND VPWR sky130_fd_sc_hd__tapvpwrvgnd_1
XFILLER_21_167 VGND VGND VPWR VPWR sky130_fd_sc_hd__fill_1
XFILLER_148_876 VGND VGND VPWR VPWR sky130_fd_sc_hd__decap_8
X_08104_ u_interface.u_gelu_fp32.u_fp32_to_q16.s3_mag\[9\] _01878_ VGND VGND VPWR
+ VPWR _01952_ sky130_fd_sc_hd__xnor2_1
XFILLER_108_718 VGND VGND VPWR VPWR sky130_fd_sc_hd__fill_1
X_09084_ _02833_ _02842_ VGND VGND VPWR VPWR _02843_ sky130_fd_sc_hd__nor2_1
Xinput80 s_axis_tdata[15] VGND VGND VPWR VPWR net80 sky130_fd_sc_hd__clkbuf_1
Xinput91 s_axis_tdata[25] VGND VGND VPWR VPWR net91 sky130_fd_sc_hd__clkbuf_1
XFILLER_135_559 VGND VGND VPWR VPWR sky130_fd_sc_hd__fill_1
X_08035_ u_interface.u_gelu_fp32.u_fp32_to_q16.s3_mag\[28\] u_interface.u_gelu_fp32.u_fp32_to_q16.s3_mag\[27\]
+ _01891_ VGND VGND VPWR VPWR _01892_ sky130_fd_sc_hd__and3_1
XTAP_TAPCELL_ROW_92_1813 VGND VPWR sky130_fd_sc_hd__tapvpwrvgnd_1
XTAP_TAPCELL_ROW_92_1802 VGND VPWR sky130_fd_sc_hd__tapvpwrvgnd_1
Xhold820 _00890_ VGND VGND VPWR VPWR net1685 sky130_fd_sc_hd__dlygate4sd3_1
XFILLER_131_710 VGND VGND VPWR VPWR sky130_fd_sc_hd__fill_2
Xhold842 u_interface.u_gelu_fp32.u_fp32_to_q16.s3_mag\[29\] VGND VGND VPWR VPWR net1707
+ sky130_fd_sc_hd__dlygate4sd3_1
Xhold831 u_interface.u_gelu_fp32.u_fp32_to_q16.s3_mag\[28\] VGND VGND VPWR VPWR net1696
+ sky130_fd_sc_hd__dlygate4sd3_1
Xhold864 u_interface.u_gelu_fp32.u_fp32_to_q16.s3_mag\[27\] VGND VGND VPWR VPWR net1729
+ sky130_fd_sc_hd__dlygate4sd3_1
XFILLER_116_773 VGND VGND VPWR VPWR sky130_fd_sc_hd__fill_2
Xhold853 u_interface.u_gelu_fp32.u_fp32_to_q16.s3_mag\[13\] VGND VGND VPWR VPWR net1718
+ sky130_fd_sc_hd__dlygate4sd3_1
XFILLER_89_602 VGND VGND VPWR VPWR sky130_fd_sc_hd__decap_3
XFILLER_1_517 VPWR VGND VPWR VGND sky130_ef_sc_hd__decap_12
Xhold886 u_interface.u_gelu_fp32.u_fp32_to_q16.s3_mag\[6\] VGND VGND VPWR VPWR net1751
+ sky130_fd_sc_hd__dlygate4sd3_1
Xhold897 u_interface.u_gelu_fp32.u_fp32_to_q16.s3_mag\[14\] VGND VGND VPWR VPWR net1762
+ sky130_fd_sc_hd__dlygate4sd3_1
Xhold875 u_interface.u_gelu_fp32.u_synth_top.s1_hits\[8\] VGND VGND VPWR VPWR net1740
+ sky130_fd_sc_hd__dlygate4sd3_1
X_09986_ _03625_ _03627_ VGND VGND VPWR VPWR _03739_ sky130_fd_sc_hd__or2_1
XFILLER_67_27 VPWR VGND VPWR VGND sky130_ef_sc_hd__decap_12
X_08937_ _02693_ _02694_ _02676_ VGND VGND VPWR VPWR _02696_ sky130_fd_sc_hd__o21ai_1
XFILLER_88_189 VGND VGND VPWR VPWR sky130_fd_sc_hd__decap_6
XFILLER_67_49 VGND VGND VPWR VPWR sky130_fd_sc_hd__decap_6
X_08868_ _02625_ _02626_ VGND VGND VPWR VPWR _02627_ sky130_fd_sc_hd__nor2_1
XFILLER_29_223 VGND VGND VPWR VPWR sky130_fd_sc_hd__fill_1
XTAP_TAPCELL_ROW_123_2301 VGND VPWR sky130_fd_sc_hd__tapvpwrvgnd_1
X_07819_ net959 net350 net232 VGND VGND VPWR VPWR _00580_ sky130_fd_sc_hd__mux2_1
XFILLER_83_15 VGND VGND VPWR VPWR sky130_fd_sc_hd__decap_6
XTAP_TAPCELL_ROW_4_399 VGND VPWR sky130_fd_sc_hd__tapvpwrvgnd_1
X_08799_ _02509_ _02515_ _02514_ VGND VGND VPWR VPWR _02558_ sky130_fd_sc_hd__a21o_1
XFILLER_83_48 VGND VGND VPWR VPWR sky130_fd_sc_hd__decap_8
X_10830_ net473 _04462_ _04463_ _04343_ VGND VGND VPWR VPWR _04575_ sky130_fd_sc_hd__o22a_1
XFILLER_16_53 VPWR VGND VPWR VGND sky130_ef_sc_hd__decap_12
X_10761_ _04491_ _04504_ _04505_ VGND VGND VPWR VPWR _04507_ sky130_fd_sc_hd__nand3_2
X_13480_ clknet_leaf_1_clk _00490_ VGND VGND VPWR VPWR u_interface.u_gelu_fp32.u_synth_top.s2_b\[13\]
+ sky130_fd_sc_hd__dfxtp_1
X_10692_ _04194_ _04195_ _04316_ _04438_ _04315_ VGND VGND VPWR VPWR _04439_ sky130_fd_sc_hd__o311a_1
XFILLER_52_281 VPWR VGND VPWR VGND sky130_ef_sc_hd__decap_12
XFILLER_9_617 VPWR VGND VPWR VGND sky130_ef_sc_hd__decap_12
X_12500_ _06223_ _06224_ VGND VGND VPWR VPWR _06225_ sky130_fd_sc_hd__and2_1
XFILLER_16_97 VPWR VGND VPWR VGND sky130_ef_sc_hd__decap_12
XFILLER_40_421 VGND VGND VPWR VPWR sky130_fd_sc_hd__decap_8
XFILLER_138_320 VGND VGND VPWR VPWR sky130_fd_sc_hd__fill_1
XTAP_TAPCELL_ROW_101_1953 VGND VPWR sky130_fd_sc_hd__tapvpwrvgnd_1
X_12431_ _06129_ _06157_ VGND VGND VPWR VPWR _06158_ sky130_fd_sc_hd__xnor2_1
XFILLER_148_41 VGND VGND VPWR VPWR sky130_fd_sc_hd__decap_4
XTAP_TAPCELL_ROW_23_696 VGND VPWR sky130_fd_sc_hd__tapvpwrvgnd_1
XFILLER_32_41 VPWR VGND VPWR VGND sky130_ef_sc_hd__decap_12
XFILLER_154_813 VGND VGND VPWR VPWR sky130_fd_sc_hd__decap_6
X_12362_ _06087_ _06088_ VGND VGND VPWR VPWR _06090_ sky130_fd_sc_hd__xor2_1
XFILLER_32_85 VGND VGND VPWR VPWR sky130_fd_sc_hd__decap_4
XFILLER_32_96 VGND VGND VPWR VPWR sky130_fd_sc_hd__decap_6
XFILLER_148_85 VGND VGND VPWR VPWR sky130_fd_sc_hd__fill_1
XTAP_TAPCELL_ROW_134_2485 VGND VPWR sky130_fd_sc_hd__tapvpwrvgnd_1
XTAP_TAPCELL_ROW_134_2474 VGND VPWR sky130_fd_sc_hd__tapvpwrvgnd_1
X_14101_ clknet_leaf_27_clk _01027_ VGND VGND VPWR VPWR u_interface.meta_tuser_pipe\[6\]
+ sky130_fd_sc_hd__dfxtp_1
X_11313_ net694 net434 _05051_ _05052_ VGND VGND VPWR VPWR _05054_ sky130_fd_sc_hd__nand4_1
X_12293_ net710 net390 _06020_ VGND VGND VPWR VPWR _06022_ sky130_fd_sc_hd__and3_1
XFILLER_4_333 VPWR VGND VPWR VGND sky130_ef_sc_hd__decap_12
XFILLER_153_378 VGND VGND VPWR VPWR sky130_fd_sc_hd__fill_1
XFILLER_113_209 VGND VGND VPWR VPWR sky130_fd_sc_hd__decap_4
X_14032_ clknet_leaf_50_clk _00958_ VGND VGND VPWR VPWR u_interface.core_data_out\[18\]
+ sky130_fd_sc_hd__dfxtp_1
XFILLER_5_889 VGND VGND VPWR VPWR sky130_fd_sc_hd__decap_6
X_11244_ net602 net392 VGND VGND VPWR VPWR _04986_ sky130_fd_sc_hd__nand2_1
XFILLER_122_721 VGND VGND VPWR VPWR sky130_fd_sc_hd__decap_4
XFILLER_4_377 VPWR VGND VPWR VGND sky130_ef_sc_hd__decap_12
X_11175_ _04687_ _04802_ VGND VGND VPWR VPWR _04917_ sky130_fd_sc_hd__nand2_1
XFILLER_94_115 VGND VGND VPWR VPWR sky130_fd_sc_hd__fill_1
X_10126_ _03875_ _03876_ _03864_ VGND VGND VPWR VPWR _03877_ sky130_fd_sc_hd__a21oi_1
XFILLER_79_189 VPWR VGND VPWR VGND sky130_ef_sc_hd__decap_12
XFILLER_0_561 VPWR VGND VPWR VGND sky130_ef_sc_hd__decap_12
XFILLER_121_297 VPWR VGND VPWR VGND sky130_ef_sc_hd__decap_12
X_10057_ _03807_ _03808_ VGND VGND VPWR VPWR _03809_ sky130_fd_sc_hd__and2b_1
XFILLER_90_365 VPWR VGND VPWR VGND sky130_ef_sc_hd__decap_12
X_13816_ clknet_leaf_89_clk _00826_ VGND VGND VPWR VPWR u_interface.u_gelu_fp32.u_synth_top.s3_mult\[34\]
+ sky130_fd_sc_hd__dfxtp_1
XFILLER_73_81 VPWR VGND VPWR VGND sky130_ef_sc_hd__decap_12
X_13747_ clknet_leaf_87_clk _00757_ VGND VGND VPWR VPWR u_interface.u_gelu_fp32.u_q16_to_fp32.s1_mag\[13\]
+ sky130_fd_sc_hd__dfxtp_1
X_10959_ net452 net704 net712 net456 VGND VGND VPWR VPWR _04703_ sky130_fd_sc_hd__a22o_1
XFILLER_50_229 VGND VGND VPWR VPWR sky130_fd_sc_hd__fill_2
XFILLER_31_421 VGND VGND VPWR VPWR sky130_fd_sc_hd__fill_2
XFILLER_31_443 VGND VGND VPWR VPWR sky130_fd_sc_hd__decap_4
XFILLER_43_281 VPWR VGND VPWR VGND sky130_ef_sc_hd__decap_12
XTAP_TAPCELL_ROW_154_2806 VGND VPWR sky130_fd_sc_hd__tapvpwrvgnd_1
X_13678_ clknet_leaf_14_clk _00688_ VGND VGND VPWR VPWR u_interface.u_gelu_fp32.u_fp32_to_q16.s3_frac\[14\]
+ sky130_fd_sc_hd__dfxtp_1
X_12629_ _06320_ _06330_ VGND VGND VPWR VPWR _06331_ sky130_fd_sc_hd__nand2_1
XFILLER_78_3 VGND VGND VPWR VPWR sky130_fd_sc_hd__decap_8
XFILLER_144_345 VGND VGND VPWR VPWR sky130_fd_sc_hd__fill_1
XFILLER_117_548 VGND VGND VPWR VPWR sky130_fd_sc_hd__fill_2
Xhold116 u_interface.fifo_data\[14\]\[17\] VGND VGND VPWR VPWR net981 sky130_fd_sc_hd__dlygate4sd3_1
Xhold105 u_interface.fifo_data\[5\]\[24\] VGND VGND VPWR VPWR net970 sky130_fd_sc_hd__dlygate4sd3_1
XFILLER_7_193 VPWR VGND VPWR VGND sky130_ef_sc_hd__decap_12
Xhold149 u_interface.fifo_data\[1\]\[13\] VGND VGND VPWR VPWR net1014 sky130_fd_sc_hd__dlygate4sd3_1
Xhold127 u_interface.fifo_data\[13\]\[17\] VGND VGND VPWR VPWR net992 sky130_fd_sc_hd__dlygate4sd3_1
XTAP_TAPCELL_ROW_74_1521 VGND VPWR sky130_fd_sc_hd__tapvpwrvgnd_1
Xhold138 u_interface.fifo_data\[5\]\[2\] VGND VGND VPWR VPWR net1003 sky130_fd_sc_hd__dlygate4sd3_1
XFILLER_98_421 VGND VGND VPWR VPWR sky130_fd_sc_hd__fill_2
XFILLER_140_551 VGND VGND VPWR VPWR sky130_fd_sc_hd__decap_8
Xfanout629 net630 VGND VGND VPWR VPWR net629 sky130_fd_sc_hd__buf_2
XFILLER_113_765 VGND VGND VPWR VPWR sky130_fd_sc_hd__decap_3
Xfanout607 net608 VGND VGND VPWR VPWR net607 sky130_fd_sc_hd__buf_2
X_09840_ _03583_ _03593_ VGND VGND VPWR VPWR _03594_ sky130_fd_sc_hd__xnor2_1
Xfanout618 net619 VGND VGND VPWR VPWR net618 sky130_fd_sc_hd__buf_2
X_06983_ _01502_ _01506_ VGND VGND VPWR VPWR _01507_ sky130_fd_sc_hd__nor2_2
X_09771_ _03321_ _03523_ _03525_ _03417_ VGND VGND VPWR VPWR _03526_ sky130_fd_sc_hd__o211a_1
XFILLER_112_253 VGND VGND VPWR VPWR sky130_fd_sc_hd__decap_8
XFILLER_100_415 VGND VGND VPWR VPWR sky130_fd_sc_hd__fill_1
XFILLER_58_329 VGND VGND VPWR VPWR sky130_fd_sc_hd__fill_1
XFILLER_39_510 VPWR VGND VPWR VGND sky130_ef_sc_hd__decap_12
X_08722_ net621 net484 VGND VGND VPWR VPWR _02481_ sky130_fd_sc_hd__nand2_1
XFILLER_100_459 VGND VGND VPWR VPWR sky130_fd_sc_hd__decap_8
XFILLER_82_822 VGND VGND VPWR VPWR sky130_fd_sc_hd__fill_1
XFILLER_27_727 VGND VGND VPWR VPWR sky130_fd_sc_hd__fill_1
XFILLER_39_565 VGND VGND VPWR VPWR sky130_fd_sc_hd__fill_1
XTAP_TAPCELL_ROW_105_2020 VGND VPWR sky130_fd_sc_hd__tapvpwrvgnd_1
X_08653_ _02418_ _02419_ VGND VGND VPWR VPWR _02420_ sky130_fd_sc_hd__nor2_1
XTAP_TAPCELL_ROW_1_347 VGND VPWR sky130_fd_sc_hd__tapvpwrvgnd_1
XTAP_TAPCELL_ROW_1_358 VGND VPWR sky130_fd_sc_hd__tapvpwrvgnd_1
XFILLER_26_226 VPWR VGND VPWR VGND sky130_ef_sc_hd__decap_12
X_08584_ net155 _02370_ net823 VGND VGND VPWR VPWR _00780_ sky130_fd_sc_hd__a21oi_1
X_07604_ net807 net1562 net281 _01699_ VGND VGND VPWR VPWR _00470_ sky130_fd_sc_hd__a22o_1
X_07535_ net821 net1730 net305 _01600_ VGND VGND VPWR VPWR _00440_ sky130_fd_sc_hd__a22o_1
XTAP_TAPCELL_ROW_85_1694 VGND VPWR sky130_fd_sc_hd__tapvpwrvgnd_1
XFILLER_149_9 VPWR VGND VPWR VGND sky130_ef_sc_hd__decap_12
X_07466_ net816 net1483 net300 _01600_ VGND VGND VPWR VPWR _00431_ sky130_fd_sc_hd__a22o_1
XFILLER_22_421 VGND VGND VPWR VPWR sky130_fd_sc_hd__fill_1
X_09205_ _02941_ _02942_ _02944_ VGND VGND VPWR VPWR _02964_ sky130_fd_sc_hd__a21o_1
X_07397_ net1480 net563 net237 VGND VGND VPWR VPWR _00427_ sky130_fd_sc_hd__mux2_1
X_09136_ _02891_ _02893_ _02894_ VGND VGND VPWR VPWR _02895_ sky130_fd_sc_hd__nand3_1
XTAP_TAPCELL_ROW_20_655 VGND VPWR sky130_fd_sc_hd__tapvpwrvgnd_1
X_09067_ _02823_ _02825_ VGND VGND VPWR VPWR _02826_ sky130_fd_sc_hd__nand2_1
XFILLER_135_345 VGND VGND VPWR VPWR sky130_fd_sc_hd__decap_3
X_08018_ u_interface.u_gelu_fp32.u_fp32_to_q16.s3_mag\[4\] u_interface.u_gelu_fp32.u_fp32_to_q16.s3_mag\[3\]
+ _01874_ VGND VGND VPWR VPWR _01875_ sky130_fd_sc_hd__and3_1
XTAP_TAPCELL_ROW_116_2193 VGND VPWR sky130_fd_sc_hd__tapvpwrvgnd_1
XFILLER_135_389 VGND VGND VPWR VPWR sky130_fd_sc_hd__decap_3
XFILLER_123_529 VGND VGND VPWR VPWR sky130_fd_sc_hd__decap_6
Xhold661 u_interface.fifo_data\[11\]\[24\] VGND VGND VPWR VPWR net1526 sky130_fd_sc_hd__dlygate4sd3_1
Xhold672 u_interface.fifo_data\[3\]\[25\] VGND VGND VPWR VPWR net1537 sky130_fd_sc_hd__dlygate4sd3_1
XFILLER_78_48 VGND VGND VPWR VPWR sky130_fd_sc_hd__decap_6
Xhold650 u_interface.fifo_data\[14\]\[20\] VGND VGND VPWR VPWR net1515 sky130_fd_sc_hd__dlygate4sd3_1
XFILLER_2_837 VPWR VGND VPWR VGND sky130_ef_sc_hd__decap_12
Xhold683 u_interface.fifo_data\[11\]\[29\] VGND VGND VPWR VPWR net1548 sky130_fd_sc_hd__dlygate4sd3_1
XFILLER_104_754 VGND VGND VPWR VPWR sky130_fd_sc_hd__fill_2
XFILLER_103_231 VGND VGND VPWR VPWR sky130_fd_sc_hd__fill_1
Xhold694 u_interface.fifo_data\[12\]\[20\] VGND VGND VPWR VPWR net1559 sky130_fd_sc_hd__dlygate4sd3_1
X_09969_ _03687_ _03719_ _03720_ VGND VGND VPWR VPWR _03722_ sky130_fd_sc_hd__and3_1
XFILLER_77_638 VGND VGND VPWR VPWR sky130_fd_sc_hd__fill_1
XFILLER_134_54 VGND VGND VPWR VPWR sky130_fd_sc_hd__decap_8
XFILLER_76_137 VGND VGND VPWR VPWR sky130_fd_sc_hd__decap_3
X_12980_ u_interface.fifo_count\[5\] _06494_ _06495_ net828 VGND VGND VPWR VPWR _06497_
+ sky130_fd_sc_hd__a31o_1
XFILLER_94_69 VGND VGND VPWR VPWR sky130_fd_sc_hd__decap_8
XFILLER_85_671 VGND VGND VPWR VPWR sky130_fd_sc_hd__fill_1
XFILLER_91_129 VGND VGND VPWR VPWR sky130_fd_sc_hd__fill_1
XFILLER_84_170 VGND VGND VPWR VPWR sky130_fd_sc_hd__decap_3
XFILLER_18_749 VGND VGND VPWR VPWR sky130_fd_sc_hd__decap_6
X_11931_ _05663_ _05664_ VGND VGND VPWR VPWR _05665_ sky130_fd_sc_hd__and2b_1
XFILLER_150_53 VPWR VGND VPWR VGND sky130_ef_sc_hd__decap_12
XFILLER_72_365 VGND VGND VPWR VPWR sky130_fd_sc_hd__decap_6
X_11862_ _05587_ _05595_ VGND VGND VPWR VPWR _05597_ sky130_fd_sc_hd__and2_1
X_13601_ clknet_leaf_32_clk _00611_ VGND VGND VPWR VPWR u_interface.fifo_data\[3\]\[16\]
+ sky130_fd_sc_hd__dfxtp_1
X_10813_ _04453_ _04455_ VGND VGND VPWR VPWR _04558_ sky130_fd_sc_hd__nand2_1
XFILLER_60_516 VPWR VGND VPWR VGND sky130_ef_sc_hd__decap_12
XFILLER_26_793 VPWR VGND VPWR VGND sky130_ef_sc_hd__decap_12
XTAP_TAPCELL_ROW_28_777 VGND VPWR sky130_fd_sc_hd__tapvpwrvgnd_1
XTAP_TAPCELL_ROW_28_788 VGND VPWR sky130_fd_sc_hd__tapvpwrvgnd_1
X_13532_ clknet_leaf_52_clk _00542_ VGND VGND VPWR VPWR u_interface.fifo_data\[5\]\[11\]
+ sky130_fd_sc_hd__dfxtp_1
X_11793_ net642 net387 VGND VGND VPWR VPWR _05529_ sky130_fd_sc_hd__and2b_1
XFILLER_25_281 VGND VGND VPWR VPWR sky130_fd_sc_hd__decap_4
XFILLER_25_292 VGND VGND VPWR VPWR sky130_fd_sc_hd__fill_1
X_10744_ _04386_ _04388_ VGND VGND VPWR VPWR _04490_ sky130_fd_sc_hd__nand2_1
XFILLER_9_414 VPWR VGND VPWR VGND sky130_ef_sc_hd__decap_12
XFILLER_40_251 VGND VGND VPWR VPWR sky130_fd_sc_hd__fill_1
XFILLER_43_51 VGND VGND VPWR VPWR sky130_fd_sc_hd__decap_4
XTAP_TAPCELL_ROW_136_2514 VGND VPWR sky130_fd_sc_hd__tapvpwrvgnd_1
X_13463_ clknet_leaf_60_clk _00473_ VGND VGND VPWR VPWR u_interface.u_gelu_fp32.u_q16_to_fp32.s3_norm_mag\[3\]
+ sky130_fd_sc_hd__dfxtp_1
X_10675_ _04340_ _04341_ _04418_ _04419_ VGND VGND VPWR VPWR _04422_ sky130_fd_sc_hd__nand4_1
XFILLER_9_436 VGND VGND VPWR VPWR sky130_fd_sc_hd__fill_1
XFILLER_40_273 VGND VGND VPWR VPWR sky130_fd_sc_hd__fill_1
XFILLER_40_295 VPWR VGND VPWR VGND sky130_ef_sc_hd__decap_12
X_13394_ clknet_leaf_42_clk _00404_ VGND VGND VPWR VPWR u_interface.fifo_data\[6\]\[7\]
+ sky130_fd_sc_hd__dfxtp_1
X_12414_ _06089_ _06091_ _06140_ VGND VGND VPWR VPWR _06141_ sky130_fd_sc_hd__nand3_1
X_12345_ net200 _06072_ VGND VGND VPWR VPWR _06073_ sky130_fd_sc_hd__nor2_1
XFILLER_114_518 VGND VGND VPWR VPWR sky130_fd_sc_hd__fill_1
XFILLER_5_653 VPWR VGND VPWR VGND sky130_ef_sc_hd__decap_12
XFILLER_4_141 VPWR VGND VPWR VGND sky130_ef_sc_hd__decap_12
XFILLER_154_698 VGND VGND VPWR VPWR sky130_fd_sc_hd__fill_2
XFILLER_141_337 VPWR VGND VPWR VGND sky130_ef_sc_hd__decap_12
XFILLER_141_315 VGND VGND VPWR VPWR sky130_fd_sc_hd__fill_1
XFILLER_5_697 VPWR VGND VPWR VGND sky130_ef_sc_hd__decap_12
X_12276_ net202 _05949_ _05950_ VGND VGND VPWR VPWR _06005_ sky130_fd_sc_hd__o21a_1
X_14015_ clknet_leaf_51_clk _00941_ VGND VGND VPWR VPWR u_interface.core_data_out\[1\]
+ sky130_fd_sc_hd__dfxtp_1
X_11227_ net643 net651 net416 net412 VGND VGND VPWR VPWR _04969_ sky130_fd_sc_hd__and4_1
X_11158_ _04793_ _04900_ VGND VGND VPWR VPWR _04901_ sky130_fd_sc_hd__nand2_1
X_10109_ _03740_ _03746_ _03859_ VGND VGND VPWR VPWR _03861_ sky130_fd_sc_hd__o21ai_1
XTAP_TAPCELL_ROW_147_2687 VGND VPWR sky130_fd_sc_hd__tapvpwrvgnd_1
X_11089_ net686 net694 net443 net438 VGND VGND VPWR VPWR _04832_ sky130_fd_sc_hd__and4_1
XFILLER_64_877 VGND VGND VPWR VPWR sky130_fd_sc_hd__decap_4
XFILLER_63_343 VPWR VGND VPWR VGND sky130_ef_sc_hd__decap_12
X_07320_ net1144 net350 net255 VGND VGND VPWR VPWR _00350_ sky130_fd_sc_hd__mux2_1
X_07251_ net1239 net354 net250 VGND VGND VPWR VPWR _00283_ sky130_fd_sc_hd__mux2_1
X_07182_ net1107 net341 net263 VGND VGND VPWR VPWR _00222_ sky130_fd_sc_hd__mux2_1
XFILLER_117_301 VGND VGND VPWR VPWR sky130_fd_sc_hd__fill_1
XFILLER_129_183 VPWR VGND VPWR VGND sky130_ef_sc_hd__decap_12
XFILLER_87_903 VGND VGND VPWR VPWR sky130_fd_sc_hd__fill_1
Xfanout404 u_interface.u_gelu_fp32.u_synth_top.s2_dx\[27\] VGND VGND VPWR VPWR net404
+ sky130_fd_sc_hd__buf_2
XFILLER_141_893 VGND VGND VPWR VPWR sky130_fd_sc_hd__decap_3
XFILLER_99_785 VGND VGND VPWR VPWR sky130_fd_sc_hd__decap_4
X_09823_ _03428_ _03575_ VGND VGND VPWR VPWR _03577_ sky130_fd_sc_hd__and2_1
XFILLER_98_273 VGND VGND VPWR VPWR sky130_fd_sc_hd__decap_8
XFILLER_98_251 VGND VGND VPWR VPWR sky130_fd_sc_hd__fill_1
Xfanout437 u_interface.u_gelu_fp32.u_synth_top.s2_dx\[20\] VGND VGND VPWR VPWR net437
+ sky130_fd_sc_hd__buf_2
Xfanout448 net449 VGND VGND VPWR VPWR net448 sky130_fd_sc_hd__buf_2
Xfanout426 u_interface.u_gelu_fp32.u_synth_top.s2_dx\[22\] VGND VGND VPWR VPWR net426
+ sky130_fd_sc_hd__dlymetal6s2s_1
XFILLER_59_638 VPWR VGND VPWR VGND sky130_ef_sc_hd__decap_12
XFILLER_58_115 VGND VGND VPWR VPWR sky130_fd_sc_hd__fill_1
XTAP_TAPCELL_ROW_6_439 VGND VPWR sky130_fd_sc_hd__tapvpwrvgnd_1
XTAP_TAPCELL_ROW_6_428 VGND VPWR sky130_fd_sc_hd__tapvpwrvgnd_1
Xfanout415 net416 VGND VGND VPWR VPWR net415 sky130_fd_sc_hd__buf_2
Xfanout459 u_interface.u_gelu_fp32.u_synth_top.s2_dx\[15\] VGND VGND VPWR VPWR net459
+ sky130_fd_sc_hd__clkbuf_2
XFILLER_58_137 VGND VGND VPWR VPWR sky130_fd_sc_hd__decap_3
X_09754_ net175 _03468_ _03506_ _03507_ VGND VGND VPWR VPWR _03509_ sky130_fd_sc_hd__o22a_1
X_06966_ _01476_ _01493_ VGND VGND VPWR VPWR _01494_ sky130_fd_sc_hd__nor2_1
XFILLER_74_608 VGND VGND VPWR VPWR sky130_fd_sc_hd__fill_2
X_08705_ _02462_ _02463_ VGND VGND VPWR VPWR _02464_ sky130_fd_sc_hd__or2_1
X_09685_ _03334_ _03336_ _03335_ VGND VGND VPWR VPWR _03440_ sky130_fd_sc_hd__a21bo_1
X_06897_ _01437_ _01438_ VGND VGND VPWR VPWR _01439_ sky130_fd_sc_hd__nor2_1
XTAP_TAPCELL_ROW_87_1734 VGND VPWR sky130_fd_sc_hd__tapvpwrvgnd_1
XTAP_TAPCELL_ROW_87_1723 VGND VPWR sky130_fd_sc_hd__tapvpwrvgnd_1
XFILLER_67_693 VGND VGND VPWR VPWR sky130_fd_sc_hd__fill_1
XFILLER_55_822 VGND VGND VPWR VPWR sky130_fd_sc_hd__fill_2
XFILLER_54_321 VGND VGND VPWR VPWR sky130_fd_sc_hd__fill_1
XPHY_EDGE_ROW_126_Right_126 VGND VGND VPWR VPWR sky130_fd_sc_hd__decap_3
X_08636_ _02253_ _02256_ VGND VGND VPWR VPWR _02407_ sky130_fd_sc_hd__xor2_1
XFILLER_54_365 VGND VGND VPWR VPWR sky130_fd_sc_hd__decap_4
XFILLER_42_527 VGND VGND VPWR VPWR sky130_fd_sc_hd__decap_4
XFILLER_120_56 VGND VGND VPWR VPWR sky130_fd_sc_hd__decap_3
XFILLER_81_195 VGND VGND VPWR VPWR sky130_fd_sc_hd__decap_6
XFILLER_54_398 VPWR VGND VPWR VGND sky130_ef_sc_hd__decap_12
XFILLER_23_741 VPWR VGND VPWR VGND sky130_ef_sc_hd__decap_12
XTAP_TAPCELL_ROW_25_736 VGND VPWR sky130_fd_sc_hd__tapvpwrvgnd_1
X_08567_ _02356_ _02357_ VGND VGND VPWR VPWR _02358_ sky130_fd_sc_hd__nand2_1
XFILLER_42_549 VGND VGND VPWR VPWR sky130_fd_sc_hd__fill_1
X_07518_ _01602_ _01604_ net551 VGND VGND VPWR VPWR _01648_ sky130_fd_sc_hd__mux2_1
XFILLER_80_27 VGND VGND VPWR VPWR sky130_fd_sc_hd__fill_1
XFILLER_23_785 VPWR VGND VPWR VGND sky130_ef_sc_hd__decap_12
X_08498_ _02283_ _02288_ VGND VGND VPWR VPWR _02289_ sky130_fd_sc_hd__nand2_1
X_07449_ net554 _01582_ _01583_ VGND VGND VPWR VPWR _01584_ sky130_fd_sc_hd__o21ai_1
XTAP_TAPCELL_ROW_118_2222 VGND VPWR sky130_fd_sc_hd__tapvpwrvgnd_1
XFILLER_10_413 VGND VGND VPWR VPWR sky130_fd_sc_hd__decap_6
X_10460_ net277 _03869_ _04206_ VGND VGND VPWR VPWR _04208_ sky130_fd_sc_hd__nand3_1
X_09119_ net597 net496 _02876_ _02874_ VGND VGND VPWR VPWR _02878_ sky130_fd_sc_hd__a31o_1
XFILLER_129_54 VGND VGND VPWR VPWR sky130_fd_sc_hd__fill_2
XTAP_TAPCELL_ROW_131_2433 VGND VPWR sky130_fd_sc_hd__tapvpwrvgnd_1
XFILLER_109_879 VGND VGND VPWR VPWR sky130_fd_sc_hd__fill_1
XFILLER_108_356 VGND VGND VPWR VPWR sky130_fd_sc_hd__fill_2
XTAP_TAPCELL_ROW_98_1896 VGND VPWR sky130_fd_sc_hd__tapvpwrvgnd_1
X_10391_ _04138_ _04139_ _04107_ VGND VGND VPWR VPWR _04140_ sky130_fd_sc_hd__a21o_1
XFILLER_151_613 VGND VGND VPWR VPWR sky130_fd_sc_hd__decap_3
XFILLER_136_698 VGND VGND VPWR VPWR sky130_fd_sc_hd__fill_2
XFILLER_123_337 VGND VGND VPWR VPWR sky130_fd_sc_hd__decap_4
XFILLER_123_315 VGND VGND VPWR VPWR sky130_fd_sc_hd__decap_3
XFILLER_108_389 VGND VGND VPWR VPWR sky130_fd_sc_hd__fill_1
XFILLER_2_601 VPWR VGND VPWR VGND sky130_ef_sc_hd__decap_12
X_12130_ _05787_ _05790_ _05861_ VGND VGND VPWR VPWR _05862_ sky130_fd_sc_hd__and3_1
Xhold480 u_interface.fifo_data\[5\]\[30\] VGND VGND VPWR VPWR net1345 sky130_fd_sc_hd__dlygate4sd3_1
XFILLER_8_3 VPWR VGND VPWR VGND sky130_ef_sc_hd__decap_12
XFILLER_1_111 VGND VGND VPWR VPWR sky130_fd_sc_hd__fill_1
XFILLER_2_645 VPWR VGND VPWR VGND sky130_ef_sc_hd__decap_12
X_12061_ _05640_ _05719_ _05720_ VGND VGND VPWR VPWR _05794_ sky130_fd_sc_hd__a21oi_1
XFILLER_132_893 VGND VGND VPWR VPWR sky130_fd_sc_hd__decap_4
Xhold491 u_interface.fifo_data\[11\]\[13\] VGND VGND VPWR VPWR net1356 sky130_fd_sc_hd__dlygate4sd3_1
X_11012_ _04752_ _04755_ VGND VGND VPWR VPWR _04756_ sky130_fd_sc_hd__xnor2_1
XFILLER_46_811 VGND VGND VPWR VPWR sky130_fd_sc_hd__fill_1
X_12963_ u_interface.fifo_count\[3\] _06467_ VGND VGND VPWR VPWR _06482_ sky130_fd_sc_hd__nand2_1
XTAP_TAPCELL_ROW_129_2395 VGND VPWR sky130_fd_sc_hd__tapvpwrvgnd_1
XFILLER_64_129 VGND VGND VPWR VPWR sky130_fd_sc_hd__fill_2
Xclkbuf_leaf_84_clk clknet_3_4__leaf_clk VGND VGND VPWR VPWR clknet_leaf_84_clk sky130_fd_sc_hd__clkbuf_8
X_11914_ _05641_ _05646_ _05648_ VGND VGND VPWR VPWR _00832_ sky130_fd_sc_hd__a21oi_1
X_12894_ net785 net933 VGND VGND VPWR VPWR _01036_ sky130_fd_sc_hd__and2_1
XFILLER_54_83 VGND VGND VPWR VPWR sky130_fd_sc_hd__fill_1
X_11845_ _05333_ _05502_ VGND VGND VPWR VPWR _05580_ sky130_fd_sc_hd__nand2_1
X_11776_ _05439_ _05441_ _05440_ VGND VGND VPWR VPWR _05512_ sky130_fd_sc_hd__o21bai_1
X_13515_ clknet_leaf_42_clk _00525_ VGND VGND VPWR VPWR u_interface.core_data_out\[26\]
+ sky130_fd_sc_hd__dfxtp_1
X_10727_ net460 net704 _04471_ _04472_ VGND VGND VPWR VPWR _04473_ sky130_fd_sc_hd__a22o_1
X_13446_ clknet_leaf_10_clk _00456_ VGND VGND VPWR VPWR u_interface.u_gelu_fp32.u_fp32_to_q16.s3_mag\[17\]
+ sky130_fd_sc_hd__dfxtp_1
XFILLER_9_277 VGND VGND VPWR VPWR sky130_fd_sc_hd__decap_3
Xclkload25 clknet_leaf_10_clk VGND VGND VPWR VPWR clkload25/Y sky130_fd_sc_hd__inv_6
Xclkload14 clknet_leaf_25_clk VGND VGND VPWR VPWR clkload14/Y sky130_fd_sc_hd__inv_12
X_10658_ _04403_ _04404_ _04398_ VGND VGND VPWR VPWR _04405_ sky130_fd_sc_hd__a21o_1
X_13377_ clknet_leaf_35_clk _00387_ VGND VGND VPWR VPWR u_interface.fifo_data\[7\]\[22\]
+ sky130_fd_sc_hd__dfxtp_1
Xclkload69 clknet_leaf_33_clk VGND VGND VPWR VPWR clkload69/Y sky130_fd_sc_hd__inv_6
Xclkload36 clknet_leaf_22_clk VGND VGND VPWR VPWR clkload36/Y sky130_fd_sc_hd__clkinv_2
X_10589_ _04334_ _04335_ net189 VGND VGND VPWR VPWR _04336_ sky130_fd_sc_hd__a21o_1
Xclkload58 clknet_leaf_68_clk VGND VGND VPWR VPWR clkload58/X sky130_fd_sc_hd__clkbuf_4
Xclkload47 clknet_leaf_80_clk VGND VGND VPWR VPWR clkload47/Y sky130_fd_sc_hd__inv_8
XFILLER_5_461 VPWR VGND VPWR VGND sky130_ef_sc_hd__decap_12
X_12328_ _05990_ _05993_ VGND VGND VPWR VPWR _06057_ sky130_fd_sc_hd__and2_1
XTAP_TAPCELL_ROW_149_2727 VGND VPWR sky130_fd_sc_hd__tapvpwrvgnd_1
XTAP_TAPCELL_ROW_149_2716 VGND VPWR sky130_fd_sc_hd__tapvpwrvgnd_1
XFILLER_114_337 VGND VGND VPWR VPWR sky130_fd_sc_hd__fill_1
X_12259_ _05867_ _05921_ _05920_ VGND VGND VPWR VPWR _05989_ sky130_fd_sc_hd__a21o_1
XFILLER_141_178 VGND VGND VPWR VPWR sky130_fd_sc_hd__decap_6
XFILLER_68_435 VPWR VGND VPWR VGND sky130_ef_sc_hd__decap_12
X_06820_ _01367_ _01368_ _01371_ net318 VGND VGND VPWR VPWR net124 sky130_fd_sc_hd__a22o_1
XFILLER_37_800 VGND VGND VPWR VPWR sky130_fd_sc_hd__fill_1
XFILLER_110_587 VGND VGND VPWR VPWR sky130_fd_sc_hd__fill_1
XFILLER_83_449 VGND VGND VPWR VPWR sky130_fd_sc_hd__decap_8
X_06751_ u_interface.fifo_data\[12\]\[15\] u_interface.fifo_data\[13\]\[15\] u_interface.fifo_data\[14\]\[15\]
+ u_interface.fifo_data\[15\]\[15\] net761 net744 VGND VGND VPWR VPWR _01311_ sky130_fd_sc_hd__mux4_1
XFILLER_48_170 VPWR VGND VPWR VGND sky130_ef_sc_hd__decap_12
X_09470_ _03203_ _03205_ VGND VGND VPWR VPWR _03227_ sky130_fd_sc_hd__nand2b_1
XTAP_TAPCELL_ROW_69_1442 VGND VPWR sky130_fd_sc_hd__tapvpwrvgnd_1
XFILLER_64_641 VGND VGND VPWR VPWR sky130_fd_sc_hd__decap_3
X_06682_ u_interface.fifo_data\[4\]\[6\] u_interface.fifo_data\[5\]\[6\] u_interface.fifo_data\[6\]\[6\]
+ u_interface.fifo_data\[7\]\[6\] net755 net738 VGND VGND VPWR VPWR _01251_ sky130_fd_sc_hd__mux4_1
Xclkbuf_leaf_75_clk clknet_3_5__leaf_clk VGND VGND VPWR VPWR clknet_leaf_75_clk sky130_fd_sc_hd__clkbuf_8
X_08421_ u_interface.u_gelu_fp32.u_synth_top.s3_mult\[17\] u_interface.u_gelu_fp32.u_synth_top.s3_b\[1\]
+ VGND VGND VPWR VPWR _02212_ sky130_fd_sc_hd__xor2_1
XFILLER_63_173 VGND VGND VPWR VPWR sky130_fd_sc_hd__decap_4
XFILLER_24_516 VGND VGND VPWR VPWR sky130_fd_sc_hd__fill_2
XFILLER_36_365 VGND VGND VPWR VPWR sky130_fd_sc_hd__decap_4
XTAP_TAPCELL_ROW_82_1642 VGND VPWR sky130_fd_sc_hd__tapvpwrvgnd_1
XTAP_TAPCELL_ROW_82_1653 VGND VPWR sky130_fd_sc_hd__tapvpwrvgnd_1
XFILLER_51_357 VGND VGND VPWR VPWR sky130_fd_sc_hd__decap_4
X_08352_ net528 _02146_ net1629 VGND VGND VPWR VPWR _02147_ sky130_fd_sc_hd__a21oi_1
X_08283_ u_interface.u_gelu_fp32.s2_data\[10\] _02092_ VGND VGND VPWR VPWR _02095_
+ sky130_fd_sc_hd__or2_1
X_07303_ net1171 net385 net253 VGND VGND VPWR VPWR _00333_ sky130_fd_sc_hd__mux2_1
X_07234_ net1660 _01532_ net828 VGND VGND VPWR VPWR _01534_ sky130_fd_sc_hd__a21oi_1
XFILLER_149_289 VGND VGND VPWR VPWR sky130_fd_sc_hd__decap_4
XFILLER_149_267 VGND VGND VPWR VPWR sky130_fd_sc_hd__fill_2
Xclkload8 clknet_leaf_1_clk VGND VGND VPWR VPWR clkload8/Y sky130_fd_sc_hd__inv_12
XFILLER_20_755 VGND VGND VPWR VPWR sky130_fd_sc_hd__fill_1
XFILLER_145_440 VGND VGND VPWR VPWR sky130_fd_sc_hd__decap_4
X_07165_ net1453 net374 net261 VGND VGND VPWR VPWR _00205_ sky130_fd_sc_hd__mux2_1
XFILLER_145_473 VGND VGND VPWR VPWR sky130_fd_sc_hd__fill_1
XFILLER_117_186 VGND VGND VPWR VPWR sky130_fd_sc_hd__fill_2
XFILLER_117_164 VGND VGND VPWR VPWR sky130_fd_sc_hd__decap_4
XTAP_TAPCELL_ROW_113_2141 VGND VPWR sky130_fd_sc_hd__tapvpwrvgnd_1
X_07096_ net1220 net354 net226 VGND VGND VPWR VPWR _00136_ sky130_fd_sc_hd__mux2_1
XFILLER_105_337 VPWR VGND VPWR VGND sky130_ef_sc_hd__decap_12
Xfanout223 net224 VGND VGND VPWR VPWR net223 sky130_fd_sc_hd__buf_4
XFILLER_120_307 VGND VGND VPWR VPWR sky130_fd_sc_hd__fill_1
Xfanout212 net213 VGND VGND VPWR VPWR net212 sky130_fd_sc_hd__clkbuf_2
Xfanout201 _05408_ VGND VGND VPWR VPWR net201 sky130_fd_sc_hd__clkbuf_4
Xfanout256 _01511_ VGND VGND VPWR VPWR net256 sky130_fd_sc_hd__clkbuf_4
Xfanout234 _01518_ VGND VGND VPWR VPWR net234 sky130_fd_sc_hd__clkbuf_4
Xfanout245 net246 VGND VGND VPWR VPWR net245 sky130_fd_sc_hd__buf_4
Xfanout278 _01839_ VGND VGND VPWR VPWR net278 sky130_fd_sc_hd__buf_2
Xfanout267 net268 VGND VGND VPWR VPWR net267 sky130_fd_sc_hd__buf_4
X_07998_ _01862_ _01863_ VGND VGND VPWR VPWR _00701_ sky130_fd_sc_hd__or2_1
Xfanout289 net290 VGND VGND VPWR VPWR net289 sky130_fd_sc_hd__clkbuf_2
X_09806_ _03557_ _03558_ _03540_ VGND VGND VPWR VPWR _03560_ sky130_fd_sc_hd__o21ai_1
XFILLER_86_265 VPWR VGND VPWR VGND sky130_ef_sc_hd__decap_12
X_09737_ _03490_ _03491_ _03484_ VGND VGND VPWR VPWR _03492_ sky130_fd_sc_hd__a21o_1
X_06949_ u_interface.u_gelu_fp32.u_synth_top.s1_x\[27\] net275 VGND VGND VPWR VPWR
+ _01480_ sky130_fd_sc_hd__xnor2_1
XFILLER_28_811 VGND VGND VPWR VPWR sky130_fd_sc_hd__fill_1
XFILLER_131_11 VGND VGND VPWR VPWR sky130_fd_sc_hd__fill_1
Xclkbuf_leaf_66_clk clknet_3_5__leaf_clk VGND VGND VPWR VPWR clknet_leaf_66_clk sky130_fd_sc_hd__clkbuf_8
XFILLER_27_321 VGND VGND VPWR VPWR sky130_fd_sc_hd__decap_6
X_09668_ net607 net450 VGND VGND VPWR VPWR _03423_ sky130_fd_sc_hd__nand2_1
XFILLER_91_15 VPWR VGND VPWR VGND sky130_ef_sc_hd__decap_12
XFILLER_55_663 VGND VGND VPWR VPWR sky130_fd_sc_hd__decap_8
XFILLER_54_151 VGND VGND VPWR VPWR sky130_fd_sc_hd__decap_4
XFILLER_15_505 VPWR VGND VPWR VGND sky130_ef_sc_hd__decap_12
X_09599_ _03278_ _03354_ VGND VGND VPWR VPWR _03355_ sky130_fd_sc_hd__nand2_1
X_08619_ net157 _02393_ _02394_ VGND VGND VPWR VPWR _02395_ sky130_fd_sc_hd__nand3_1
X_11630_ _05363_ _05367_ VGND VGND VPWR VPWR _05368_ sky130_fd_sc_hd__xnor2_1
XFILLER_30_519 VPWR VGND VPWR VGND sky130_ef_sc_hd__decap_12
XFILLER_42_368 VPWR VGND VPWR VGND sky130_ef_sc_hd__decap_12
X_11561_ _05216_ _05299_ VGND VGND VPWR VPWR _05300_ sky130_fd_sc_hd__xnor2_1
XFILLER_24_53 VPWR VGND VPWR VGND sky130_ef_sc_hd__decap_12
X_10512_ net644 net653 net445 net440 VGND VGND VPWR VPWR _04260_ sky130_fd_sc_hd__and4_1
X_13300_ clknet_leaf_71_clk _00310_ VGND VGND VPWR VPWR u_interface.fifo_data\[8\]\[9\]
+ sky130_fd_sc_hd__dfxtp_1
XFILLER_24_97 VPWR VGND VPWR VGND sky130_ef_sc_hd__decap_12
XFILLER_155_237 VGND VGND VPWR VPWR sky130_fd_sc_hd__decap_4
X_11492_ net205 _05230_ VGND VGND VPWR VPWR _05231_ sky130_fd_sc_hd__xnor2_1
XFILLER_11_777 VGND VGND VPWR VPWR sky130_fd_sc_hd__decap_6
XFILLER_155_259 VGND VGND VPWR VPWR sky130_fd_sc_hd__decap_3
XFILLER_136_440 VPWR VGND VPWR VGND sky130_ef_sc_hd__decap_12
XFILLER_124_602 VGND VGND VPWR VPWR sky130_fd_sc_hd__fill_2
X_10443_ _04190_ _04191_ VGND VGND VPWR VPWR _04192_ sky130_fd_sc_hd__and2b_1
X_13231_ clknet_leaf_62_clk _00241_ VGND VGND VPWR VPWR u_interface.fifo_data\[11\]\[9\]
+ sky130_fd_sc_hd__dfxtp_1
XFILLER_6_269 VGND VGND VPWR VPWR sky130_fd_sc_hd__fill_2
X_13162_ clknet_leaf_67_clk _00172_ VGND VGND VPWR VPWR u_interface.fifo_data\[9\]\[4\]
+ sky130_fd_sc_hd__dfxtp_1
X_10374_ _04018_ _04021_ VGND VGND VPWR VPWR _04123_ sky130_fd_sc_hd__nand2_1
XFILLER_40_85 VPWR VGND VPWR VGND sky130_ef_sc_hd__decap_12
XFILLER_108_197 VPWR VGND VPWR VGND sky130_ef_sc_hd__decap_12
X_12113_ _05814_ _05844_ VGND VGND VPWR VPWR _05845_ sky130_fd_sc_hd__xor2_1
XFILLER_123_167 VGND VGND VPWR VPWR sky130_fd_sc_hd__fill_1
X_13093_ clknet_leaf_42_clk _00103_ VGND VGND VPWR VPWR u_interface.fifo_data\[15\]\[14\]
+ sky130_fd_sc_hd__dfxtp_1
XFILLER_2_475 VGND VGND VPWR VPWR sky130_fd_sc_hd__fill_1
XFILLER_49_61 VGND VGND VPWR VPWR sky130_fd_sc_hd__fill_1
X_12044_ _05734_ _05776_ VGND VGND VPWR VPWR _05777_ sky130_fd_sc_hd__xnor2_1
XTAP_TAPCELL_ROW_144_2646 VGND VPWR sky130_fd_sc_hd__tapvpwrvgnd_1
XTAP_TAPCELL_ROW_144_2635 VGND VPWR sky130_fd_sc_hd__tapvpwrvgnd_1
Xfanout790 net791 VGND VGND VPWR VPWR net790 sky130_fd_sc_hd__buf_2
XFILLER_77_298 VGND VGND VPWR VPWR sky130_fd_sc_hd__fill_2
XFILLER_19_833 VGND VGND VPWR VPWR sky130_fd_sc_hd__decap_6
Xclkbuf_leaf_57_clk clknet_3_1__leaf_clk VGND VGND VPWR VPWR clknet_leaf_57_clk sky130_fd_sc_hd__clkbuf_8
X_13995_ clknet_leaf_55_clk _00921_ VGND VGND VPWR VPWR u_interface.u_gelu_fp32.u_q16_to_fp32.s3_norm_mag\[22\]
+ sky130_fd_sc_hd__dfxtp_1
XFILLER_65_449 VPWR VGND VPWR VGND sky130_ef_sc_hd__decap_12
XFILLER_46_630 VGND VGND VPWR VPWR sky130_fd_sc_hd__decap_3
XFILLER_1_57 VPWR VGND VPWR VGND sky130_ef_sc_hd__decap_12
X_12946_ _06466_ _06467_ VGND VGND VPWR VPWR _06468_ sky130_fd_sc_hd__or2_2
XFILLER_92_279 VGND VGND VPWR VPWR sky130_fd_sc_hd__decap_8
XFILLER_18_365 VPWR VGND VPWR VGND sky130_ef_sc_hd__decap_12
XFILLER_19_877 VPWR VGND VPWR VGND sky130_ef_sc_hd__decap_12
XFILLER_34_825 VPWR VGND VPWR VGND sky130_ef_sc_hd__decap_12
X_12877_ _06433_ VGND VGND VPWR VPWR _01020_ sky130_fd_sc_hd__inv_2
XFILLER_61_655 VGND VGND VPWR VPWR sky130_fd_sc_hd__fill_1
XFILLER_61_633 VGND VGND VPWR VPWR sky130_fd_sc_hd__fill_1
XFILLER_33_313 VGND VGND VPWR VPWR sky130_fd_sc_hd__fill_1
XFILLER_34_869 VPWR VGND VPWR VGND sky130_ef_sc_hd__decap_12
XTAP_TAPCELL_ROW_64_1361 VGND VPWR sky130_fd_sc_hd__tapvpwrvgnd_1
XFILLER_60_165 VGND VGND VPWR VPWR sky130_fd_sc_hd__decap_8
X_11828_ _05478_ _05485_ VGND VGND VPWR VPWR _05564_ sky130_fd_sc_hd__and2_1
XTAP_TAPCELL_ROW_16_588 VGND VPWR sky130_fd_sc_hd__tapvpwrvgnd_1
XTAP_TAPCELL_ROW_16_599 VGND VPWR sky130_fd_sc_hd__tapvpwrvgnd_1
XFILLER_119_418 VGND VGND VPWR VPWR sky130_fd_sc_hd__fill_2
X_11759_ net201 _05494_ VGND VGND VPWR VPWR _05495_ sky130_fd_sc_hd__nor2_1
XFILLER_146_215 VGND VGND VPWR VPWR sky130_fd_sc_hd__fill_1
X_13429_ clknet_leaf_18_clk _00439_ VGND VGND VPWR VPWR u_interface.u_gelu_fp32.u_fp32_to_q16.s3_mag\[0\]
+ sky130_fd_sc_hd__dfxtp_1
XFILLER_60_3 VPWR VGND VPWR VGND sky130_ef_sc_hd__decap_12
XFILLER_154_270 VPWR VGND VPWR VGND sky130_ef_sc_hd__decap_12
XFILLER_115_613 VGND VGND VPWR VPWR sky130_fd_sc_hd__decap_3
XFILLER_6_781 VPWR VGND VPWR VGND sky130_ef_sc_hd__decap_12
XFILLER_142_465 VGND VGND VPWR VPWR sky130_fd_sc_hd__decap_6
X_08970_ _02570_ _02722_ _02721_ VGND VGND VPWR VPWR _02729_ sky130_fd_sc_hd__a21o_1
XFILLER_114_178 VPWR VGND VPWR VGND sky130_ef_sc_hd__decap_12
XFILLER_114_167 VGND VGND VPWR VPWR sky130_fd_sc_hd__decap_6
XFILLER_102_307 VGND VGND VPWR VPWR sky130_fd_sc_hd__fill_1
X_07921_ _01813_ _01814_ VGND VGND VPWR VPWR _01815_ sky130_fd_sc_hd__nand2_1
XFILLER_96_530 VGND VGND VPWR VPWR sky130_fd_sc_hd__fill_2
XFILLER_68_221 VGND VGND VPWR VPWR sky130_fd_sc_hd__fill_1
X_07852_ net348 net1491 net285 VGND VGND VPWR VPWR _00613_ sky130_fd_sc_hd__mux2_1
XFILLER_96_552 VPWR VGND VPWR VGND sky130_ef_sc_hd__decap_12
Xinput1 m_axis_tready VGND VGND VPWR VPWR net1 sky130_fd_sc_hd__buf_1
XFILLER_110_384 VGND VGND VPWR VPWR sky130_fd_sc_hd__decap_8
X_06803_ _01355_ _01356_ net730 VGND VGND VPWR VPWR _01357_ sky130_fd_sc_hd__mux2_1
X_07783_ net1002 net358 net235 VGND VGND VPWR VPWR _00544_ sky130_fd_sc_hd__mux2_1
X_09522_ _03276_ _03277_ VGND VGND VPWR VPWR _03279_ sky130_fd_sc_hd__xnor2_1
Xclkbuf_leaf_48_clk clknet_3_7__leaf_clk VGND VGND VPWR VPWR clknet_leaf_48_clk sky130_fd_sc_hd__clkbuf_8
XFILLER_37_641 VPWR VGND VPWR VGND sky130_ef_sc_hd__decap_12
X_06734_ u_interface.fifo_data\[8\]\[13\] u_interface.fifo_data\[9\]\[13\] u_interface.fifo_data\[10\]\[13\]
+ u_interface.fifo_data\[11\]\[13\] net767 net750 VGND VGND VPWR VPWR _01296_ sky130_fd_sc_hd__mux4_1
XFILLER_83_279 VGND VGND VPWR VPWR sky130_fd_sc_hd__fill_1
XFILLER_24_302 VGND VGND VPWR VPWR sky130_fd_sc_hd__decap_6
X_09453_ _03208_ _03209_ _03168_ VGND VGND VPWR VPWR _03211_ sky130_fd_sc_hd__a21oi_1
X_06665_ u_interface.fifo_data\[0\]\[4\] u_interface.fifo_data\[1\]\[4\] u_interface.fifo_data\[2\]\[4\]
+ u_interface.fifo_data\[3\]\[4\] net761 net744 VGND VGND VPWR VPWR _01236_ sky130_fd_sc_hd__mux4_1
XFILLER_36_184 VPWR VGND VPWR VGND sky130_ef_sc_hd__decap_12
X_09384_ net467 net616 net624 net470 VGND VGND VPWR VPWR _03142_ sky130_fd_sc_hd__a22o_1
X_08404_ u_interface.u_gelu_fp32.u_synth_top.s3_mult\[24\] u_interface.u_gelu_fp32.u_synth_top.s3_b\[8\]
+ VGND VGND VPWR VPWR _02195_ sky130_fd_sc_hd__nand2_1
XFILLER_51_154 VGND VGND VPWR VPWR sky130_fd_sc_hd__decap_6
XFILLER_101_69 VPWR VGND VPWR VGND sky130_ef_sc_hd__decap_12
X_06596_ u_interface.u_gelu_fp32.s1_data\[23\] u_interface.u_gelu_fp32.s1_data\[22\]
+ _01171_ _01172_ VGND VGND VPWR VPWR _01179_ sky130_fd_sc_hd__and4_1
XFILLER_51_198 VGND VGND VPWR VPWR sky130_fd_sc_hd__fill_1
X_08335_ u_interface.u_gelu_fp32.s2_data\[23\] _02131_ VGND VGND VPWR VPWR _02134_
+ sky130_fd_sc_hd__or2_1
XTAP_TAPCELL_ROW_35_897 VGND VPWR sky130_fd_sc_hd__tapvpwrvgnd_1
XFILLER_137_237 VPWR VGND VPWR VGND sky130_ef_sc_hd__decap_12
X_08266_ net947 _02081_ _02082_ VGND VGND VPWR VPWR _00750_ sky130_fd_sc_hd__a21oi_1
X_08197_ u_interface.u_gelu_fp32.u_fp32_to_q16.s3_mag\[24\] _01889_ VGND VGND VPWR
+ VPWR _02030_ sky130_fd_sc_hd__xnor2_1
X_07217_ net574 net1533 net258 VGND VGND VPWR VPWR _00257_ sky130_fd_sc_hd__mux2_1
XFILLER_152_218 VGND VGND VPWR VPWR sky130_fd_sc_hd__decap_6
XTAP_TAPCELL_ROW_95_1855 VGND VPWR sky130_fd_sc_hd__tapvpwrvgnd_1
X_07148_ net1422 net345 net217 VGND VGND VPWR VPWR _00188_ sky130_fd_sc_hd__mux2_1
XFILLER_3_217 VGND VGND VPWR VPWR sky130_fd_sc_hd__decap_6
XFILLER_145_281 VGND VGND VPWR VPWR sky130_fd_sc_hd__fill_1
XFILLER_105_123 VGND VGND VPWR VPWR sky130_fd_sc_hd__fill_1
XFILLER_105_167 VGND VGND VPWR VPWR sky130_fd_sc_hd__fill_1
X_07079_ net1195 net564 net208 VGND VGND VPWR VPWR _00119_ sky130_fd_sc_hd__mux2_1
XFILLER_10_77 VGND VGND VPWR VPWR sky130_fd_sc_hd__decap_6
XFILLER_0_902 VPWR VGND VPWR VGND sky130_ef_sc_hd__decap_12
XFILLER_102_841 VGND VGND VPWR VPWR sky130_fd_sc_hd__decap_6
X_10090_ _03839_ _03840_ _03804_ VGND VGND VPWR VPWR _03842_ sky130_fd_sc_hd__a21oi_1
XFILLER_86_15 VGND VGND VPWR VPWR sky130_fd_sc_hd__decap_6
XFILLER_75_736 VPWR VGND VPWR VGND sky130_ef_sc_hd__decap_12
Xclkbuf_leaf_39_clk clknet_3_7__leaf_clk VGND VGND VPWR VPWR clknet_leaf_39_clk sky130_fd_sc_hd__clkbuf_8
XTAP_TAPCELL_ROW_126_2354 VGND VPWR sky130_fd_sc_hd__tapvpwrvgnd_1
XFILLER_90_706 VGND VGND VPWR VPWR sky130_fd_sc_hd__fill_1
X_12800_ _01789_ _06416_ VGND VGND VPWR VPWR _00960_ sky130_fd_sc_hd__nor2_1
XFILLER_47_449 VGND VGND VPWR VPWR sky130_fd_sc_hd__fill_1
X_13780_ clknet_leaf_86_clk _00790_ VGND VGND VPWR VPWR u_interface.u_gelu_fp32.s2_data\[14\]
+ sky130_fd_sc_hd__dfxtp_1
XFILLER_62_419 VGND VGND VPWR VPWR sky130_fd_sc_hd__fill_1
X_10992_ _04624_ _04626_ _04735_ VGND VGND VPWR VPWR _04736_ sky130_fd_sc_hd__and3_1
XFILLER_16_825 VPWR VGND VPWR VGND sky130_ef_sc_hd__decap_12
X_12731_ u_interface.u_gelu_fp32.u_q16_to_fp32.s2_mag\[27\] u_interface.u_gelu_fp32.u_q16_to_fp32.s2_mag\[26\]
+ u_interface.u_gelu_fp32.u_q16_to_fp32.s2_mag\[25\] u_interface.u_gelu_fp32.u_q16_to_fp32.s2_mag\[24\]
+ net336 net332 VGND VGND VPWR VPWR _06382_ sky130_fd_sc_hd__mux4_1
XFILLER_55_482 VGND VGND VPWR VPWR sky130_fd_sc_hd__fill_1
XFILLER_43_633 VGND VGND VPWR VPWR sky130_fd_sc_hd__fill_1
X_12662_ u_interface.u_gelu_fp32.u_q16_to_fp32.s1_mag\[17\] net1699 net802 VGND VGND
+ VPWR VPWR _00898_ sky130_fd_sc_hd__mux2_1
XFILLER_16_869 VPWR VGND VPWR VGND sky130_ef_sc_hd__decap_12
XTAP_TAPCELL_ROW_104_1995 VGND VPWR sky130_fd_sc_hd__tapvpwrvgnd_1
XFILLER_15_379 VGND VGND VPWR VPWR sky130_fd_sc_hd__decap_4
XFILLER_30_316 VGND VGND VPWR VPWR sky130_fd_sc_hd__decap_8
XFILLER_31_839 VGND VGND VPWR VPWR sky130_fd_sc_hd__fill_1
X_11613_ net692 net420 _05349_ _05350_ VGND VGND VPWR VPWR _05351_ sky130_fd_sc_hd__a22o_1
X_12593_ u_interface.u_gelu_fp32.u_q16_to_fp32.s1_mag\[29\] u_interface.u_gelu_fp32.u_q16_to_fp32.s1_mag\[28\]
+ u_interface.u_gelu_fp32.u_q16_to_fp32.s1_mag\[31\] VGND VGND VPWR VPWR _06296_ sky130_fd_sc_hd__or3_1
XFILLER_11_541 VPWR VGND VPWR VGND sky130_ef_sc_hd__decap_12
XTAP_TAPCELL_ROW_13_536 VGND VPWR sky130_fd_sc_hd__tapvpwrvgnd_1
XTAP_TAPCELL_ROW_13_547 VGND VPWR sky130_fd_sc_hd__tapvpwrvgnd_1
XFILLER_129_738 VGND VGND VPWR VPWR sky130_fd_sc_hd__decap_8
XFILLER_11_585 VPWR VGND VPWR VGND sky130_ef_sc_hd__decap_12
X_11544_ _05265_ _05282_ VGND VGND VPWR VPWR _05283_ sky130_fd_sc_hd__xnor2_2
X_11475_ _05213_ _05214_ VGND VGND VPWR VPWR _05215_ sky130_fd_sc_hd__xnor2_1
X_13214_ clknet_leaf_46_clk _00224_ VGND VGND VPWR VPWR u_interface.fifo_data\[12\]\[24\]
+ sky130_fd_sc_hd__dfxtp_1
X_10426_ _04173_ _04174_ _04059_ VGND VGND VPWR VPWR _04175_ sky130_fd_sc_hd__o21ai_2
XFILLER_124_421 VGND VGND VPWR VPWR sky130_fd_sc_hd__decap_8
X_13145_ clknet_leaf_36_clk _00155_ VGND VGND VPWR VPWR u_interface.fifo_tlast\[12\]
+ sky130_fd_sc_hd__dfxtp_1
XFILLER_98_817 VGND VGND VPWR VPWR sky130_fd_sc_hd__fill_1
XFILLER_97_305 VGND VGND VPWR VPWR sky130_fd_sc_hd__decap_8
X_10357_ _04084_ _04102_ _04103_ VGND VGND VPWR VPWR _04106_ sky130_fd_sc_hd__nand3_1
X_13076_ clknet_leaf_45_clk _00086_ VGND VGND VPWR VPWR u_interface.fifo_data\[14\]\[29\]
+ sky130_fd_sc_hd__dfxtp_1
XFILLER_97_349 VGND VGND VPWR VPWR sky130_fd_sc_hd__fill_1
X_10288_ _04035_ _04036_ net594 net422 VGND VGND VPWR VPWR _04038_ sky130_fd_sc_hd__and4bb_1
X_12027_ _05757_ _05758_ VGND VGND VPWR VPWR _05760_ sky130_fd_sc_hd__xnor2_1
XFILLER_93_522 VPWR VGND VPWR VGND sky130_ef_sc_hd__decap_12
XFILLER_93_500 VGND VGND VPWR VPWR sky130_fd_sc_hd__decap_4
XFILLER_76_70 VGND VGND VPWR VPWR sky130_fd_sc_hd__decap_8
XFILLER_65_257 VGND VGND VPWR VPWR sky130_fd_sc_hd__fill_1
XFILLER_19_641 VPWR VGND VPWR VGND sky130_ef_sc_hd__decap_12
X_13978_ clknet_leaf_84_clk net1717 VGND VGND VPWR VPWR u_interface.u_gelu_fp32.u_q16_to_fp32.s2_mag\[23\]
+ sky130_fd_sc_hd__dfxtp_1
XFILLER_19_685 VPWR VGND VPWR VGND sky130_ef_sc_hd__decap_12
X_12929_ u_interface.in_flight_count\[3\] _06439_ VGND VGND VPWR VPWR _06454_ sky130_fd_sc_hd__xnor2_1
XFILLER_18_195 VGND VGND VPWR VPWR sky130_fd_sc_hd__fill_1
XFILLER_61_441 VGND VGND VPWR VPWR sky130_fd_sc_hd__fill_2
XFILLER_34_699 VGND VGND VPWR VPWR sky130_fd_sc_hd__fill_1
XTAP_TAPCELL_ROW_32_845 VGND VPWR sky130_fd_sc_hd__tapvpwrvgnd_1
X_08120_ net291 _01965_ VGND VGND VPWR VPWR _00721_ sky130_fd_sc_hd__nor2_1
XFILLER_30_861 VGND VGND VPWR VPWR sky130_fd_sc_hd__decap_6
X_08051_ _01900_ _01902_ _01907_ u_interface.u_gelu_fp32.u_fp32_to_q16.round_bit VGND
+ VGND VPWR VPWR _01908_ sky130_fd_sc_hd__o31ai_1
X_07002_ net1273 net326 net235 VGND VGND VPWR VPWR _00050_ sky130_fd_sc_hd__mux2_1
XFILLER_116_900 VGND VGND VPWR VPWR sky130_fd_sc_hd__decap_4
XFILLER_127_281 VGND VGND VPWR VPWR sky130_fd_sc_hd__decap_4
XTAP_TAPCELL_ROW_110_2100 VGND VPWR sky130_fd_sc_hd__tapvpwrvgnd_1
XTAP_TAPCELL_ROW_77_1574 VGND VPWR sky130_fd_sc_hd__tapvpwrvgnd_1
XTAP_TAPCELL_ROW_77_1563 VGND VPWR sky130_fd_sc_hd__tapvpwrvgnd_1
XFILLER_142_240 VPWR VGND VPWR VGND sky130_ef_sc_hd__decap_12
XFILLER_89_839 VGND VGND VPWR VPWR sky130_fd_sc_hd__fill_1
XFILLER_88_305 VGND VGND VPWR VPWR sky130_fd_sc_hd__decap_3
XFILLER_0_209 VPWR VGND VPWR VGND sky130_ef_sc_hd__decap_12
XFILLER_142_295 VGND VGND VPWR VPWR sky130_fd_sc_hd__fill_1
X_08953_ _02561_ _02563_ VGND VGND VPWR VPWR _02712_ sky130_fd_sc_hd__xnor2_1
XFILLER_88_327 VGND VGND VPWR VPWR sky130_fd_sc_hd__decap_8
X_07904_ net778 net98 VGND VGND VPWR VPWR _00663_ sky130_fd_sc_hd__and2_1
XTAP_TAPCELL_ROW_90_1774 VGND VPWR sky130_fd_sc_hd__tapvpwrvgnd_1
X_08884_ net466 net605 net470 net614 VGND VGND VPWR VPWR _02643_ sky130_fd_sc_hd__nand4_1
XFILLER_56_29 VPWR VGND VPWR VGND sky130_ef_sc_hd__decap_12
X_07835_ net382 net1393 net285 VGND VGND VPWR VPWR _00596_ sky130_fd_sc_hd__mux2_1
XFILLER_84_555 VGND VGND VPWR VPWR sky130_fd_sc_hd__decap_6
XFILLER_84_533 VGND VGND VPWR VPWR sky130_fd_sc_hd__decap_8
XFILLER_29_449 VGND VGND VPWR VPWR sky130_fd_sc_hd__fill_1
XTAP_TAPCELL_ROW_108_2062 VGND VPWR sky130_fd_sc_hd__tapvpwrvgnd_1
X_07766_ net1571 net294 _01801_ VGND VGND VPWR VPWR _00528_ sky130_fd_sc_hd__and3_1
XFILLER_25_600 VPWR VGND VPWR VGND sky130_ef_sc_hd__decap_12
X_09505_ _03261_ VGND VGND VPWR VPWR _03262_ sky130_fd_sc_hd__inv_2
X_06717_ u_interface.fifo_data\[8\]\[11\] u_interface.fifo_data\[9\]\[11\] u_interface.fifo_data\[10\]\[11\]
+ u_interface.fifo_data\[11\]\[11\] net763 net746 VGND VGND VPWR VPWR _01281_ sky130_fd_sc_hd__mux4_1
X_09436_ _03192_ _03193_ _03189_ VGND VGND VPWR VPWR _03194_ sky130_fd_sc_hd__a21o_1
X_07697_ _01128_ _01755_ _00500_ VGND VGND VPWR VPWR _00499_ sky130_fd_sc_hd__or3_2
XFILLER_24_121 VGND VGND VPWR VPWR sky130_fd_sc_hd__decap_3
XTAP_TAPCELL_ROW_121_2273 VGND VPWR sky130_fd_sc_hd__tapvpwrvgnd_1
XFILLER_52_496 VGND VGND VPWR VPWR sky130_fd_sc_hd__fill_1
XFILLER_52_474 VGND VGND VPWR VPWR sky130_fd_sc_hd__fill_2
X_06648_ net320 _01220_ net725 VGND VGND VPWR VPWR _01221_ sky130_fd_sc_hd__o21a_1
XFILLER_13_839 VGND VGND VPWR VPWR sky130_fd_sc_hd__fill_1
XFILLER_40_625 VPWR VGND VPWR VGND sky130_ef_sc_hd__decap_12
X_09367_ _03004_ _03007_ _02868_ VGND VGND VPWR VPWR _03126_ sky130_fd_sc_hd__a21o_1
X_06579_ _01150_ _01154_ _01157_ VGND VGND VPWR VPWR _00005_ sky130_fd_sc_hd__and3_1
X_09298_ _03023_ _03044_ _03056_ VGND VGND VPWR VPWR _03057_ sky130_fd_sc_hd__a21o_1
X_08318_ _02120_ _02121_ VGND VGND VPWR VPWR _00763_ sky130_fd_sc_hd__nor2_1
X_08249_ net533 u_interface.u_gelu_fp32.s2_data\[1\] u_interface.u_gelu_fp32.s2_data\[0\]
+ net823 VGND VGND VPWR VPWR _02071_ sky130_fd_sc_hd__a31o_1
XFILLER_125_218 VGND VGND VPWR VPWR sky130_fd_sc_hd__decap_6
XFILLER_137_54 VGND VGND VPWR VPWR sky130_fd_sc_hd__fill_2
XFILLER_108_3 VGND VGND VPWR VPWR sky130_fd_sc_hd__decap_8
XFILLER_106_421 VGND VGND VPWR VPWR sky130_fd_sc_hd__decap_3
X_11260_ _05000_ _05001_ VGND VGND VPWR VPWR _05002_ sky130_fd_sc_hd__nor2_1
XFILLER_134_752 VGND VGND VPWR VPWR sky130_fd_sc_hd__decap_4
X_10211_ _03960_ _03961_ VGND VGND VPWR VPWR _03962_ sky130_fd_sc_hd__nor2_1
X_11191_ _04931_ _04932_ VGND VGND VPWR VPWR _04933_ sky130_fd_sc_hd__nor2_1
XFILLER_121_435 VPWR VGND VPWR VGND sky130_ef_sc_hd__decap_12
XFILLER_106_487 VPWR VGND VPWR VGND sky130_ef_sc_hd__decap_12
X_10142_ net473 net688 VGND VGND VPWR VPWR _03893_ sky130_fd_sc_hd__and2_1
XFILLER_79_316 VPWR VGND VPWR VGND sky130_ef_sc_hd__decap_12
X_10073_ net455 net641 net649 net459 VGND VGND VPWR VPWR _03825_ sky130_fd_sc_hd__a22o_1
X_13901_ clknet_leaf_22_clk net884 VGND VGND VPWR VPWR u_interface.u_gelu_fp32.u_synth_top.s1_x\[5\]
+ sky130_fd_sc_hd__dfxtp_1
XFILLER_101_192 VGND VGND VPWR VPWR sky130_fd_sc_hd__fill_2
XFILLER_48_747 VGND VGND VPWR VPWR sky130_fd_sc_hd__decap_8
XFILLER_47_257 VGND VGND VPWR VPWR sky130_fd_sc_hd__decap_8
XTAP_TAPCELL_ROW_18_617 VGND VPWR sky130_fd_sc_hd__tapvpwrvgnd_1
X_13832_ clknet_leaf_79_clk _00842_ VGND VGND VPWR VPWR u_interface.u_gelu_fp32.u_synth_top.s3_mult\[50\]
+ sky130_fd_sc_hd__dfxtp_1
XFILLER_35_419 VGND VGND VPWR VPWR sky130_fd_sc_hd__fill_1
XFILLER_90_536 VGND VGND VPWR VPWR sky130_fd_sc_hd__decap_8
XFILLER_63_739 VGND VGND VPWR VPWR sky130_fd_sc_hd__fill_1
XTAP_TAPCELL_ROW_18_628 VGND VPWR sky130_fd_sc_hd__tapvpwrvgnd_1
X_13763_ clknet_leaf_82_clk _00773_ VGND VGND VPWR VPWR u_interface.u_gelu_fp32.u_q16_to_fp32.s1_mag\[29\]
+ sky130_fd_sc_hd__dfxtp_1
X_12714_ net808 u_interface.u_gelu_fp32.u_q16_to_fp32.s3_norm_mag\[23\] _01725_ _06344_
+ VGND VGND VPWR VPWR _06369_ sky130_fd_sc_hd__a22o_1
X_10975_ _04717_ _04718_ VGND VGND VPWR VPWR _04719_ sky130_fd_sc_hd__and2b_1
X_13694_ clknet_leaf_13_clk _00704_ VGND VGND VPWR VPWR u_interface.u_gelu_fp32.u_fp32_to_q16.s3_frac\[30\]
+ sky130_fd_sc_hd__dfxtp_1
XFILLER_102_90 VGND VGND VPWR VPWR sky130_fd_sc_hd__fill_1
XFILLER_71_794 VGND VGND VPWR VPWR sky130_fd_sc_hd__decap_6
XFILLER_16_699 VGND VGND VPWR VPWR sky130_fd_sc_hd__fill_1
XFILLER_31_603 VPWR VGND VPWR VGND sky130_ef_sc_hd__decap_12
XTAP_TAPCELL_ROW_139_2556 VGND VPWR sky130_fd_sc_hd__tapvpwrvgnd_1
X_12645_ net937 u_interface.u_gelu_fp32.u_q16_to_fp32.s2_mag\[0\] net824 VGND VGND
+ VPWR VPWR _00881_ sky130_fd_sc_hd__mux2_1
XTAP_TAPCELL_ROW_44_1039 VGND VPWR sky130_fd_sc_hd__tapvpwrvgnd_1
X_12576_ net1602 _06279_ VGND VGND VPWR VPWR _06280_ sky130_fd_sc_hd__nand2_1
XTAP_TAPCELL_ROW_139_2567 VGND VPWR sky130_fd_sc_hd__tapvpwrvgnd_1
XFILLER_12_861 VGND VGND VPWR VPWR sky130_fd_sc_hd__decap_6
XFILLER_30_157 VPWR VGND VPWR VGND sky130_ef_sc_hd__decap_12
X_11527_ net659 net406 VGND VGND VPWR VPWR _05266_ sky130_fd_sc_hd__nand2_1
XTAP_TAPCELL_ROW_152_2767 VGND VPWR sky130_fd_sc_hd__tapvpwrvgnd_1
XFILLER_144_549 VGND VGND VPWR VPWR sky130_fd_sc_hd__fill_1
XFILLER_109_281 VGND VGND VPWR VPWR sky130_fd_sc_hd__decap_3
Xhold309 u_interface.fifo_data\[15\]\[24\] VGND VGND VPWR VPWR net1174 sky130_fd_sc_hd__dlygate4sd3_1
X_11458_ _05195_ _05196_ VGND VGND VPWR VPWR _05198_ sky130_fd_sc_hd__xor2_2
XFILLER_125_763 VGND VGND VPWR VPWR sky130_fd_sc_hd__fill_1
X_10409_ _04154_ _04157_ VGND VGND VPWR VPWR _04158_ sky130_fd_sc_hd__xnor2_1
XTAP_TAPCELL_ROW_59_1282 VGND VPWR sky130_fd_sc_hd__tapvpwrvgnd_1
X_11389_ _05045_ _05060_ _05061_ VGND VGND VPWR VPWR _05129_ sky130_fd_sc_hd__o21ba_1
X_13128_ clknet_leaf_26_clk _00138_ VGND VGND VPWR VPWR u_interface.fifo_data\[2\]\[17\]
+ sky130_fd_sc_hd__dfxtp_1
XFILLER_97_113 VGND VGND VPWR VPWR sky130_fd_sc_hd__fill_1
XFILLER_97_102 VGND VGND VPWR VPWR sky130_fd_sc_hd__decap_8
XFILLER_140_755 VGND VGND VPWR VPWR sky130_fd_sc_hd__fill_1
XFILLER_97_146 VGND VGND VPWR VPWR sky130_fd_sc_hd__fill_1
XFILLER_87_80 VPWR VGND VPWR VGND sky130_ef_sc_hd__decap_12
XFILLER_79_894 VGND VGND VPWR VPWR sky130_fd_sc_hd__fill_2
XFILLER_78_360 VGND VGND VPWR VPWR sky130_fd_sc_hd__decap_4
X_13059_ clknet_leaf_65_clk _00069_ VGND VGND VPWR VPWR u_interface.fifo_data\[14\]\[12\]
+ sky130_fd_sc_hd__dfxtp_1
XTAP_TAPCELL_ROW_72_1493 VGND VPWR sky130_fd_sc_hd__tapvpwrvgnd_1
XTAP_TAPCELL_ROW_72_1482 VGND VPWR sky130_fd_sc_hd__tapvpwrvgnd_1
XFILLER_23_3 VPWR VGND VPWR VGND sky130_ef_sc_hd__decap_12
XFILLER_27_909 VGND VGND VPWR VPWR sky130_fd_sc_hd__decap_8
X_07620_ _01711_ _01704_ net334 VGND VGND VPWR VPWR _01712_ sky130_fd_sc_hd__mux2_1
XFILLER_54_717 VGND VGND VPWR VPWR sky130_fd_sc_hd__fill_2
X_07551_ net811 net1644 net304 _01667_ VGND VGND VPWR VPWR _00449_ sky130_fd_sc_hd__a22o_1
XFILLER_47_780 VGND VGND VPWR VPWR sky130_fd_sc_hd__decap_4
XFILLER_19_471 VPWR VGND VPWR VGND sky130_ef_sc_hd__decap_12
XTAP_TAPCELL_ROW_37_926 VGND VPWR sky130_fd_sc_hd__tapvpwrvgnd_1
X_06502_ u_interface.fifo_rd_ptr\[0\] VGND VGND VPWR VPWR _01102_ sky130_fd_sc_hd__inv_2
XFILLER_62_761 VGND VGND VPWR VPWR sky130_fd_sc_hd__fill_1
X_07482_ _01571_ _01573_ net555 VGND VGND VPWR VPWR _01615_ sky130_fd_sc_hd__mux2_1
XFILLER_61_271 VGND VGND VPWR VPWR sky130_fd_sc_hd__decap_8
XFILLER_22_625 VPWR VGND VPWR VGND sky130_ef_sc_hd__decap_12
X_09221_ _02937_ _02966_ _02978_ VGND VGND VPWR VPWR _02980_ sky130_fd_sc_hd__nand3_1
XFILLER_21_113 VPWR VGND VPWR VGND sky130_ef_sc_hd__decap_12
XFILLER_22_669 VPWR VGND VPWR VGND sky130_ef_sc_hd__decap_12
X_09152_ _02905_ _02909_ _02910_ VGND VGND VPWR VPWR _02911_ sky130_fd_sc_hd__nand3_1
X_08103_ net291 _01951_ VGND VGND VPWR VPWR _00718_ sky130_fd_sc_hd__nor2_1
XTAP_TAPCELL_ROW_79_1603 VGND VPWR sky130_fd_sc_hd__tapvpwrvgnd_1
X_09083_ net654 net516 net520 net664 VGND VGND VPWR VPWR _02842_ sky130_fd_sc_hd__a22oi_1
XFILLER_135_516 VGND VGND VPWR VPWR sky130_fd_sc_hd__fill_1
Xinput70 s_axil_rready VGND VGND VPWR VPWR net70 sky130_fd_sc_hd__clkbuf_1
Xinput81 s_axis_tdata[16] VGND VGND VPWR VPWR net81 sky130_fd_sc_hd__clkbuf_1
X_08034_ u_interface.u_gelu_fp32.u_fp32_to_q16.s3_mag\[26\] _01890_ VGND VGND VPWR
+ VPWR _01891_ sky130_fd_sc_hd__and2_1
Xhold821 u_interface.u_gelu_fp32.u_synth_top.s1_x\[14\] VGND VGND VPWR VPWR net1686
+ sky130_fd_sc_hd__dlygate4sd3_1
XTAP_TAPCELL_ROW_92_1803 VGND VPWR sky130_fd_sc_hd__tapvpwrvgnd_1
Xhold810 u_interface.u_gelu_fp32.u_q16_to_fp32.s2_mag\[15\] VGND VGND VPWR VPWR net1675
+ sky130_fd_sc_hd__dlygate4sd3_1
Xinput92 s_axis_tdata[26] VGND VGND VPWR VPWR net92 sky130_fd_sc_hd__clkbuf_1
Xhold854 u_interface.u_gelu_fp32.u_synth_top.s1_hits\[14\] VGND VGND VPWR VPWR net1719
+ sky130_fd_sc_hd__dlygate4sd3_1
XTAP_TAPCELL_ROW_92_1814 VGND VPWR sky130_fd_sc_hd__tapvpwrvgnd_1
XFILLER_89_614 VGND VGND VPWR VPWR sky130_fd_sc_hd__fill_2
Xhold843 u_interface.u_gelu_fp32.u_q16_to_fp32.s1_mag\[19\] VGND VGND VPWR VPWR net1708
+ sky130_fd_sc_hd__dlygate4sd3_1
Xhold832 u_interface.u_gelu_fp32.u_q16_to_fp32.s2_mag\[20\] VGND VGND VPWR VPWR net1697
+ sky130_fd_sc_hd__dlygate4sd3_1
XFILLER_143_593 VGND VGND VPWR VPWR sky130_fd_sc_hd__decap_6
Xhold865 u_interface.u_gelu_fp32.u_fp32_to_q16.s3_mag\[1\] VGND VGND VPWR VPWR net1730
+ sky130_fd_sc_hd__dlygate4sd3_1
XFILLER_103_402 VPWR VGND VPWR VGND sky130_ef_sc_hd__decap_12
Xhold876 u_interface.u_gelu_fp32.u_synth_top.s2_b\[9\] VGND VGND VPWR VPWR net1741
+ sky130_fd_sc_hd__dlygate4sd3_1
Xhold887 u_interface.u_gelu_fp32.u_synth_top.s2_b\[14\] VGND VGND VPWR VPWR net1752
+ sky130_fd_sc_hd__dlygate4sd3_1
Xhold898 u_interface.u_gelu_fp32.u_synth_top.s2_b\[15\] VGND VGND VPWR VPWR net1763
+ sky130_fd_sc_hd__dlygate4sd3_1
XFILLER_88_102 VPWR VGND VPWR VGND sky130_ef_sc_hd__decap_12
XFILLER_1_529 VPWR VGND VPWR VGND sky130_ef_sc_hd__decap_12
X_09985_ _03736_ _03737_ VGND VGND VPWR VPWR _03738_ sky130_fd_sc_hd__or2_1
XFILLER_77_809 VGND VGND VPWR VPWR sky130_fd_sc_hd__decap_3
X_08936_ _02694_ VGND VGND VPWR VPWR _02695_ sky130_fd_sc_hd__inv_2
X_08867_ _02602_ _02624_ VGND VGND VPWR VPWR _02626_ sky130_fd_sc_hd__and2_1
XFILLER_69_393 VPWR VGND VPWR VGND sky130_ef_sc_hd__decap_12
XFILLER_57_533 VGND VGND VPWR VPWR sky130_fd_sc_hd__decap_6
X_07818_ net1326 net352 net231 VGND VGND VPWR VPWR _00579_ sky130_fd_sc_hd__mux2_1
XTAP_TAPCELL_ROW_123_2302 VGND VPWR sky130_fd_sc_hd__tapvpwrvgnd_1
XFILLER_17_408 VPWR VGND VPWR VGND sky130_ef_sc_hd__decap_12
X_08798_ _02555_ _02556_ VGND VGND VPWR VPWR _02557_ sky130_fd_sc_hd__and2b_1
XFILLER_123_89 VGND VGND VPWR VPWR sky130_fd_sc_hd__fill_2
X_07749_ u_interface.u_gelu_fp32.u_q16_to_fp32.s3_exp\[0\] _01790_ net294 VGND VGND
+ VPWR VPWR _01793_ sky130_fd_sc_hd__o21ai_1
XFILLER_53_761 VGND VGND VPWR VPWR sky130_fd_sc_hd__decap_3
XFILLER_25_452 VGND VGND VPWR VPWR sky130_fd_sc_hd__decap_6
X_10760_ _04504_ _04505_ _04491_ VGND VGND VPWR VPWR _04506_ sky130_fd_sc_hd__a21o_1
XFILLER_53_772 VGND VGND VPWR VPWR sky130_fd_sc_hd__decap_4
XFILLER_16_65 VPWR VGND VPWR VGND sky130_ef_sc_hd__decap_12
X_09419_ net510 net706 _03175_ _03176_ VGND VGND VPWR VPWR _03177_ sky130_fd_sc_hd__o2bb2a_1
X_10691_ _04314_ _04192_ VGND VGND VPWR VPWR _04438_ sky130_fd_sc_hd__nand2b_1
XFILLER_52_293 VGND VGND VPWR VPWR sky130_fd_sc_hd__decap_6
XTAP_TAPCELL_ROW_101_1954 VGND VPWR sky130_fd_sc_hd__tapvpwrvgnd_1
XFILLER_9_629 VPWR VGND VPWR VGND sky130_ef_sc_hd__decap_12
X_12430_ _06155_ _06156_ VGND VGND VPWR VPWR _06157_ sky130_fd_sc_hd__and2b_1
XFILLER_40_477 VPWR VGND VPWR VGND sky130_ef_sc_hd__decap_12
XFILLER_8_139 VGND VGND VPWR VPWR sky130_fd_sc_hd__fill_1
XTAP_TAPCELL_ROW_23_697 VGND VPWR sky130_fd_sc_hd__tapvpwrvgnd_1
XFILLER_32_53 VGND VGND VPWR VPWR sky130_fd_sc_hd__decap_6
XFILLER_138_387 VPWR VGND VPWR VGND sky130_ef_sc_hd__decap_12
XFILLER_138_365 VGND VGND VPWR VPWR sky130_fd_sc_hd__decap_6
X_14100_ clknet_leaf_27_clk _01026_ VGND VGND VPWR VPWR u_interface.meta_tuser_pipe\[7\]
+ sky130_fd_sc_hd__dfxtp_1
X_12361_ _06087_ _06088_ VGND VGND VPWR VPWR _06089_ sky130_fd_sc_hd__nand2_1
XFILLER_20_190 VGND VGND VPWR VPWR sky130_fd_sc_hd__decap_6
XFILLER_154_869 VPWR VGND VPWR VGND sky130_ef_sc_hd__decap_12
XFILLER_153_335 VGND VGND VPWR VPWR sky130_fd_sc_hd__fill_1
XTAP_TAPCELL_ROW_134_2486 VGND VPWR sky130_fd_sc_hd__tapvpwrvgnd_1
XTAP_TAPCELL_ROW_134_2475 VGND VPWR sky130_fd_sc_hd__tapvpwrvgnd_1
X_11312_ net694 net434 _05051_ _05052_ VGND VGND VPWR VPWR _05053_ sky130_fd_sc_hd__a22o_1
X_12292_ net710 net390 VGND VGND VPWR VPWR _06021_ sky130_fd_sc_hd__nand2_1
XFILLER_4_301 VGND VGND VPWR VPWR sky130_fd_sc_hd__decap_6
X_14031_ clknet_leaf_53_clk _00957_ VGND VGND VPWR VPWR u_interface.core_data_out\[17\]
+ sky130_fd_sc_hd__dfxtp_1
XFILLER_4_345 VPWR VGND VPWR VGND sky130_ef_sc_hd__decap_12
X_11243_ net595 net388 VGND VGND VPWR VPWR _04985_ sky130_fd_sc_hd__and2b_1
XFILLER_4_389 VPWR VGND VPWR VGND sky130_ef_sc_hd__decap_12
X_11174_ _04795_ _04809_ _04808_ VGND VGND VPWR VPWR _04916_ sky130_fd_sc_hd__a21o_1
XFILLER_95_617 VGND VGND VPWR VPWR sky130_fd_sc_hd__decap_6
X_10125_ _03865_ _03873_ _03874_ VGND VGND VPWR VPWR _03876_ sky130_fd_sc_hd__nand3_1
XFILLER_0_573 VPWR VGND VPWR VGND sky130_ef_sc_hd__decap_12
X_10056_ net474 net691 net698 net478 VGND VGND VPWR VPWR _03808_ sky130_fd_sc_hd__a22o_1
XFILLER_48_533 VPWR VGND VPWR VGND sky130_ef_sc_hd__decap_12
XFILLER_90_300 VGND VGND VPWR VPWR sky130_fd_sc_hd__fill_2
XFILLER_63_558 VGND VGND VPWR VPWR sky130_fd_sc_hd__fill_2
X_13815_ clknet_leaf_85_clk _00825_ VGND VGND VPWR VPWR u_interface.u_gelu_fp32.u_synth_top.s3_mult\[33\]
+ sky130_fd_sc_hd__dfxtp_1
XFILLER_90_377 VGND VGND VPWR VPWR sky130_fd_sc_hd__decap_4
X_13746_ clknet_leaf_87_clk _00756_ VGND VGND VPWR VPWR u_interface.u_gelu_fp32.u_q16_to_fp32.s1_mag\[12\]
+ sky130_fd_sc_hd__dfxtp_1
X_10958_ net452 net456 net704 net712 VGND VGND VPWR VPWR _04702_ sky130_fd_sc_hd__nand4_1
XFILLER_44_783 VGND VGND VPWR VPWR sky130_fd_sc_hd__fill_1
X_13677_ clknet_leaf_12_clk _00687_ VGND VGND VPWR VPWR u_interface.u_gelu_fp32.u_fp32_to_q16.s3_frac\[13\]
+ sky130_fd_sc_hd__dfxtp_1
XFILLER_73_93 VPWR VGND VPWR VGND sky130_ef_sc_hd__decap_12
XFILLER_43_293 VPWR VGND VPWR VGND sky130_ef_sc_hd__decap_12
XTAP_TAPCELL_ROW_154_2807 VGND VPWR sky130_fd_sc_hd__tapvpwrvgnd_1
X_12628_ _06327_ _06328_ VGND VGND VPWR VPWR _06330_ sky130_fd_sc_hd__nand2_1
X_10889_ net586 net392 VGND VGND VPWR VPWR _04634_ sky130_fd_sc_hd__nand2_1
XFILLER_117_505 VGND VGND VPWR VPWR sky130_fd_sc_hd__decap_4
X_12559_ net782 net920 VGND VGND VPWR VPWR _00857_ sky130_fd_sc_hd__and2_1
Xhold106 u_interface.fifo_tlast\[10\] VGND VGND VPWR VPWR net971 sky130_fd_sc_hd__dlygate4sd3_1
Xhold117 u_interface.u_gelu_fp32.s2_data\[3\] VGND VGND VPWR VPWR net982 sky130_fd_sc_hd__dlygate4sd3_1
XFILLER_7_161 VGND VGND VPWR VPWR sky130_fd_sc_hd__decap_6
Xhold128 u_interface.u_gelu_fp32.u_fp32_to_q16.s3_frac\[20\] VGND VGND VPWR VPWR net993
+ sky130_fd_sc_hd__dlygate4sd3_1
XTAP_TAPCELL_ROW_74_1522 VGND VPWR sky130_fd_sc_hd__tapvpwrvgnd_1
Xhold139 u_interface.fifo_data\[10\]\[3\] VGND VGND VPWR VPWR net1004 sky130_fd_sc_hd__dlygate4sd3_1
XPHY_EDGE_ROW_9_Right_9 VGND VGND VPWR VPWR sky130_fd_sc_hd__decap_3
Xfanout608 u_interface.u_gelu_fp32.u_synth_top.s2_m\[3\] VGND VGND VPWR VPWR net608
+ sky130_fd_sc_hd__clkbuf_2
Xfanout619 net624 VGND VGND VPWR VPWR net619 sky130_fd_sc_hd__clkbuf_2
X_06982_ _01100_ u_interface.fifo_wr_ptr\[1\] u_interface.fifo_wr_ptr\[0\] net827
+ VGND VGND VPWR VPWR _01506_ sky130_fd_sc_hd__or4_4
X_09770_ _03415_ _03318_ VGND VGND VPWR VPWR _03525_ sky130_fd_sc_hd__nand2b_1
XPHY_EDGE_ROW_107_Right_107 VGND VGND VPWR VPWR sky130_fd_sc_hd__decap_3
X_08721_ _02478_ _02479_ VGND VGND VPWR VPWR _02480_ sky130_fd_sc_hd__nand2b_1
XFILLER_112_298 VGND VGND VPWR VPWR sky130_fd_sc_hd__fill_1
XFILLER_39_522 VPWR VGND VPWR VGND sky130_ef_sc_hd__decap_12
XFILLER_66_363 VGND VGND VPWR VPWR sky130_fd_sc_hd__fill_1
X_08652_ _02266_ _02270_ VGND VGND VPWR VPWR _02419_ sky130_fd_sc_hd__and2_1
XTAP_TAPCELL_ROW_105_2021 VGND VPWR sky130_fd_sc_hd__tapvpwrvgnd_1
XTAP_TAPCELL_ROW_105_2010 VGND VPWR sky130_fd_sc_hd__tapvpwrvgnd_1
XFILLER_94_683 VPWR VGND VPWR VGND sky130_ef_sc_hd__decap_12
XFILLER_93_182 VPWR VGND VPWR VGND sky130_ef_sc_hd__decap_12
X_07603_ net330 _01698_ VGND VGND VPWR VPWR _01699_ sky130_fd_sc_hd__nor2_1
XTAP_TAPCELL_ROW_1_348 VGND VPWR sky130_fd_sc_hd__tapvpwrvgnd_1
XTAP_TAPCELL_ROW_1_359 VGND VPWR sky130_fd_sc_hd__tapvpwrvgnd_1
X_08583_ _02220_ net159 _02369_ VGND VGND VPWR VPWR _02370_ sky130_fd_sc_hd__nand3b_1
XFILLER_82_878 VGND VGND VPWR VPWR sky130_fd_sc_hd__fill_2
XFILLER_81_333 VGND VGND VPWR VPWR sky130_fd_sc_hd__decap_3
XFILLER_26_238 VGND VGND VPWR VPWR sky130_fd_sc_hd__decap_8
X_07534_ net821 net1758 net305 _01569_ VGND VGND VPWR VPWR _00439_ sky130_fd_sc_hd__a22o_1
XFILLER_34_260 VGND VGND VPWR VPWR sky130_fd_sc_hd__decap_8
X_07465_ _01587_ _01599_ net312 VGND VGND VPWR VPWR _01600_ sky130_fd_sc_hd__mux2_1
XTAP_TAPCELL_ROW_85_1695 VGND VPWR sky130_fd_sc_hd__tapvpwrvgnd_1
XFILLER_34_282 VGND VGND VPWR VPWR sky130_fd_sc_hd__fill_2
X_09204_ _02947_ _02948_ _02917_ VGND VGND VPWR VPWR _02963_ sky130_fd_sc_hd__a21oi_1
XFILLER_22_477 VGND VGND VPWR VPWR sky130_fd_sc_hd__decap_3
X_07396_ net1539 net565 net240 VGND VGND VPWR VPWR _00426_ sky130_fd_sc_hd__mux2_1
XFILLER_50_797 VGND VGND VPWR VPWR sky130_fd_sc_hd__decap_6
XFILLER_22_488 VGND VGND VPWR VPWR sky130_fd_sc_hd__fill_2
X_09135_ _02839_ _02885_ _02890_ VGND VGND VPWR VPWR _02894_ sky130_fd_sc_hd__a21o_1
XTAP_TAPCELL_ROW_20_656 VGND VPWR sky130_fd_sc_hd__tapvpwrvgnd_1
XFILLER_148_696 VGND VGND VPWR VPWR sky130_fd_sc_hd__decap_4
X_09066_ net604 net496 _02823_ _02824_ VGND VGND VPWR VPWR _02825_ sky130_fd_sc_hd__nand4_1
XFILLER_136_869 VGND VGND VPWR VPWR sky130_fd_sc_hd__decap_4
XFILLER_135_335 VGND VGND VPWR VPWR sky130_fd_sc_hd__fill_1
XFILLER_150_305 VGND VGND VPWR VPWR sky130_fd_sc_hd__decap_3
X_08017_ u_interface.u_gelu_fp32.u_fp32_to_q16.s3_mag\[2\] _01873_ VGND VGND VPWR
+ VPWR _01874_ sky130_fd_sc_hd__and2_1
XTAP_TAPCELL_ROW_116_2194 VGND VPWR sky130_fd_sc_hd__tapvpwrvgnd_1
XFILLER_2_805 VGND VGND VPWR VPWR sky130_fd_sc_hd__decap_6
XFILLER_150_316 VGND VGND VPWR VPWR sky130_fd_sc_hd__fill_1
Xhold662 u_interface.fifo_data\[3\]\[13\] VGND VGND VPWR VPWR net1527 sky130_fd_sc_hd__dlygate4sd3_1
XFILLER_118_89 VGND VGND VPWR VPWR sky130_fd_sc_hd__fill_1
Xhold651 u_interface.u_gelu_fp32.u_q16_to_fp32.s2_exp\[0\] VGND VGND VPWR VPWR net1516
+ sky130_fd_sc_hd__dlygate4sd3_1
XFILLER_78_27 VGND VGND VPWR VPWR sky130_fd_sc_hd__fill_1
Xhold640 u_interface.fifo_data\[8\]\[9\] VGND VGND VPWR VPWR net1505 sky130_fd_sc_hd__dlygate4sd3_1
XFILLER_2_849 VPWR VGND VPWR VGND sky130_ef_sc_hd__decap_12
Xhold695 u_interface.u_gelu_fp32.u_fp32_to_q16.s3_frac\[29\] VGND VGND VPWR VPWR net1560
+ sky130_fd_sc_hd__dlygate4sd3_1
Xhold673 u_interface.fifo_data\[11\]\[27\] VGND VGND VPWR VPWR net1538 sky130_fd_sc_hd__dlygate4sd3_1
Xhold684 u_interface.u_gelu_fp32.u_q16_to_fp32.s3_norm_mag\[1\] VGND VGND VPWR VPWR
+ net1549 sky130_fd_sc_hd__dlygate4sd3_1
XFILLER_1_337 VPWR VGND VPWR VGND sky130_ef_sc_hd__decap_12
XFILLER_103_265 VGND VGND VPWR VPWR sky130_fd_sc_hd__fill_1
X_09968_ _03719_ _03720_ _03687_ VGND VGND VPWR VPWR _03721_ sky130_fd_sc_hd__a21oi_1
XFILLER_76_116 VPWR VGND VPWR VGND sky130_ef_sc_hd__decap_12
XFILLER_76_105 VGND VGND VPWR VPWR sky130_fd_sc_hd__fill_1
X_08919_ _02537_ _02540_ VGND VGND VPWR VPWR _02678_ sky130_fd_sc_hd__nand2_1
XFILLER_94_15 VGND VGND VPWR VPWR sky130_fd_sc_hd__decap_4
XFILLER_58_831 VGND VGND VPWR VPWR sky130_fd_sc_hd__fill_2
X_09899_ _03649_ _03650_ _03554_ _03556_ VGND VGND VPWR VPWR _03652_ sky130_fd_sc_hd__o211ai_1
XFILLER_45_503 VGND VGND VPWR VPWR sky130_fd_sc_hd__fill_1
X_11930_ _05594_ _05598_ net204 VGND VGND VPWR VPWR _05664_ sky130_fd_sc_hd__a21o_1
XFILLER_72_322 VGND VGND VPWR VPWR sky130_fd_sc_hd__fill_1
XFILLER_150_65 VPWR VGND VPWR VGND sky130_ef_sc_hd__decap_12
XFILLER_72_333 VGND VGND VPWR VPWR sky130_fd_sc_hd__decap_3
XFILLER_45_569 VGND VGND VPWR VPWR sky130_fd_sc_hd__decap_8
X_11861_ _05587_ _05595_ VGND VGND VPWR VPWR _05596_ sky130_fd_sc_hd__nor2_1
XFILLER_33_709 VPWR VGND VPWR VGND sky130_ef_sc_hd__decap_12
X_13600_ clknet_leaf_50_clk _00610_ VGND VGND VPWR VPWR u_interface.fifo_data\[3\]\[15\]
+ sky130_fd_sc_hd__dfxtp_1
X_10812_ _04546_ _04548_ VGND VGND VPWR VPWR _04557_ sky130_fd_sc_hd__and2b_1
XFILLER_60_528 VGND VGND VPWR VPWR sky130_fd_sc_hd__decap_4
X_11792_ net658 net394 VGND VGND VPWR VPWR _05528_ sky130_fd_sc_hd__nand2_1
XTAP_TAPCELL_ROW_28_778 VGND VPWR sky130_fd_sc_hd__tapvpwrvgnd_1
XTAP_TAPCELL_ROW_28_789 VGND VPWR sky130_fd_sc_hd__tapvpwrvgnd_1
X_13531_ clknet_leaf_39_clk _00541_ VGND VGND VPWR VPWR u_interface.fifo_data\[5\]\[10\]
+ sky130_fd_sc_hd__dfxtp_1
X_10743_ _04365_ _04368_ _04486_ _04487_ VGND VGND VPWR VPWR _04489_ sky130_fd_sc_hd__a211oi_2
XTAP_TAPCELL_ROW_136_2504 VGND VPWR sky130_fd_sc_hd__tapvpwrvgnd_1
XFILLER_13_466 VGND VGND VPWR VPWR sky130_fd_sc_hd__decap_3
XTAP_TAPCELL_ROW_136_2515 VGND VPWR sky130_fd_sc_hd__tapvpwrvgnd_1
X_13462_ clknet_leaf_60_clk _00472_ VGND VGND VPWR VPWR u_interface.u_gelu_fp32.u_q16_to_fp32.s3_norm_mag\[2\]
+ sky130_fd_sc_hd__dfxtp_1
X_10674_ _04340_ _04341_ _04418_ _04419_ VGND VGND VPWR VPWR _04421_ sky130_fd_sc_hd__and4_1
XFILLER_40_263 VGND VGND VPWR VPWR sky130_fd_sc_hd__decap_4
X_13393_ clknet_leaf_71_clk _00403_ VGND VGND VPWR VPWR u_interface.fifo_data\[6\]\[6\]
+ sky130_fd_sc_hd__dfxtp_1
X_12413_ _05958_ _06138_ VGND VGND VPWR VPWR _06140_ sky130_fd_sc_hd__xor2_1
X_12344_ net202 _06013_ _06012_ VGND VGND VPWR VPWR _06072_ sky130_fd_sc_hd__o21a_1
XFILLER_5_665 VGND VGND VPWR VPWR sky130_fd_sc_hd__decap_6
XFILLER_154_688 VGND VGND VPWR VPWR sky130_fd_sc_hd__fill_2
XFILLER_99_219 VGND VGND VPWR VPWR sky130_fd_sc_hd__decap_4
X_14014_ clknet_leaf_62_clk _00940_ VGND VGND VPWR VPWR u_interface.core_data_out\[0\]
+ sky130_fd_sc_hd__dfxtp_1
XTAP_TAPCELL_ROW_56_1230 VGND VPWR sky130_fd_sc_hd__tapvpwrvgnd_1
XFILLER_4_153 VPWR VGND VPWR VGND sky130_ef_sc_hd__decap_12
X_12275_ net182 _06003_ VGND VGND VPWR VPWR _06004_ sky130_fd_sc_hd__xnor2_1
XFILLER_141_349 VGND VGND VPWR VPWR sky130_fd_sc_hd__decap_6
XFILLER_122_530 VGND VGND VPWR VPWR sky130_fd_sc_hd__fill_2
XFILLER_4_197 VPWR VGND VPWR VGND sky130_ef_sc_hd__decap_12
X_11226_ net659 net420 VGND VGND VPWR VPWR _04968_ sky130_fd_sc_hd__nand2_1
XFILLER_96_915 VGND VGND VPWR VPWR sky130_fd_sc_hd__fill_2
XFILLER_67_105 VGND VGND VPWR VPWR sky130_fd_sc_hd__decap_6
X_11157_ _04897_ _04898_ VGND VGND VPWR VPWR _04900_ sky130_fd_sc_hd__xnor2_1
XTAP_TAPCELL_ROW_8_470 VGND VPWR sky130_fd_sc_hd__tapvpwrvgnd_1
X_10108_ _03740_ _03746_ _03859_ VGND VGND VPWR VPWR _03860_ sky130_fd_sc_hd__or3_1
XFILLER_68_93 VGND VGND VPWR VPWR sky130_fd_sc_hd__fill_2
XFILLER_67_149 VGND VGND VPWR VPWR sky130_fd_sc_hd__decap_3
XFILLER_67_127 VGND VGND VPWR VPWR sky130_fd_sc_hd__decap_4
XTAP_TAPCELL_ROW_147_2688 VGND VPWR sky130_fd_sc_hd__tapvpwrvgnd_1
X_11088_ net703 net448 VGND VGND VPWR VPWR _04831_ sky130_fd_sc_hd__nand2_1
X_10039_ net603 net436 VGND VGND VPWR VPWR _03791_ sky130_fd_sc_hd__nand2_1
XFILLER_64_856 VGND VGND VPWR VPWR sky130_fd_sc_hd__decap_4
XFILLER_63_355 VGND VGND VPWR VPWR sky130_fd_sc_hd__decap_6
XFILLER_17_783 VGND VGND VPWR VPWR sky130_fd_sc_hd__fill_1
XFILLER_90_185 VGND VGND VPWR VPWR sky130_fd_sc_hd__decap_8
XFILLER_149_405 VGND VGND VPWR VPWR sky130_fd_sc_hd__fill_1
X_13729_ clknet_leaf_7_clk _00739_ VGND VGND VPWR VPWR u_interface.u_gelu_fp32.s1_data\[29\]
+ sky130_fd_sc_hd__dfxtp_1
XFILLER_90_3 VPWR VGND VPWR VGND sky130_ef_sc_hd__decap_12
XFILLER_149_449 VGND VGND VPWR VPWR sky130_fd_sc_hd__fill_2
X_07250_ net1297 net356 net251 VGND VGND VPWR VPWR _00282_ sky130_fd_sc_hd__mux2_1
XFILLER_129_140 VGND VGND VPWR VPWR sky130_fd_sc_hd__fill_2
X_07181_ net1009 net342 net261 VGND VGND VPWR VPWR _00221_ sky130_fd_sc_hd__mux2_1
XFILLER_129_195 VGND VGND VPWR VPWR sky130_fd_sc_hd__decap_8
XFILLER_118_858 VGND VGND VPWR VPWR sky130_fd_sc_hd__fill_1
XFILLER_118_869 VGND VGND VPWR VPWR sky130_fd_sc_hd__decap_6
XFILLER_125_390 VGND VGND VPWR VPWR sky130_fd_sc_hd__fill_2
Xfanout405 u_interface.u_gelu_fp32.u_synth_top.s2_dx\[27\] VGND VGND VPWR VPWR net405
+ sky130_fd_sc_hd__buf_1
X_09822_ _03428_ _03575_ VGND VGND VPWR VPWR _03576_ sky130_fd_sc_hd__nor2_1
XFILLER_98_263 VGND VGND VPWR VPWR sky130_fd_sc_hd__decap_6
XFILLER_86_403 VGND VGND VPWR VPWR sky130_fd_sc_hd__fill_1
Xfanout427 u_interface.u_gelu_fp32.u_synth_top.s2_dx\[22\] VGND VGND VPWR VPWR net427
+ sky130_fd_sc_hd__buf_2
XFILLER_59_617 VGND VGND VPWR VPWR sky130_fd_sc_hd__decap_3
Xfanout438 net440 VGND VGND VPWR VPWR net438 sky130_fd_sc_hd__clkbuf_2
Xfanout416 net419 VGND VGND VPWR VPWR net416 sky130_fd_sc_hd__buf_2
XTAP_TAPCELL_ROW_6_429 VGND VPWR sky130_fd_sc_hd__tapvpwrvgnd_1
X_09753_ _03469_ _03504_ _03505_ VGND VGND VPWR VPWR _03508_ sky130_fd_sc_hd__nand3_1
Xfanout449 net451 VGND VGND VPWR VPWR net449 sky130_fd_sc_hd__clkbuf_4
X_08704_ net690 net697 net515 net519 VGND VGND VPWR VPWR _02463_ sky130_fd_sc_hd__and4_1
XFILLER_104_14 VPWR VGND VPWR VGND sky130_ef_sc_hd__decap_12
X_06965_ _01475_ _01480_ _01482_ _01488_ VGND VGND VPWR VPWR _01493_ sky130_fd_sc_hd__or4_1
XFILLER_67_650 VPWR VGND VPWR VGND sky130_ef_sc_hd__decap_12
XFILLER_55_801 VGND VGND VPWR VPWR sky130_fd_sc_hd__fill_1
X_09684_ _03435_ _03436_ _03437_ VGND VGND VPWR VPWR _03439_ sky130_fd_sc_hd__nand3_1
X_06896_ u_interface.u_gelu_fp32.u_synth_top.s1_x\[16\] _01184_ _01436_ VGND VGND
+ VPWR VPWR _01438_ sky130_fd_sc_hd__and3_1
XTAP_TAPCELL_ROW_87_1735 VGND VPWR sky130_fd_sc_hd__tapvpwrvgnd_1
XTAP_TAPCELL_ROW_87_1724 VGND VPWR sky130_fd_sc_hd__tapvpwrvgnd_1
XFILLER_27_503 VGND VGND VPWR VPWR sky130_fd_sc_hd__fill_1
XFILLER_27_514 VPWR VGND VPWR VGND sky130_ef_sc_hd__decap_12
XFILLER_82_664 VPWR VGND VPWR VGND sky130_ef_sc_hd__decap_12
XFILLER_82_642 VGND VGND VPWR VPWR sky130_fd_sc_hd__fill_2
XFILLER_64_29 VGND VGND VPWR VPWR sky130_fd_sc_hd__fill_1
X_08635_ net153 _02406_ net794 VGND VGND VPWR VPWR _00795_ sky130_fd_sc_hd__a21oi_1
XFILLER_15_709 VPWR VGND VPWR VGND sky130_ef_sc_hd__decap_12
XFILLER_27_558 VGND VGND VPWR VPWR sky130_fd_sc_hd__fill_2
XFILLER_82_697 VGND VGND VPWR VPWR sky130_fd_sc_hd__decap_3
X_08566_ _02332_ _02337_ _02339_ _02355_ VGND VGND VPWR VPWR _02357_ sky130_fd_sc_hd__and4_1
XFILLER_42_506 VGND VGND VPWR VPWR sky130_fd_sc_hd__fill_1
X_07517_ _01645_ _01646_ net547 VGND VGND VPWR VPWR _01647_ sky130_fd_sc_hd__mux2_1
XTAP_TAPCELL_ROW_25_737 VGND VPWR sky130_fd_sc_hd__tapvpwrvgnd_1
XFILLER_23_753 VPWR VGND VPWR VGND sky130_ef_sc_hd__decap_12
X_08497_ _02285_ _02287_ VGND VGND VPWR VPWR _02288_ sky130_fd_sc_hd__nor2_1
X_07448_ net554 net559 VGND VGND VPWR VPWR _01583_ sky130_fd_sc_hd__nand2_1
XTAP_TAPCELL_ROW_118_2223 VGND VPWR sky130_fd_sc_hd__tapvpwrvgnd_1
XFILLER_23_797 VPWR VGND VPWR VGND sky130_ef_sc_hd__decap_12
XFILLER_155_419 VGND VGND VPWR VPWR sky130_fd_sc_hd__fill_1
X_07379_ net1148 net361 net237 VGND VGND VPWR VPWR _00409_ sky130_fd_sc_hd__mux2_1
XFILLER_13_55 VGND VGND VPWR VPWR sky130_fd_sc_hd__fill_1
X_09118_ _02874_ _02876_ VGND VGND VPWR VPWR _02877_ sky130_fd_sc_hd__and2b_1
XFILLER_108_302 VGND VGND VPWR VPWR sky130_fd_sc_hd__decap_6
XFILLER_6_418 VGND VGND VPWR VPWR sky130_fd_sc_hd__fill_2
XFILLER_135_143 VGND VGND VPWR VPWR sky130_fd_sc_hd__decap_8
XTAP_TAPCELL_ROW_131_2434 VGND VPWR sky130_fd_sc_hd__tapvpwrvgnd_1
XFILLER_129_77 VPWR VGND VPWR VGND sky130_ef_sc_hd__decap_12
XTAP_TAPCELL_ROW_98_1897 VGND VPWR sky130_fd_sc_hd__tapvpwrvgnd_1
X_10390_ _04057_ _04136_ _04137_ VGND VGND VPWR VPWR _04139_ sky130_fd_sc_hd__or3_1
X_09049_ _02802_ _02806_ _02807_ VGND VGND VPWR VPWR _02808_ sky130_fd_sc_hd__nor3_2
XFILLER_2_613 VPWR VGND VPWR VGND sky130_ef_sc_hd__decap_12
XFILLER_145_21 VGND VGND VPWR VPWR sky130_fd_sc_hd__fill_1
Xhold481 u_interface.fifo_data\[13\]\[23\] VGND VGND VPWR VPWR net1346 sky130_fd_sc_hd__dlygate4sd3_1
XFILLER_104_530 VGND VGND VPWR VPWR sky130_fd_sc_hd__fill_2
Xhold470 u_interface.fifo_data\[12\]\[12\] VGND VGND VPWR VPWR net1335 sky130_fd_sc_hd__dlygate4sd3_1
XFILLER_2_657 VPWR VGND VPWR VGND sky130_ef_sc_hd__decap_12
X_12060_ _05791_ _05792_ VGND VGND VPWR VPWR _05793_ sky130_fd_sc_hd__xnor2_1
XFILLER_145_65 VGND VGND VPWR VPWR sky130_fd_sc_hd__decap_4
Xhold492 u_interface.fifo_data\[12\]\[7\] VGND VGND VPWR VPWR net1357 sky130_fd_sc_hd__dlygate4sd3_1
XFILLER_89_274 VGND VGND VPWR VPWR sky130_fd_sc_hd__fill_2
XFILLER_77_403 VGND VGND VPWR VPWR sky130_fd_sc_hd__fill_1
X_11011_ _04753_ _04754_ VGND VGND VPWR VPWR _04755_ sky130_fd_sc_hd__nor2_1
XFILLER_1_167 VGND VGND VPWR VPWR sky130_fd_sc_hd__fill_1
XFILLER_131_393 VGND VGND VPWR VPWR sky130_fd_sc_hd__decap_6
XFILLER_77_447 VGND VGND VPWR VPWR sky130_fd_sc_hd__fill_1
XFILLER_38_52 VGND VGND VPWR VPWR sky130_fd_sc_hd__fill_2
X_12962_ u_interface.fifo_count\[3\] _06467_ VGND VGND VPWR VPWR _06481_ sky130_fd_sc_hd__nor2_1
XTAP_TAPCELL_ROW_129_2396 VGND VPWR sky130_fd_sc_hd__tapvpwrvgnd_1
XFILLER_45_300 VPWR VGND VPWR VGND sky130_ef_sc_hd__decap_12
XFILLER_38_85 VPWR VGND VPWR VGND sky130_ef_sc_hd__decap_12
X_12893_ net789 net965 VGND VGND VPWR VPWR _01035_ sky130_fd_sc_hd__and2_1
XFILLER_73_642 VGND VGND VPWR VPWR sky130_fd_sc_hd__decap_3
X_11913_ net793 _05647_ VGND VGND VPWR VPWR _05648_ sky130_fd_sc_hd__or2_1
XFILLER_72_141 VGND VGND VPWR VPWR sky130_fd_sc_hd__fill_2
XFILLER_54_40 VPWR VGND VPWR VGND sky130_ef_sc_hd__decap_12
X_11844_ _05511_ _05518_ _05519_ VGND VGND VPWR VPWR _05579_ sky130_fd_sc_hd__a21boi_1
XFILLER_72_185 VGND VGND VPWR VPWR sky130_fd_sc_hd__fill_1
X_11775_ _05430_ _05433_ VGND VGND VPWR VPWR _05511_ sky130_fd_sc_hd__nand2_1
XFILLER_41_550 VGND VGND VPWR VPWR sky130_fd_sc_hd__decap_4
X_13514_ clknet_leaf_51_clk _00524_ VGND VGND VPWR VPWR u_interface.core_data_out\[25\]
+ sky130_fd_sc_hd__dfxtp_1
X_10726_ net452 net687 net695 net456 VGND VGND VPWR VPWR _04472_ sky130_fd_sc_hd__a22o_1
X_13445_ clknet_leaf_10_clk _00455_ VGND VGND VPWR VPWR u_interface.u_gelu_fp32.u_fp32_to_q16.s3_mag\[16\]
+ sky130_fd_sc_hd__dfxtp_1
X_10657_ _04279_ _04401_ _04402_ VGND VGND VPWR VPWR _04404_ sky130_fd_sc_hd__nand3_1
Xclkload26 clknet_leaf_11_clk VGND VGND VPWR VPWR clkload26/Y sky130_fd_sc_hd__inv_8
Xclkload15 clknet_leaf_56_clk VGND VGND VPWR VPWR clkload15/Y sky130_fd_sc_hd__inv_8
XFILLER_70_83 VGND VGND VPWR VPWR sky130_fd_sc_hd__fill_1
XFILLER_154_441 VGND VGND VPWR VPWR sky130_fd_sc_hd__decap_8
Xclkload37 clknet_leaf_27_clk VGND VGND VPWR VPWR clkload37/Y sky130_fd_sc_hd__clkinv_2
XFILLER_126_121 VGND VGND VPWR VPWR sky130_fd_sc_hd__decap_3
X_10588_ _04331_ _04332_ _04333_ VGND VGND VPWR VPWR _04335_ sky130_fd_sc_hd__nand3_2
Xclkload59 clknet_leaf_69_clk VGND VGND VPWR VPWR clkload59/Y sky130_fd_sc_hd__inv_8
X_13376_ clknet_leaf_83_clk _00386_ VGND VGND VPWR VPWR u_interface.fifo_data\[7\]\[21\]
+ sky130_fd_sc_hd__dfxtp_1
Xclkload48 clknet_leaf_81_clk VGND VGND VPWR VPWR clkload48/Y sky130_fd_sc_hd__inv_8
XFILLER_141_102 VGND VGND VPWR VPWR sky130_fd_sc_hd__fill_1
XFILLER_114_305 VGND VGND VPWR VPWR sky130_fd_sc_hd__decap_3
XFILLER_5_473 VPWR VGND VPWR VGND sky130_ef_sc_hd__decap_12
X_12327_ _06054_ _06055_ VGND VGND VPWR VPWR _06056_ sky130_fd_sc_hd__nand2_1
XTAP_TAPCELL_ROW_149_2717 VGND VPWR sky130_fd_sc_hd__tapvpwrvgnd_1
X_12258_ _05938_ _05987_ VGND VGND VPWR VPWR _05988_ sky130_fd_sc_hd__xnor2_1
XFILLER_96_701 VGND VGND VPWR VPWR sky130_fd_sc_hd__decap_6
X_11209_ _04947_ _04950_ VGND VGND VPWR VPWR _04951_ sky130_fd_sc_hd__xor2_2
XFILLER_122_371 VPWR VGND VPWR VGND sky130_ef_sc_hd__decap_12
XFILLER_110_533 VGND VGND VPWR VPWR sky130_fd_sc_hd__fill_1
X_12189_ _05918_ _05919_ VGND VGND VPWR VPWR _05920_ sky130_fd_sc_hd__and2_1
X_06750_ net731 _01309_ VGND VGND VPWR VPWR _01310_ sky130_fd_sc_hd__or2_1
XTAP_TAPCELL_ROW_69_1443 VGND VPWR sky130_fd_sc_hd__tapvpwrvgnd_1
XTAP_TAPCELL_ROW_69_1432 VGND VPWR sky130_fd_sc_hd__tapvpwrvgnd_1
XFILLER_48_182 VGND VGND VPWR VPWR sky130_fd_sc_hd__decap_6
X_06681_ u_interface.fifo_data\[0\]\[6\] u_interface.fifo_data\[1\]\[6\] u_interface.fifo_data\[2\]\[6\]
+ u_interface.fifo_data\[3\]\[6\] net755 net738 VGND VGND VPWR VPWR _01250_ sky130_fd_sc_hd__mux4_1
X_08420_ u_interface.u_gelu_fp32.u_synth_top.s3_mult\[17\] u_interface.u_gelu_fp32.u_synth_top.s3_b\[1\]
+ VGND VGND VPWR VPWR _02211_ sky130_fd_sc_hd__and2_1
XFILLER_91_461 VPWR VGND VPWR VGND sky130_ef_sc_hd__decap_12
XFILLER_63_185 VPWR VGND VPWR VGND sky130_ef_sc_hd__decap_12
XTAP_TAPCELL_ROW_82_1654 VGND VPWR sky130_fd_sc_hd__tapvpwrvgnd_1
XTAP_TAPCELL_ROW_82_1643 VGND VPWR sky130_fd_sc_hd__tapvpwrvgnd_1
XFILLER_51_369 VPWR VGND VPWR VGND sky130_ef_sc_hd__decap_12
X_08351_ u_interface.u_gelu_fp32.s2_data\[27\] _02143_ VGND VGND VPWR VPWR _02146_
+ sky130_fd_sc_hd__or2_1
X_08282_ _02093_ _02094_ VGND VGND VPWR VPWR _00754_ sky130_fd_sc_hd__nor2_1
XFILLER_20_701 VPWR VGND VPWR VGND sky130_ef_sc_hd__decap_12
X_07302_ net1033 net561 net245 VGND VGND VPWR VPWR _00332_ sky130_fd_sc_hd__mux2_1
X_07233_ _01532_ _01533_ VGND VGND VPWR VPWR _00266_ sky130_fd_sc_hd__nor2_1
Xclkload9 clknet_leaf_6_clk VGND VGND VPWR VPWR clkload9/X sky130_fd_sc_hd__clkbuf_8
XPHY_EDGE_ROW_4_Left_160 VGND VGND VPWR VPWR sky130_fd_sc_hd__decap_3
XFILLER_146_920 VGND VGND VPWR VPWR sky130_fd_sc_hd__fill_1
X_07164_ net1371 net377 net261 VGND VGND VPWR VPWR _00204_ sky130_fd_sc_hd__mux2_1
XFILLER_145_463 VGND VGND VPWR VPWR sky130_fd_sc_hd__decap_4
XFILLER_133_625 VGND VGND VPWR VPWR sky130_fd_sc_hd__decap_3
X_07095_ net1011 net356 net227 VGND VGND VPWR VPWR _00135_ sky130_fd_sc_hd__mux2_1
XTAP_TAPCELL_ROW_113_2142 VGND VPWR sky130_fd_sc_hd__tapvpwrvgnd_1
XFILLER_133_647 VGND VGND VPWR VPWR sky130_fd_sc_hd__decap_3
XFILLER_121_809 VGND VGND VPWR VPWR sky130_fd_sc_hd__decap_4
XFILLER_105_349 VGND VGND VPWR VPWR sky130_fd_sc_hd__decap_4
XFILLER_132_157 VGND VGND VPWR VPWR sky130_fd_sc_hd__fill_1
Xfanout213 _06298_ VGND VGND VPWR VPWR net213 sky130_fd_sc_hd__clkbuf_2
Xfanout202 _05661_ VGND VGND VPWR VPWR net202 sky130_fd_sc_hd__buf_4
Xfanout235 net236 VGND VGND VPWR VPWR net235 sky130_fd_sc_hd__buf_4
Xfanout224 _01522_ VGND VGND VPWR VPWR net224 sky130_fd_sc_hd__clkbuf_8
XFILLER_113_393 VGND VGND VPWR VPWR sky130_fd_sc_hd__fill_2
Xfanout246 _01514_ VGND VGND VPWR VPWR net246 sky130_fd_sc_hd__clkbuf_4
XFILLER_59_436 VPWR VGND VPWR VGND sky130_ef_sc_hd__decap_12
Xfanout268 _01505_ VGND VGND VPWR VPWR net268 sky130_fd_sc_hd__buf_4
X_07997_ net308 net301 _01668_ net1745 net814 VGND VGND VPWR VPWR _01863_ sky130_fd_sc_hd__a32o_1
Xfanout279 _01838_ VGND VGND VPWR VPWR net279 sky130_fd_sc_hd__buf_2
XFILLER_115_57 VPWR VGND VPWR VGND sky130_ef_sc_hd__decap_12
X_09805_ _03558_ VGND VGND VPWR VPWR _03559_ sky130_fd_sc_hd__inv_2
Xfanout257 net258 VGND VGND VPWR VPWR net257 sky130_fd_sc_hd__buf_4
X_09736_ _03485_ _03488_ _03489_ VGND VGND VPWR VPWR _03491_ sky130_fd_sc_hd__nand3_1
XFILLER_101_588 VGND VGND VPWR VPWR sky130_fd_sc_hd__fill_1
XFILLER_86_277 VGND VGND VPWR VPWR sky130_fd_sc_hd__fill_1
X_06948_ _01478_ _01479_ VGND VGND VPWR VPWR _00026_ sky130_fd_sc_hd__nor2_1
XFILLER_75_39 VGND VGND VPWR VPWR sky130_fd_sc_hd__fill_1
XFILLER_74_428 VPWR VGND VPWR VGND sky130_ef_sc_hd__decap_12
X_09667_ net581 net437 VGND VGND VPWR VPWR _03422_ sky130_fd_sc_hd__nand2_1
XFILLER_28_867 VGND VGND VPWR VPWR sky130_fd_sc_hd__fill_1
XFILLER_131_34 VGND VGND VPWR VPWR sky130_fd_sc_hd__decap_8
X_08618_ _02179_ _02237_ _02239_ VGND VGND VPWR VPWR _02394_ sky130_fd_sc_hd__a21o_1
XFILLER_54_163 VGND VGND VPWR VPWR sky130_fd_sc_hd__decap_6
X_06879_ net730 _01422_ VGND VGND VPWR VPWR _01423_ sky130_fd_sc_hd__or2_1
XFILLER_15_517 VPWR VGND VPWR VGND sky130_ef_sc_hd__decap_12
XFILLER_27_366 VPWR VGND VPWR VGND sky130_ef_sc_hd__decap_12
XFILLER_42_303 VGND VGND VPWR VPWR sky130_fd_sc_hd__decap_4
X_09598_ _03345_ _03352_ VGND VGND VPWR VPWR _03354_ sky130_fd_sc_hd__xnor2_1
XFILLER_91_27 VPWR VGND VPWR VGND sky130_ef_sc_hd__decap_12
XFILLER_82_494 VGND VGND VPWR VPWR sky130_fd_sc_hd__decap_4
XFILLER_55_697 VGND VGND VPWR VPWR sky130_fd_sc_hd__fill_1
X_08549_ _02296_ _02306_ _02308_ VGND VGND VPWR VPWR _02340_ sky130_fd_sc_hd__nand3_1
X_11560_ _05296_ _05297_ VGND VGND VPWR VPWR _05299_ sky130_fd_sc_hd__xor2_1
XFILLER_23_561 VPWR VGND VPWR VGND sky130_ef_sc_hd__decap_12
XFILLER_24_65 VPWR VGND VPWR VGND sky130_ef_sc_hd__decap_12
XFILLER_138_3 VGND VGND VPWR VPWR sky130_fd_sc_hd__decap_8
X_10511_ net660 net449 VGND VGND VPWR VPWR _04259_ sky130_fd_sc_hd__nand2_1
XFILLER_155_216 VGND VGND VPWR VPWR sky130_fd_sc_hd__decap_4
XFILLER_137_920 VGND VGND VPWR VPWR sky130_fd_sc_hd__fill_1
X_11491_ _05223_ _05228_ VGND VGND VPWR VPWR _05230_ sky130_fd_sc_hd__xnor2_1
XFILLER_7_727 VGND VGND VPWR VPWR sky130_fd_sc_hd__fill_1
X_13230_ clknet_leaf_72_clk _00240_ VGND VGND VPWR VPWR u_interface.fifo_data\[11\]\[8\]
+ sky130_fd_sc_hd__dfxtp_1
XFILLER_136_452 VGND VGND VPWR VPWR sky130_fd_sc_hd__decap_4
XFILLER_109_644 VGND VGND VPWR VPWR sky130_fd_sc_hd__decap_3
X_10442_ _04074_ _04076_ VGND VGND VPWR VPWR _04191_ sky130_fd_sc_hd__nand2b_1
XFILLER_152_912 VGND VGND VPWR VPWR sky130_fd_sc_hd__fill_1
X_10373_ _04111_ _04121_ VGND VGND VPWR VPWR _04122_ sky130_fd_sc_hd__xnor2_1
X_13161_ clknet_leaf_74_clk _00171_ VGND VGND VPWR VPWR u_interface.fifo_data\[9\]\[3\]
+ sky130_fd_sc_hd__dfxtp_1
XFILLER_40_97 VPWR VGND VPWR VGND sky130_ef_sc_hd__decap_12
X_13092_ clknet_leaf_33_clk _00102_ VGND VGND VPWR VPWR u_interface.fifo_data\[15\]\[13\]
+ sky130_fd_sc_hd__dfxtp_1
XFILLER_123_113 VGND VGND VPWR VPWR sky130_fd_sc_hd__decap_4
XFILLER_2_421 VPWR VGND VPWR VGND sky130_ef_sc_hd__decap_12
X_12112_ _05841_ _05842_ VGND VGND VPWR VPWR _05844_ sky130_fd_sc_hd__xnor2_1
XFILLER_123_157 VGND VGND VPWR VPWR sky130_fd_sc_hd__fill_1
X_12043_ _05773_ _05774_ VGND VGND VPWR VPWR _05776_ sky130_fd_sc_hd__xnor2_1
XFILLER_105_894 VGND VGND VPWR VPWR sky130_fd_sc_hd__fill_2
XFILLER_49_51 VGND VGND VPWR VPWR sky130_fd_sc_hd__decap_4
Xfanout780 net792 VGND VGND VPWR VPWR net780 sky130_fd_sc_hd__buf_2
XTAP_TAPCELL_ROW_144_2647 VGND VPWR sky130_fd_sc_hd__tapvpwrvgnd_1
XTAP_TAPCELL_ROW_144_2636 VGND VPWR sky130_fd_sc_hd__tapvpwrvgnd_1
Xfanout791 net792 VGND VGND VPWR VPWR net791 sky130_fd_sc_hd__buf_1
X_13994_ clknet_leaf_55_clk _00920_ VGND VGND VPWR VPWR u_interface.u_gelu_fp32.u_q16_to_fp32.s3_norm_mag\[21\]
+ sky130_fd_sc_hd__dfxtp_1
XFILLER_46_642 VGND VGND VPWR VPWR sky130_fd_sc_hd__fill_2
XFILLER_1_69 VPWR VGND VPWR VGND sky130_ef_sc_hd__decap_12
X_12945_ u_interface.core_valid_out _01527_ VGND VGND VPWR VPWR _06467_ sky130_fd_sc_hd__nor2_2
XFILLER_73_461 VPWR VGND VPWR VGND sky130_ef_sc_hd__decap_12
XFILLER_18_377 VGND VGND VPWR VPWR sky130_fd_sc_hd__decap_4
XFILLER_19_889 VGND VGND VPWR VPWR sky130_fd_sc_hd__decap_6
X_12876_ net1680 net829 net1764 net35 VGND VGND VPWR VPWR _06433_ sky130_fd_sc_hd__or4b_1
XFILLER_60_100 VPWR VGND VPWR VGND sky130_ef_sc_hd__decap_12
XFILLER_34_837 VPWR VGND VPWR VGND sky130_ef_sc_hd__decap_12
X_11827_ _05561_ _05562_ VGND VGND VPWR VPWR _05563_ sky130_fd_sc_hd__nand2b_1
XTAP_TAPCELL_ROW_64_1362 VGND VPWR sky130_fd_sc_hd__tapvpwrvgnd_1
XTAP_TAPCELL_ROW_16_589 VGND VPWR sky130_fd_sc_hd__tapvpwrvgnd_1
X_11758_ _05413_ _05426_ _05425_ VGND VGND VPWR VPWR _05494_ sky130_fd_sc_hd__a21oi_1
X_10709_ net189 _04452_ _04453_ VGND VGND VPWR VPWR _04455_ sky130_fd_sc_hd__nand3_1
XFILLER_41_391 VGND VGND VPWR VPWR sky130_fd_sc_hd__fill_1
XFILLER_128_920 VGND VGND VPWR VPWR sky130_fd_sc_hd__fill_1
X_11689_ _05414_ _05424_ VGND VGND VPWR VPWR _05426_ sky130_fd_sc_hd__xnor2_1
X_13428_ clknet_leaf_11_clk _00438_ VGND VGND VPWR VPWR u_interface.u_gelu_fp32.u_fp32_to_q16.s3_frac\[8\]
+ sky130_fd_sc_hd__dfxtp_1
XFILLER_155_783 VGND VGND VPWR VPWR sky130_fd_sc_hd__fill_1
XFILLER_127_463 VGND VGND VPWR VPWR sky130_fd_sc_hd__fill_1
X_13359_ clknet_leaf_48_clk _00369_ VGND VGND VPWR VPWR u_interface.fifo_data\[7\]\[4\]
+ sky130_fd_sc_hd__dfxtp_1
XFILLER_53_3 VPWR VGND VPWR VGND sky130_ef_sc_hd__decap_12
XFILLER_154_282 VPWR VGND VPWR VGND sky130_ef_sc_hd__decap_12
XFILLER_114_124 VGND VGND VPWR VPWR sky130_fd_sc_hd__fill_1
XFILLER_6_793 VPWR VGND VPWR VGND sky130_ef_sc_hd__decap_12
XFILLER_5_281 VPWR VGND VPWR VGND sky130_ef_sc_hd__decap_12
X_07920_ _01811_ _01807_ u_interface.u_gelu_fp32.u_fp32_to_q16.s1_exp\[7\] VGND VGND
+ VPWR VPWR _01814_ sky130_fd_sc_hd__or3b_1
X_07851_ net350 net1343 net285 VGND VGND VPWR VPWR _00612_ sky130_fd_sc_hd__mux2_1
XFILLER_96_564 VGND VGND VPWR VPWR sky130_fd_sc_hd__decap_8
Xinput2 rst VGND VGND VPWR VPWR net2 sky130_fd_sc_hd__buf_4
X_07782_ net1109 net360 net233 VGND VGND VPWR VPWR _00543_ sky130_fd_sc_hd__mux2_1
X_06802_ u_interface.fifo_data\[4\]\[21\] u_interface.fifo_data\[5\]\[21\] u_interface.fifo_data\[6\]\[21\]
+ u_interface.fifo_data\[7\]\[21\] net755 net738 VGND VGND VPWR VPWR _01356_ sky130_fd_sc_hd__mux4_1
X_06733_ u_interface.fifo_data\[12\]\[13\] u_interface.fifo_data\[13\]\[13\] u_interface.fifo_data\[14\]\[13\]
+ u_interface.fifo_data\[15\]\[13\] net767 net750 VGND VGND VPWR VPWR _01295_ sky130_fd_sc_hd__mux4_1
X_09521_ _03277_ _03276_ VGND VGND VPWR VPWR _03278_ sky130_fd_sc_hd__and2b_1
XFILLER_83_236 VGND VGND VPWR VPWR sky130_fd_sc_hd__decap_4
XFILLER_36_141 VGND VGND VPWR VPWR sky130_fd_sc_hd__decap_6
XFILLER_37_653 VGND VGND VPWR VPWR sky130_fd_sc_hd__decap_3
X_09452_ _03168_ _03208_ _03209_ VGND VGND VPWR VPWR _03210_ sky130_fd_sc_hd__and3_1
X_06664_ net321 _01232_ net726 VGND VGND VPWR VPWR _01235_ sky130_fd_sc_hd__o21a_1
X_09383_ net467 net470 net612 net624 VGND VGND VPWR VPWR _03141_ sky130_fd_sc_hd__nand4_1
X_06595_ _01173_ _01177_ _01178_ VGND VGND VPWR VPWR _00018_ sky130_fd_sc_hd__and3_1
X_08403_ u_interface.u_gelu_fp32.u_synth_top.s3_mult\[25\] u_interface.u_gelu_fp32.u_synth_top.s3_b\[9\]
+ VGND VGND VPWR VPWR _02194_ sky130_fd_sc_hd__nand2_1
XFILLER_40_807 VGND VGND VPWR VPWR sky130_fd_sc_hd__decap_4
XFILLER_51_177 VGND VGND VPWR VPWR sky130_fd_sc_hd__fill_2
X_08334_ _02132_ _02133_ VGND VGND VPWR VPWR _00767_ sky130_fd_sc_hd__nor2_1
XPHY_EDGE_ROW_49_Left_205 VGND VGND VPWR VPWR sky130_fd_sc_hd__decap_3
XTAP_TAPCELL_ROW_35_898 VGND VPWR sky130_fd_sc_hd__tapvpwrvgnd_1
XFILLER_20_531 VGND VGND VPWR VPWR sky130_fd_sc_hd__fill_1
X_08265_ net947 _02081_ net782 VGND VGND VPWR VPWR _02082_ sky130_fd_sc_hd__o21ai_1
XFILLER_20_564 VGND VGND VPWR VPWR sky130_fd_sc_hd__fill_1
XFILLER_137_249 VGND VGND VPWR VPWR sky130_fd_sc_hd__decap_6
X_08196_ net289 _02029_ VGND VGND VPWR VPWR _00733_ sky130_fd_sc_hd__nor2_1
X_07216_ net576 net1526 net259 VGND VGND VPWR VPWR _00256_ sky130_fd_sc_hd__mux2_1
X_07147_ net1460 net346 net220 VGND VGND VPWR VPWR _00187_ sky130_fd_sc_hd__mux2_1
XTAP_TAPCELL_ROW_95_1856 VGND VPWR sky130_fd_sc_hd__tapvpwrvgnd_1
XFILLER_105_113 VGND VGND VPWR VPWR sky130_fd_sc_hd__fill_2
XFILLER_121_617 VGND VGND VPWR VPWR sky130_fd_sc_hd__decap_8
X_07078_ net1416 net566 net210 VGND VGND VPWR VPWR _00118_ sky130_fd_sc_hd__mux2_1
XFILLER_0_914 VGND VGND VPWR VPWR sky130_fd_sc_hd__decap_6
XFILLER_102_831 VGND VGND VPWR VPWR sky130_fd_sc_hd__fill_1
XPHY_EDGE_ROW_58_Left_214 VGND VGND VPWR VPWR sky130_fd_sc_hd__decap_3
XFILLER_102_864 VGND VGND VPWR VPWR sky130_fd_sc_hd__decap_4
XFILLER_87_575 VGND VGND VPWR VPWR sky130_fd_sc_hd__fill_2
XFILLER_75_715 VPWR VGND VPWR VGND sky130_ef_sc_hd__decap_12
XFILLER_74_203 VGND VGND VPWR VPWR sky130_fd_sc_hd__fill_1
XFILLER_59_277 VGND VGND VPWR VPWR sky130_fd_sc_hd__decap_3
XTAP_TAPCELL_ROW_126_2355 VGND VPWR sky130_fd_sc_hd__tapvpwrvgnd_1
XTAP_TAPCELL_ROW_126_2344 VGND VPWR sky130_fd_sc_hd__tapvpwrvgnd_1
XFILLER_75_748 VPWR VGND VPWR VGND sky130_ef_sc_hd__decap_12
X_09719_ _03472_ _03473_ VGND VGND VPWR VPWR _03474_ sky130_fd_sc_hd__nand2_1
XFILLER_55_461 VGND VGND VPWR VPWR sky130_fd_sc_hd__fill_1
X_10991_ _04725_ _04733_ VGND VGND VPWR VPWR _04735_ sky130_fd_sc_hd__xnor2_1
XFILLER_82_280 VGND VGND VPWR VPWR sky130_fd_sc_hd__fill_2
X_12730_ _01734_ net288 _06381_ VGND VGND VPWR VPWR _00925_ sky130_fd_sc_hd__a21o_1
XFILLER_16_837 VPWR VGND VPWR VGND sky130_ef_sc_hd__decap_12
XFILLER_70_431 VGND VGND VPWR VPWR sky130_fd_sc_hd__decap_4
XPHY_EDGE_ROW_67_Left_223 VGND VGND VPWR VPWR sky130_fd_sc_hd__decap_3
X_12661_ net1047 u_interface.u_gelu_fp32.u_q16_to_fp32.s2_mag\[16\] net802 VGND VGND
+ VPWR VPWR _00897_ sky130_fd_sc_hd__mux2_1
XFILLER_35_75 VGND VGND VPWR VPWR sky130_fd_sc_hd__fill_1
XFILLER_70_475 VGND VGND VPWR VPWR sky130_fd_sc_hd__fill_1
XTAP_TAPCELL_ROW_46_1070 VGND VPWR sky130_fd_sc_hd__tapvpwrvgnd_1
XFILLER_24_881 VPWR VGND VPWR VGND sky130_ef_sc_hd__decap_12
X_11612_ net685 net416 net410 net676 VGND VGND VPWR VPWR _05350_ sky130_fd_sc_hd__a22o_1
XTAP_TAPCELL_ROW_104_1996 VGND VPWR sky130_fd_sc_hd__tapvpwrvgnd_1
X_12592_ u_interface.u_gelu_fp32.u_q16_to_fp32.s1_mag\[17\] u_interface.u_gelu_fp32.u_q16_to_fp32.s1_mag\[16\]
+ u_interface.u_gelu_fp32.u_q16_to_fp32.s1_mag\[19\] u_interface.u_gelu_fp32.u_q16_to_fp32.s1_mag\[18\]
+ VGND VGND VPWR VPWR _06295_ sky130_fd_sc_hd__or4_1
XTAP_TAPCELL_ROW_13_537 VGND VPWR sky130_fd_sc_hd__tapvpwrvgnd_1
XTAP_TAPCELL_ROW_13_548 VGND VPWR sky130_fd_sc_hd__tapvpwrvgnd_1
XFILLER_128_216 VGND VGND VPWR VPWR sky130_fd_sc_hd__decap_8
XFILLER_128_205 VGND VGND VPWR VPWR sky130_fd_sc_hd__decap_3
XFILLER_11_553 VGND VGND VPWR VPWR sky130_fd_sc_hd__decap_6
X_11543_ _05280_ _05281_ VGND VGND VPWR VPWR _05282_ sky130_fd_sc_hd__xnor2_2
X_11474_ _05114_ _05115_ _05120_ VGND VGND VPWR VPWR _05214_ sky130_fd_sc_hd__o21ba_1
XFILLER_11_597 VPWR VGND VPWR VGND sky130_ef_sc_hd__decap_12
X_13213_ clknet_leaf_44_clk _00223_ VGND VGND VPWR VPWR u_interface.fifo_data\[12\]\[23\]
+ sky130_fd_sc_hd__dfxtp_1
X_10425_ _04171_ _04172_ _04152_ VGND VGND VPWR VPWR _04174_ sky130_fd_sc_hd__a21oi_1
X_13144_ clknet_leaf_36_clk _00154_ VGND VGND VPWR VPWR u_interface.fifo_tlast\[13\]
+ sky130_fd_sc_hd__dfxtp_1
XFILLER_152_753 VGND VGND VPWR VPWR sky130_fd_sc_hd__decap_3
XFILLER_124_477 VGND VGND VPWR VPWR sky130_fd_sc_hd__fill_2
X_10356_ _04084_ _04102_ _04103_ VGND VGND VPWR VPWR _04105_ sky130_fd_sc_hd__and3_1
XPHY_EDGE_ROW_76_Left_232 VGND VGND VPWR VPWR sky130_fd_sc_hd__decap_3
XFILLER_3_741 VPWR VGND VPWR VGND sky130_ef_sc_hd__decap_12
X_13075_ clknet_leaf_39_clk _00085_ VGND VGND VPWR VPWR u_interface.fifo_data\[14\]\[28\]
+ sky130_fd_sc_hd__dfxtp_1
X_10287_ net594 net423 _04035_ _04036_ VGND VGND VPWR VPWR _04037_ sky130_fd_sc_hd__o2bb2a_1
XFILLER_3_785 VPWR VGND VPWR VGND sky130_ef_sc_hd__decap_12
XFILLER_2_251 VGND VGND VPWR VPWR sky130_fd_sc_hd__fill_1
XFILLER_78_531 VGND VGND VPWR VPWR sky130_fd_sc_hd__fill_1
X_12026_ net675 net390 _05757_ VGND VGND VPWR VPWR _05759_ sky130_fd_sc_hd__and3_1
XFILLER_39_918 VGND VGND VPWR VPWR sky130_fd_sc_hd__decap_3
XFILLER_66_715 VGND VGND VPWR VPWR sky130_fd_sc_hd__decap_3
XFILLER_76_93 VPWR VGND VPWR VGND sky130_ef_sc_hd__decap_12
XFILLER_80_206 VGND VGND VPWR VPWR sky130_fd_sc_hd__fill_1
X_13977_ clknet_leaf_84_clk net1693 VGND VGND VPWR VPWR u_interface.u_gelu_fp32.u_q16_to_fp32.s2_mag\[22\]
+ sky130_fd_sc_hd__dfxtp_1
XFILLER_46_450 VPWR VGND VPWR VGND sky130_ef_sc_hd__decap_12
XFILLER_18_141 VGND VGND VPWR VPWR sky130_fd_sc_hd__decap_8
XFILLER_19_653 VPWR VGND VPWR VGND sky130_ef_sc_hd__decap_12
XFILLER_34_601 VPWR VGND VPWR VGND sky130_ef_sc_hd__decap_12
X_12928_ net788 _06453_ VGND VGND VPWR VPWR _01055_ sky130_fd_sc_hd__and2_1
XPHY_EDGE_ROW_85_Left_241 VGND VGND VPWR VPWR sky130_fd_sc_hd__decap_3
XFILLER_19_697 VPWR VGND VPWR VGND sky130_ef_sc_hd__decap_12
XFILLER_34_645 VPWR VGND VPWR VGND sky130_ef_sc_hd__decap_12
X_12859_ net1072 u_interface.u_gelu_fp32.u_fp32_to_q16.s2_norm_mag\[14\] net820 VGND
+ VGND VPWR VPWR _01003_ sky130_fd_sc_hd__mux2_1
XFILLER_147_503 VGND VGND VPWR VPWR sky130_fd_sc_hd__fill_1
XFILLER_14_391 VGND VGND VPWR VPWR sky130_fd_sc_hd__decap_4
XTAP_TAPCELL_ROW_32_846 VGND VPWR sky130_fd_sc_hd__tapvpwrvgnd_1
X_08050_ _01903_ _01904_ _01906_ VGND VGND VPWR VPWR _01907_ sky130_fd_sc_hd__or3_1
X_07001_ _01504_ _01515_ VGND VGND VPWR VPWR _01518_ sky130_fd_sc_hd__nor2_2
XFILLER_115_400 VGND VGND VPWR VPWR sky130_fd_sc_hd__decap_3
XPHY_EDGE_ROW_94_Left_250 VGND VGND VPWR VPWR sky130_fd_sc_hd__decap_3
XTAP_TAPCELL_ROW_77_1575 VGND VPWR sky130_fd_sc_hd__tapvpwrvgnd_1
XTAP_TAPCELL_ROW_77_1564 VGND VPWR sky130_fd_sc_hd__tapvpwrvgnd_1
XTAP_TAPCELL_ROW_110_2101 VGND VPWR sky130_fd_sc_hd__tapvpwrvgnd_1
XFILLER_103_617 VPWR VGND VPWR VGND sky130_ef_sc_hd__decap_12
X_08952_ _02578_ _02579_ _02596_ VGND VGND VPWR VPWR _02711_ sky130_fd_sc_hd__o21ai_1
X_07903_ net93 net95 _01806_ VGND VGND VPWR VPWR _00662_ sky130_fd_sc_hd__nor3_1
XFILLER_130_447 VPWR VGND VPWR VGND sky130_ef_sc_hd__decap_12
X_08883_ net472 net621 VGND VGND VPWR VPWR _02642_ sky130_fd_sc_hd__and2_1
XTAP_TAPCELL_ROW_90_1775 VGND VPWR sky130_fd_sc_hd__tapvpwrvgnd_1
XFILLER_111_650 VGND VGND VPWR VPWR sky130_fd_sc_hd__decap_6
X_07834_ net384 net1530 net282 VGND VGND VPWR VPWR _00595_ sky130_fd_sc_hd__mux2_1
XTAP_TAPCELL_ROW_108_2063 VGND VPWR sky130_fd_sc_hd__tapvpwrvgnd_1
X_07765_ _01803_ net294 _01802_ VGND VGND VPWR VPWR _00527_ sky130_fd_sc_hd__and3b_1
XFILLER_84_567 VGND VGND VPWR VPWR sky130_fd_sc_hd__decap_4
XFILLER_72_718 VGND VGND VPWR VPWR sky130_fd_sc_hd__fill_1
XFILLER_72_707 VGND VGND VPWR VPWR sky130_fd_sc_hd__decap_4
X_06716_ _01276_ _01277_ _01280_ net318 VGND VGND VPWR VPWR net110 sky130_fd_sc_hd__a22o_1
X_09504_ _03199_ _03201_ _03258_ _03259_ VGND VGND VPWR VPWR _03261_ sky130_fd_sc_hd__o211a_1
X_07696_ _01758_ _01762_ VGND VGND VPWR VPWR _00500_ sky130_fd_sc_hd__or2_2
XFILLER_65_781 VGND VGND VPWR VPWR sky130_fd_sc_hd__decap_3
XFILLER_25_612 VGND VGND VPWR VPWR sky130_fd_sc_hd__decap_4
X_09435_ net498 net680 _03190_ _03191_ VGND VGND VPWR VPWR _03193_ sky130_fd_sc_hd__nand4_1
XFILLER_72_29 VGND VGND VPWR VPWR sky130_fd_sc_hd__decap_3
X_06647_ u_interface.fifo_data\[12\]\[2\] u_interface.fifo_data\[13\]\[2\] u_interface.fifo_data\[14\]\[2\]
+ u_interface.fifo_data\[15\]\[2\] net757 net740 VGND VGND VPWR VPWR _01220_ sky130_fd_sc_hd__mux4_1
XTAP_TAPCELL_ROW_121_2274 VGND VPWR sky130_fd_sc_hd__tapvpwrvgnd_1
XFILLER_12_317 VPWR VGND VPWR VGND sky130_ef_sc_hd__decap_12
X_09366_ _03009_ _03042_ _03112_ _03123_ VGND VGND VPWR VPWR _03125_ sky130_fd_sc_hd__a2bb2o_1
X_06578_ _01140_ _01165_ _01168_ VGND VGND VPWR VPWR _00007_ sky130_fd_sc_hd__and3b_1
XFILLER_40_637 VGND VGND VPWR VPWR sky130_fd_sc_hd__decap_6
X_09297_ _03051_ _03055_ VGND VGND VPWR VPWR _03056_ sky130_fd_sc_hd__nand2_1
X_08317_ net530 net1628 _02119_ net796 VGND VGND VPWR VPWR _02121_ sky130_fd_sc_hd__a31o_1
X_08248_ net533 u_interface.u_gelu_fp32.s2_data\[0\] net1755 VGND VGND VPWR VPWR _02070_
+ sky130_fd_sc_hd__a21oi_1
XFILLER_21_895 VGND VGND VPWR VPWR sky130_fd_sc_hd__fill_1
XFILLER_106_400 VGND VGND VPWR VPWR sky130_fd_sc_hd__fill_1
XFILLER_21_55 VGND VGND VPWR VPWR sky130_fd_sc_hd__fill_1
X_08179_ _02009_ _02010_ net540 VGND VGND VPWR VPWR _02015_ sky130_fd_sc_hd__o21ai_1
X_10210_ _03849_ _03851_ _03957_ _03959_ VGND VGND VPWR VPWR _03961_ sky130_fd_sc_hd__o211a_1
X_11190_ _04701_ _04816_ _04930_ VGND VGND VPWR VPWR _04932_ sky130_fd_sc_hd__nor3_1
XFILLER_106_499 VGND VGND VPWR VPWR sky130_fd_sc_hd__decap_8
X_10141_ _03888_ _03891_ VGND VGND VPWR VPWR _03892_ sky130_fd_sc_hd__xnor2_1
XFILLER_79_328 VGND VGND VPWR VPWR sky130_fd_sc_hd__decap_8
XFILLER_121_458 VGND VGND VPWR VPWR sky130_fd_sc_hd__fill_2
XFILLER_121_447 VGND VGND VPWR VPWR sky130_fd_sc_hd__fill_1
X_10072_ net455 net459 net641 net649 VGND VGND VPWR VPWR _03824_ sky130_fd_sc_hd__nand4_1
X_13900_ clknet_leaf_22_clk net883 VGND VGND VPWR VPWR u_interface.u_gelu_fp32.u_synth_top.s1_x\[4\]
+ sky130_fd_sc_hd__dfxtp_1
XFILLER_94_309 VGND VGND VPWR VPWR sky130_fd_sc_hd__decap_8
XFILLER_75_501 VGND VGND VPWR VPWR sky130_fd_sc_hd__decap_3
X_13831_ clknet_leaf_79_clk _00841_ VGND VGND VPWR VPWR u_interface.u_gelu_fp32.u_synth_top.s3_mult\[49\]
+ sky130_fd_sc_hd__dfxtp_1
X_10974_ _04589_ _04592_ _04714_ _04715_ VGND VGND VPWR VPWR _04718_ sky130_fd_sc_hd__a211o_1
XTAP_TAPCELL_ROW_48_1110 VGND VPWR sky130_fd_sc_hd__tapvpwrvgnd_1
XFILLER_46_85 VGND VGND VPWR VPWR sky130_fd_sc_hd__fill_1
XFILLER_16_601 VPWR VGND VPWR VGND sky130_ef_sc_hd__decap_12
XTAP_TAPCELL_ROW_18_618 VGND VPWR sky130_fd_sc_hd__tapvpwrvgnd_1
XTAP_TAPCELL_ROW_18_629 VGND VPWR sky130_fd_sc_hd__tapvpwrvgnd_1
X_13762_ clknet_leaf_82_clk _00772_ VGND VGND VPWR VPWR u_interface.u_gelu_fp32.u_q16_to_fp32.s1_mag\[28\]
+ sky130_fd_sc_hd__dfxtp_1
X_12713_ _01750_ _06367_ _01735_ _06353_ net306 net329 VGND VGND VPWR VPWR _06368_
+ sky130_fd_sc_hd__mux4_1
XFILLER_15_111 VGND VGND VPWR VPWR sky130_fd_sc_hd__fill_1
XFILLER_16_645 VPWR VGND VPWR VGND sky130_ef_sc_hd__decap_12
X_13693_ clknet_leaf_13_clk _00703_ VGND VGND VPWR VPWR u_interface.u_gelu_fp32.u_fp32_to_q16.s3_frac\[29\]
+ sky130_fd_sc_hd__dfxtp_1
XFILLER_31_615 VGND VGND VPWR VPWR sky130_fd_sc_hd__fill_1
X_12644_ net825 net1550 _06329_ _06338_ VGND VGND VPWR VPWR _00880_ sky130_fd_sc_hd__a22o_1
XTAP_TAPCELL_ROW_61_1310 VGND VPWR sky130_fd_sc_hd__tapvpwrvgnd_1
X_12575_ net35 net144 VGND VGND VPWR VPWR _06279_ sky130_fd_sc_hd__nand2_1
XTAP_TAPCELL_ROW_139_2557 VGND VPWR sky130_fd_sc_hd__tapvpwrvgnd_1
XFILLER_8_811 VGND VGND VPWR VPWR sky130_fd_sc_hd__fill_1
XFILLER_30_169 VPWR VGND VPWR VGND sky130_ef_sc_hd__decap_12
XFILLER_11_361 VPWR VGND VPWR VGND sky130_ef_sc_hd__decap_12
X_11526_ _05263_ _05264_ VGND VGND VPWR VPWR _05265_ sky130_fd_sc_hd__nor2_1
XFILLER_7_57 VPWR VGND VPWR VGND sky130_ef_sc_hd__decap_12
XTAP_TAPCELL_ROW_152_2768 VGND VPWR sky130_fd_sc_hd__tapvpwrvgnd_1
XFILLER_125_742 VGND VGND VPWR VPWR sky130_fd_sc_hd__decap_4
X_11457_ _05195_ _05196_ VGND VGND VPWR VPWR _05197_ sky130_fd_sc_hd__nor2_1
X_10408_ _04155_ _04156_ VGND VGND VPWR VPWR _04157_ sky130_fd_sc_hd__and2b_1
XTAP_TAPCELL_ROW_59_1283 VGND VPWR sky130_fd_sc_hd__tapvpwrvgnd_1
XTAP_TAPCELL_ROW_59_1272 VGND VPWR sky130_fd_sc_hd__tapvpwrvgnd_1
X_11388_ _05037_ _05039_ VGND VGND VPWR VPWR _05128_ sky130_fd_sc_hd__nor2_1
XFILLER_140_734 VGND VGND VPWR VPWR sky130_fd_sc_hd__decap_4
XFILLER_140_712 VGND VGND VPWR VPWR sky130_fd_sc_hd__fill_1
X_13127_ clknet_leaf_32_clk _00137_ VGND VGND VPWR VPWR u_interface.fifo_data\[2\]\[16\]
+ sky130_fd_sc_hd__dfxtp_1
X_10339_ _04004_ _04012_ _04013_ VGND VGND VPWR VPWR _04088_ sky130_fd_sc_hd__a21o_1
X_13058_ clknet_leaf_52_clk _00068_ VGND VGND VPWR VPWR u_interface.fifo_data\[14\]\[11\]
+ sky130_fd_sc_hd__dfxtp_1
XFILLER_100_609 VGND VGND VPWR VPWR sky130_fd_sc_hd__decap_4
XFILLER_97_158 VGND VGND VPWR VPWR sky130_fd_sc_hd__decap_4
XFILLER_94_810 VGND VGND VPWR VPWR sky130_fd_sc_hd__fill_2
XFILLER_87_92 VPWR VGND VPWR VGND sky130_ef_sc_hd__decap_12
XTAP_TAPCELL_ROW_72_1494 VGND VPWR sky130_fd_sc_hd__tapvpwrvgnd_1
XTAP_TAPCELL_ROW_72_1483 VGND VPWR sky130_fd_sc_hd__tapvpwrvgnd_1
XFILLER_66_501 VGND VGND VPWR VPWR sky130_fd_sc_hd__decap_3
X_12009_ net415 net411 VGND VGND VPWR VPWR _05742_ sky130_fd_sc_hd__or2_1
XFILLER_16_3 VPWR VGND VPWR VGND sky130_ef_sc_hd__decap_12
XFILLER_94_865 VGND VGND VPWR VPWR sky130_fd_sc_hd__decap_3
XFILLER_66_578 VGND VGND VPWR VPWR sky130_fd_sc_hd__fill_1
XFILLER_66_556 VPWR VGND VPWR VGND sky130_ef_sc_hd__decap_12
X_07550_ _01665_ _01666_ net311 VGND VGND VPWR VPWR _01667_ sky130_fd_sc_hd__mux2_1
XFILLER_19_483 VGND VGND VPWR VPWR sky130_fd_sc_hd__decap_8
XTAP_TAPCELL_ROW_37_927 VGND VPWR sky130_fd_sc_hd__tapvpwrvgnd_1
X_06501_ u_interface.fifo_wr_ptr\[2\] VGND VGND VPWR VPWR _01101_ sky130_fd_sc_hd__inv_2
X_09220_ _02937_ _02966_ _02978_ VGND VGND VPWR VPWR _02979_ sky130_fd_sc_hd__a21o_1
X_07481_ net816 net1447 net300 _01614_ VGND VGND VPWR VPWR _00432_ sky130_fd_sc_hd__a22o_1
XFILLER_34_453 VGND VGND VPWR VPWR sky130_fd_sc_hd__fill_2
XFILLER_34_475 VGND VGND VPWR VPWR sky130_fd_sc_hd__fill_1
XFILLER_21_125 VPWR VGND VPWR VGND sky130_ef_sc_hd__decap_12
XFILLER_22_637 VGND VGND VPWR VPWR sky130_fd_sc_hd__decap_6
X_09151_ _02857_ _02908_ _02907_ VGND VGND VPWR VPWR _02910_ sky130_fd_sc_hd__o21ai_1
XFILLER_21_169 VGND VGND VPWR VPWR sky130_fd_sc_hd__decap_3
XFILLER_148_867 VGND VGND VPWR VPWR sky130_fd_sc_hd__fill_1
XFILLER_147_344 VGND VGND VPWR VPWR sky130_fd_sc_hd__fill_1
X_09082_ _02788_ _02835_ _02840_ VGND VGND VPWR VPWR _02841_ sky130_fd_sc_hd__nand3_1
X_08102_ net168 _01950_ net163 VGND VGND VPWR VPWR _01951_ sky130_fd_sc_hd__a21oi_1
XTAP_TAPCELL_ROW_79_1604 VGND VPWR sky130_fd_sc_hd__tapvpwrvgnd_1
XFILLER_30_681 VPWR VGND VPWR VGND sky130_ef_sc_hd__decap_12
X_08033_ u_interface.u_gelu_fp32.u_fp32_to_q16.s3_mag\[25\] u_interface.u_gelu_fp32.u_fp32_to_q16.s3_mag\[24\]
+ _01889_ VGND VGND VPWR VPWR _01890_ sky130_fd_sc_hd__and3_1
Xinput60 s_axil_awaddr[31] VGND VGND VPWR VPWR net60 sky130_fd_sc_hd__clkbuf_1
Xinput71 s_axil_wdata[0] VGND VGND VPWR VPWR net71 sky130_fd_sc_hd__clkbuf_1
Xinput82 s_axis_tdata[17] VGND VGND VPWR VPWR net82 sky130_fd_sc_hd__clkbuf_1
XTAP_TAPCELL_ROW_92_1804 VGND VPWR sky130_fd_sc_hd__tapvpwrvgnd_1
Xhold811 _00896_ VGND VGND VPWR VPWR net1676 sky130_fd_sc_hd__dlygate4sd3_1
Xhold800 u_interface.u_gelu_fp32.s2_data\[26\] VGND VGND VPWR VPWR net1665 sky130_fd_sc_hd__dlygate4sd3_1
Xinput93 s_axis_tdata[27] VGND VGND VPWR VPWR net93 sky130_fd_sc_hd__clkbuf_1
XTAP_TAPCELL_ROW_92_1815 VGND VPWR sky130_fd_sc_hd__tapvpwrvgnd_1
Xhold822 u_interface.u_gelu_fp32.u_q16_to_fp32.s3_norm_mag\[27\] VGND VGND VPWR VPWR
+ net1687 sky130_fd_sc_hd__dlygate4sd3_1
Xhold844 _00900_ VGND VGND VPWR VPWR net1709 sky130_fd_sc_hd__dlygate4sd3_1
Xhold833 _00901_ VGND VGND VPWR VPWR net1698 sky130_fd_sc_hd__dlygate4sd3_1
Xhold855 u_interface.u_gelu_fp32.u_q16_to_fp32.s2_mag\[27\] VGND VGND VPWR VPWR net1720
+ sky130_fd_sc_hd__dlygate4sd3_1
Xhold866 u_interface.fifo_rd_ptr\[1\] VGND VGND VPWR VPWR net1731 sky130_fd_sc_hd__dlygate4sd3_1
XFILLER_107_25 VGND VGND VPWR VPWR sky130_fd_sc_hd__decap_8
Xhold888 u_interface.u_gelu_fp32.u_synth_top.s1_hits\[10\] VGND VGND VPWR VPWR net1753
+ sky130_fd_sc_hd__dlygate4sd3_1
XFILLER_103_414 VPWR VGND VPWR VGND sky130_ef_sc_hd__decap_12
XFILLER_89_626 VPWR VGND VPWR VGND sky130_ef_sc_hd__decap_12
XFILLER_88_114 VGND VGND VPWR VPWR sky130_fd_sc_hd__decap_8
Xhold877 u_interface.u_gelu_fp32.u_q16_to_fp32.s3_norm_mag\[17\] VGND VGND VPWR VPWR
+ net1742 sky130_fd_sc_hd__dlygate4sd3_1
Xhold899 net144 VGND VGND VPWR VPWR net1764 sky130_fd_sc_hd__dlygate4sd3_1
XFILLER_131_745 VGND VGND VPWR VPWR sky130_fd_sc_hd__decap_6
XFILLER_130_244 VGND VGND VPWR VPWR sky130_fd_sc_hd__fill_1
XFILLER_103_436 VGND VGND VPWR VPWR sky130_fd_sc_hd__decap_4
X_09984_ _03632_ _03734_ _03735_ VGND VGND VPWR VPWR _03737_ sky130_fd_sc_hd__and3_1
XFILLER_130_277 VGND VGND VPWR VPWR sky130_fd_sc_hd__decap_6
X_08935_ _02546_ _02548_ _02691_ _02692_ VGND VGND VPWR VPWR _02694_ sky130_fd_sc_hd__o211a_1
XFILLER_97_670 VGND VGND VPWR VPWR sky130_fd_sc_hd__fill_2
XFILLER_76_309 VGND VGND VPWR VPWR sky130_fd_sc_hd__decap_6
X_08866_ _02602_ _02624_ VGND VGND VPWR VPWR _02625_ sky130_fd_sc_hd__nor2_1
X_08797_ _02504_ _02506_ VGND VGND VPWR VPWR _02556_ sky130_fd_sc_hd__xnor2_1
XTAP_TAPCELL_ROW_123_2303 VGND VPWR sky130_fd_sc_hd__tapvpwrvgnd_1
X_07817_ net1400 net354 net230 VGND VGND VPWR VPWR _00578_ sky130_fd_sc_hd__mux2_1
XFILLER_45_718 VGND VGND VPWR VPWR sky130_fd_sc_hd__fill_1
X_07748_ net826 u_interface.u_gelu_fp32.u_q16_to_fp32.s3_is_zero VGND VGND VPWR VPWR
+ _01792_ sky130_fd_sc_hd__nor2_1
XFILLER_45_729 VGND VGND VPWR VPWR sky130_fd_sc_hd__fill_1
XFILLER_44_228 VGND VGND VPWR VPWR sky130_fd_sc_hd__decap_4
X_07679_ u_interface.u_gelu_fp32.u_synth_top.s1_hits\[11\] u_interface.u_gelu_fp32.u_synth_top.s1_hits\[9\]
+ VGND VGND VPWR VPWR _01755_ sky130_fd_sc_hd__or2_1
XFILLER_13_615 VGND VGND VPWR VPWR sky130_fd_sc_hd__fill_1
XFILLER_16_77 VGND VGND VPWR VPWR sky130_fd_sc_hd__decap_6
XFILLER_25_475 VPWR VGND VPWR VGND sky130_ef_sc_hd__decap_12
X_09418_ net500 net689 net697 net505 VGND VGND VPWR VPWR _03176_ sky130_fd_sc_hd__a22oi_1
X_10690_ _03969_ _03970_ _04436_ VGND VGND VPWR VPWR _04437_ sky130_fd_sc_hd__a21o_1
X_09349_ _02919_ _03087_ _03098_ _03105_ _03107_ VGND VGND VPWR VPWR _03108_ sky130_fd_sc_hd__a221o_1
XTAP_TAPCELL_ROW_101_1955 VGND VPWR sky130_fd_sc_hd__tapvpwrvgnd_1
XTAP_TAPCELL_ROW_101_1944 VGND VPWR sky130_fd_sc_hd__tapvpwrvgnd_1
XFILLER_40_467 VGND VGND VPWR VPWR sky130_fd_sc_hd__decap_8
XFILLER_139_856 VGND VGND VPWR VPWR sky130_fd_sc_hd__fill_1
XFILLER_138_333 VGND VGND VPWR VPWR sky130_fd_sc_hd__decap_8
X_12360_ net718 net395 _06023_ _06022_ VGND VGND VPWR VPWR _06088_ sky130_fd_sc_hd__a31o_1
XTAP_TAPCELL_ROW_23_698 VGND VPWR sky130_fd_sc_hd__tapvpwrvgnd_1
XFILLER_40_489 VGND VGND VPWR VPWR sky130_fd_sc_hd__fill_2
XFILLER_154_826 VPWR VGND VPWR VGND sky130_ef_sc_hd__decap_12
XFILLER_154_804 VGND VGND VPWR VPWR sky130_fd_sc_hd__fill_2
X_11311_ net686 net430 net425 net677 VGND VGND VPWR VPWR _05052_ sky130_fd_sc_hd__a22o_1
XFILLER_20_180 VGND VGND VPWR VPWR sky130_fd_sc_hd__fill_1
XFILLER_138_399 VGND VGND VPWR VPWR sky130_fd_sc_hd__decap_3
XTAP_TAPCELL_ROW_134_2476 VGND VPWR sky130_fd_sc_hd__tapvpwrvgnd_1
X_12291_ net702 net388 VGND VGND VPWR VPWR _06020_ sky130_fd_sc_hd__and2b_1
XFILLER_153_347 VGND VGND VPWR VPWR sky130_fd_sc_hd__decap_4
XTAP_TAPCELL_ROW_134_2487 VGND VPWR sky130_fd_sc_hd__tapvpwrvgnd_1
X_14030_ clknet_leaf_34_clk _00956_ VGND VGND VPWR VPWR u_interface.core_data_out\[16\]
+ sky130_fd_sc_hd__dfxtp_1
XFILLER_4_357 VGND VGND VPWR VPWR sky130_fd_sc_hd__decap_6
X_11242_ net611 u_interface.u_gelu_fp32.u_synth_top.s2_dx\[29\] VGND VGND VPWR VPWR
+ _04984_ sky130_fd_sc_hd__nand2_1
XFILLER_106_263 VGND VGND VPWR VPWR sky130_fd_sc_hd__fill_2
X_11173_ _04796_ _04800_ _04799_ VGND VGND VPWR VPWR _04915_ sky130_fd_sc_hd__o21ai_1
X_10124_ _03873_ _03874_ _03865_ VGND VGND VPWR VPWR _03875_ sky130_fd_sc_hd__a21o_1
XFILLER_110_918 VGND VGND VPWR VPWR sky130_fd_sc_hd__decap_3
XFILLER_102_491 VGND VGND VPWR VPWR sky130_fd_sc_hd__fill_2
X_10055_ net474 net478 net688 net698 VGND VGND VPWR VPWR _03807_ sky130_fd_sc_hd__and4_1
XFILLER_48_545 VGND VGND VPWR VPWR sky130_fd_sc_hd__decap_8
XFILLER_0_585 VGND VGND VPWR VPWR sky130_fd_sc_hd__decap_3
XFILLER_76_887 VGND VGND VPWR VPWR sky130_fd_sc_hd__fill_2
XFILLER_76_865 VGND VGND VPWR VPWR sky130_fd_sc_hd__decap_3
XFILLER_75_331 VGND VGND VPWR VPWR sky130_fd_sc_hd__decap_4
XFILLER_75_375 VGND VGND VPWR VPWR sky130_fd_sc_hd__decap_4
X_13814_ clknet_leaf_86_clk _00824_ VGND VGND VPWR VPWR u_interface.u_gelu_fp32.u_synth_top.s3_mult\[32\]
+ sky130_fd_sc_hd__dfxtp_1
XTAP_TAPCELL_ROW_3_390 VGND VPWR sky130_fd_sc_hd__tapvpwrvgnd_1
X_13745_ clknet_leaf_59_clk net1653 VGND VGND VPWR VPWR u_interface.u_gelu_fp32.u_q16_to_fp32.s1_mag\[11\]
+ sky130_fd_sc_hd__dfxtp_1
X_10957_ net460 net720 VGND VGND VPWR VPWR _04701_ sky130_fd_sc_hd__nand2_2
XFILLER_50_209 VPWR VGND VPWR VGND sky130_ef_sc_hd__decap_12
XFILLER_16_453 VGND VGND VPWR VPWR sky130_fd_sc_hd__fill_2
X_13676_ clknet_leaf_12_clk _00686_ VGND VGND VPWR VPWR u_interface.u_gelu_fp32.u_fp32_to_q16.s3_frac\[12\]
+ sky130_fd_sc_hd__dfxtp_1
XFILLER_148_119 VGND VGND VPWR VPWR sky130_fd_sc_hd__fill_1
XFILLER_129_300 VPWR VGND VPWR VGND sky130_ef_sc_hd__decap_12
X_12627_ net823 net1516 _06328_ _06329_ VGND VGND VPWR VPWR _00874_ sky130_fd_sc_hd__a22o_1
X_10888_ net586 net396 net392 net579 VGND VGND VPWR VPWR _04633_ sky130_fd_sc_hd__a22o_1
XFILLER_12_681 VPWR VGND VPWR VGND sky130_ef_sc_hd__decap_12
X_12558_ net783 u_interface.u_gelu_fp32.u_synth_top.s2_b\[2\] VGND VGND VPWR VPWR
+ _00856_ sky130_fd_sc_hd__and2_1
Xhold107 u_interface.fifo_data\[10\]\[22\] VGND VGND VPWR VPWR net972 sky130_fd_sc_hd__dlygate4sd3_1
XFILLER_129_399 VGND VGND VPWR VPWR sky130_fd_sc_hd__fill_1
XFILLER_117_528 VGND VGND VPWR VPWR sky130_fd_sc_hd__fill_2
X_12489_ _06214_ VGND VGND VPWR VPWR _06215_ sky130_fd_sc_hd__inv_2
X_11509_ _05244_ _05245_ _05246_ VGND VGND VPWR VPWR _05248_ sky130_fd_sc_hd__nand3_1
Xhold129 u_interface.fifo_data\[15\]\[16\] VGND VGND VPWR VPWR net994 sky130_fd_sc_hd__dlygate4sd3_1
XFILLER_125_550 VGND VGND VPWR VPWR sky130_fd_sc_hd__decap_8
XTAP_TAPCELL_ROW_74_1523 VGND VPWR sky130_fd_sc_hd__tapvpwrvgnd_1
XTAP_TAPCELL_ROW_74_1512 VGND VPWR sky130_fd_sc_hd__tapvpwrvgnd_1
Xhold118 u_interface.fifo_data\[14\]\[21\] VGND VGND VPWR VPWR net983 sky130_fd_sc_hd__dlygate4sd3_1
X_14159_ clknet_leaf_42_clk _01085_ VGND VGND VPWR VPWR u_interface.fifo_data\[1\]\[19\]
+ sky130_fd_sc_hd__dfxtp_1
Xfanout609 net610 VGND VGND VPWR VPWR net609 sky130_fd_sc_hd__buf_2
X_06981_ net1126 net327 net267 VGND VGND VPWR VPWR _00042_ sky130_fd_sc_hd__mux2_1
XFILLER_67_810 VGND VGND VPWR VPWR sky130_fd_sc_hd__fill_2
XFILLER_39_501 VGND VGND VPWR VPWR sky130_fd_sc_hd__decap_3
X_08720_ _02476_ _02477_ _02472_ VGND VGND VPWR VPWR _02479_ sky130_fd_sc_hd__a21o_1
XPHY_EDGE_ROW_13_Left_169 VGND VGND VPWR VPWR sky130_fd_sc_hd__decap_3
XFILLER_39_534 VGND VGND VPWR VPWR sky130_fd_sc_hd__decap_8
XFILLER_66_331 VGND VGND VPWR VPWR sky130_fd_sc_hd__fill_1
X_08651_ _02266_ _02270_ VGND VGND VPWR VPWR _02418_ sky130_fd_sc_hd__nor2_1
XFILLER_39_578 VGND VGND VPWR VPWR sky130_fd_sc_hd__fill_1
XTAP_TAPCELL_ROW_105_2022 VGND VPWR sky130_fd_sc_hd__tapvpwrvgnd_1
XTAP_TAPCELL_ROW_105_2011 VGND VPWR sky130_fd_sc_hd__tapvpwrvgnd_1
XFILLER_94_695 VGND VGND VPWR VPWR sky130_fd_sc_hd__decap_4
X_07602_ _01114_ net339 net334 VGND VGND VPWR VPWR _01698_ sky130_fd_sc_hd__or3_1
XFILLER_54_537 VGND VGND VPWR VPWR sky130_fd_sc_hd__fill_1
XTAP_TAPCELL_ROW_1_349 VGND VPWR sky130_fd_sc_hd__tapvpwrvgnd_1
XFILLER_27_729 VPWR VGND VPWR VGND sky130_ef_sc_hd__decap_12
X_08582_ _02205_ _02206_ _02219_ VGND VGND VPWR VPWR _02369_ sky130_fd_sc_hd__a21o_1
XFILLER_93_194 VGND VGND VPWR VPWR sky130_fd_sc_hd__decap_6
X_07533_ net811 net1583 net300 _01660_ VGND VGND VPWR VPWR _00438_ sky130_fd_sc_hd__a22o_1
XFILLER_41_209 VPWR VGND VPWR VGND sky130_ef_sc_hd__decap_12
X_07464_ _01598_ _01594_ u_interface.u_gelu_fp32.u_fp32_to_q16.s2_shift\[3\] VGND
+ VGND VPWR VPWR _01599_ sky130_fd_sc_hd__mux2_1
XTAP_TAPCELL_ROW_85_1696 VGND VPWR sky130_fd_sc_hd__tapvpwrvgnd_1
XFILLER_22_434 VPWR VGND VPWR VGND sky130_ef_sc_hd__decap_12
X_09203_ _02951_ _02952_ _02947_ VGND VGND VPWR VPWR _02962_ sky130_fd_sc_hd__o21a_1
XPHY_EDGE_ROW_22_Left_178 VGND VGND VPWR VPWR sky130_fd_sc_hd__decap_3
X_09134_ _02883_ _02892_ VGND VGND VPWR VPWR _02893_ sky130_fd_sc_hd__nor2_1
X_07395_ net1275 net567 net240 VGND VGND VPWR VPWR _00425_ sky130_fd_sc_hd__mux2_1
XFILLER_108_517 VPWR VGND VPWR VGND sky130_ef_sc_hd__decap_12
XTAP_TAPCELL_ROW_20_657 VGND VPWR sky130_fd_sc_hd__tapvpwrvgnd_1
X_09065_ net590 net487 net492 net597 VGND VGND VPWR VPWR _02824_ sky130_fd_sc_hd__a22o_1
XFILLER_118_24 VGND VGND VPWR VPWR sky130_fd_sc_hd__decap_4
X_08016_ u_interface.u_gelu_fp32.u_fp32_to_q16.s3_mag\[0\] u_interface.u_gelu_fp32.u_fp32_to_q16.round_bit
+ u_interface.u_gelu_fp32.u_fp32_to_q16.s3_mag\[1\] VGND VGND VPWR VPWR _01873_ sky130_fd_sc_hd__and3_1
XTAP_TAPCELL_ROW_116_2195 VGND VPWR sky130_fd_sc_hd__tapvpwrvgnd_1
XTAP_TAPCELL_ROW_116_2184 VGND VPWR sky130_fd_sc_hd__tapvpwrvgnd_1
Xhold630 u_interface.fifo_data\[11\]\[30\] VGND VGND VPWR VPWR net1495 sky130_fd_sc_hd__dlygate4sd3_1
Xhold652 _00930_ VGND VGND VPWR VPWR net1517 sky130_fd_sc_hd__dlygate4sd3_1
Xhold663 u_interface.fifo_data\[3\]\[30\] VGND VGND VPWR VPWR net1528 sky130_fd_sc_hd__dlygate4sd3_1
Xhold641 u_interface.fifo_data\[3\]\[8\] VGND VGND VPWR VPWR net1506 sky130_fd_sc_hd__dlygate4sd3_1
XFILLER_1_305 VPWR VGND VPWR VGND sky130_ef_sc_hd__decap_12
XFILLER_143_380 VGND VGND VPWR VPWR sky130_fd_sc_hd__fill_2
XFILLER_131_531 VGND VGND VPWR VPWR sky130_fd_sc_hd__decap_3
Xhold674 u_interface.fifo_data\[6\]\[29\] VGND VGND VPWR VPWR net1539 sky130_fd_sc_hd__dlygate4sd3_1
Xhold685 u_interface.u_gelu_fp32.u_q16_to_fp32.s2_exp\[7\] VGND VGND VPWR VPWR net1550
+ sky130_fd_sc_hd__dlygate4sd3_1
Xhold696 u_interface.u_gelu_fp32.s2_data\[5\] VGND VGND VPWR VPWR net1561 sky130_fd_sc_hd__dlygate4sd3_1
XFILLER_89_456 VGND VGND VPWR VPWR sky130_fd_sc_hd__decap_4
XFILLER_1_349 VPWR VGND VPWR VGND sky130_ef_sc_hd__decap_12
X_09967_ _03576_ _03717_ _03718_ VGND VGND VPWR VPWR _03720_ sky130_fd_sc_hd__nand3_1
XPHY_EDGE_ROW_31_Left_187 VGND VGND VPWR VPWR sky130_fd_sc_hd__decap_3
X_08918_ _02607_ _02615_ _02616_ VGND VGND VPWR VPWR _02677_ sky130_fd_sc_hd__a21o_1
XFILLER_76_128 VGND VGND VPWR VPWR sky130_fd_sc_hd__decap_3
XFILLER_134_89 VPWR VGND VPWR VGND sky130_ef_sc_hd__decap_12
X_09898_ _03549_ _03551_ _03646_ _03647_ VGND VGND VPWR VPWR _03651_ sky130_fd_sc_hd__a211o_1
XFILLER_69_191 VGND VGND VPWR VPWR sky130_fd_sc_hd__decap_8
X_08849_ net614 net472 VGND VGND VPWR VPWR _02608_ sky130_fd_sc_hd__and2_1
XFILLER_85_695 VGND VGND VPWR VPWR sky130_fd_sc_hd__decap_8
XFILLER_73_879 VGND VGND VPWR VPWR sky130_fd_sc_hd__fill_1
XFILLER_72_345 VPWR VGND VPWR VGND sky130_ef_sc_hd__decap_12
X_11860_ _05588_ _05593_ VGND VGND VPWR VPWR _05595_ sky130_fd_sc_hd__xor2_1
XFILLER_150_77 VGND VGND VPWR VPWR sky130_fd_sc_hd__decap_6
X_10811_ net773 _04555_ _04556_ VGND VGND VPWR VPWR _00821_ sky130_fd_sc_hd__and3_1
XFILLER_13_401 VGND VGND VPWR VPWR sky130_fd_sc_hd__decap_3
X_11791_ _05523_ _05526_ VGND VGND VPWR VPWR _05527_ sky130_fd_sc_hd__xnor2_1
XTAP_TAPCELL_ROW_28_779 VGND VPWR sky130_fd_sc_hd__tapvpwrvgnd_1
X_10742_ _04486_ _04487_ _04365_ _04368_ VGND VGND VPWR VPWR _04488_ sky130_fd_sc_hd__o211a_1
X_13530_ clknet_leaf_83_clk _00540_ VGND VGND VPWR VPWR u_interface.fifo_data\[5\]\[9\]
+ sky130_fd_sc_hd__dfxtp_1
XFILLER_13_423 VGND VGND VPWR VPWR sky130_fd_sc_hd__fill_2
XPHY_EDGE_ROW_40_Left_196 VGND VGND VPWR VPWR sky130_fd_sc_hd__decap_3
XFILLER_40_220 VGND VGND VPWR VPWR sky130_fd_sc_hd__decap_3
XFILLER_9_405 VGND VGND VPWR VPWR sky130_fd_sc_hd__decap_4
XTAP_TAPCELL_ROW_136_2516 VGND VPWR sky130_fd_sc_hd__tapvpwrvgnd_1
XTAP_TAPCELL_ROW_136_2505 VGND VPWR sky130_fd_sc_hd__tapvpwrvgnd_1
X_13461_ clknet_leaf_60_clk _00471_ VGND VGND VPWR VPWR u_interface.u_gelu_fp32.u_q16_to_fp32.s3_norm_mag\[1\]
+ sky130_fd_sc_hd__dfxtp_1
X_10673_ _04340_ _04341_ _04418_ _04419_ VGND VGND VPWR VPWR _04420_ sky130_fd_sc_hd__a22oi_1
XFILLER_43_97 VGND VGND VPWR VPWR sky130_fd_sc_hd__fill_2
XFILLER_138_141 VGND VGND VPWR VPWR sky130_fd_sc_hd__fill_2
X_13392_ clknet_leaf_70_clk _00402_ VGND VGND VPWR VPWR u_interface.fifo_data\[6\]\[5\]
+ sky130_fd_sc_hd__dfxtp_1
X_12412_ _05958_ _06138_ VGND VGND VPWR VPWR _06139_ sky130_fd_sc_hd__nand2b_1
XFILLER_154_645 VGND VGND VPWR VPWR sky130_fd_sc_hd__decap_4
XFILLER_154_634 VGND VGND VPWR VPWR sky130_fd_sc_hd__fill_2
X_12343_ net182 _06070_ VGND VGND VPWR VPWR _06071_ sky130_fd_sc_hd__xnor2_1
XFILLER_154_656 VGND VGND VPWR VPWR sky130_fd_sc_hd__fill_1
XFILLER_4_121 VPWR VGND VPWR VGND sky130_ef_sc_hd__decap_12
X_12274_ _06001_ _06002_ VGND VGND VPWR VPWR _06003_ sky130_fd_sc_hd__nor2_1
X_14013_ clknet_leaf_33_clk _00939_ VGND VGND VPWR VPWR u_interface.u_gelu_fp32.u_q16_to_fp32.s3_valid
+ sky130_fd_sc_hd__dfxtp_1
XFILLER_107_583 VGND VGND VPWR VPWR sky130_fd_sc_hd__fill_2
XTAP_TAPCELL_ROW_56_1231 VGND VPWR sky130_fd_sc_hd__tapvpwrvgnd_1
X_11225_ net628 net408 _04867_ _04865_ VGND VGND VPWR VPWR _04967_ sky130_fd_sc_hd__a31o_1
XFILLER_4_165 VPWR VGND VPWR VGND sky130_ef_sc_hd__decap_12
XFILLER_68_618 VGND VGND VPWR VPWR sky130_fd_sc_hd__decap_4
X_11156_ _04897_ _04898_ VGND VGND VPWR VPWR _04899_ sky130_fd_sc_hd__nand2b_1
XTAP_TAPCELL_ROW_8_471 VGND VPWR sky130_fd_sc_hd__tapvpwrvgnd_1
XTAP_TAPCELL_ROW_8_460 VGND VPWR sky130_fd_sc_hd__tapvpwrvgnd_1
X_10107_ _03857_ _03858_ VGND VGND VPWR VPWR _03859_ sky130_fd_sc_hd__nor2_1
XFILLER_95_437 VGND VGND VPWR VPWR sky130_fd_sc_hd__decap_6
X_11087_ _04828_ _04829_ VGND VGND VPWR VPWR _04830_ sky130_fd_sc_hd__nor2_1
XTAP_TAPCELL_ROW_147_2689 VGND VPWR sky130_fd_sc_hd__tapvpwrvgnd_1
X_10038_ _03786_ _03789_ VGND VGND VPWR VPWR _03790_ sky130_fd_sc_hd__xnor2_1
XFILLER_0_393 VPWR VGND VPWR VGND sky130_ef_sc_hd__decap_12
XFILLER_82_109 VGND VGND VPWR VPWR sky130_fd_sc_hd__decap_4
XFILLER_64_813 VGND VGND VPWR VPWR sky130_fd_sc_hd__fill_1
XFILLER_63_301 VPWR VGND VPWR VGND sky130_ef_sc_hd__decap_12
XFILLER_36_515 VGND VGND VPWR VPWR sky130_fd_sc_hd__fill_1
X_13728_ clknet_leaf_7_clk _00738_ VGND VGND VPWR VPWR u_interface.u_gelu_fp32.s1_data\[28\]
+ sky130_fd_sc_hd__dfxtp_1
XFILLER_90_197 VGND VGND VPWR VPWR sky130_fd_sc_hd__fill_1
X_11989_ _05721_ _05722_ net793 VGND VGND VPWR VPWR _05723_ sky130_fd_sc_hd__a21oi_1
XFILLER_20_905 VPWR VGND VPWR VGND sky130_ef_sc_hd__decap_12
X_13659_ clknet_leaf_14_clk _00669_ VGND VGND VPWR VPWR u_interface.u_gelu_fp32.u_fp32_to_q16.s1_exp\[5\]
+ sky130_fd_sc_hd__dfxtp_1
XFILLER_83_3 VPWR VGND VPWR VGND sky130_ef_sc_hd__decap_12
XPHY_EDGE_ROW_140_Right_140 VGND VGND VPWR VPWR sky130_fd_sc_hd__decap_3
X_07180_ net1559 net345 net261 VGND VGND VPWR VPWR _00220_ sky130_fd_sc_hd__mux2_1
XFILLER_117_358 VGND VGND VPWR VPWR sky130_fd_sc_hd__decap_8
XFILLER_113_520 VGND VGND VPWR VPWR sky130_fd_sc_hd__decap_3
XFILLER_98_231 VPWR VGND VPWR VGND sky130_ef_sc_hd__decap_12
XFILLER_141_862 VGND VGND VPWR VPWR sky130_fd_sc_hd__decap_6
XFILLER_98_253 VGND VGND VPWR VPWR sky130_fd_sc_hd__decap_6
X_09821_ _03568_ _03573_ VGND VGND VPWR VPWR _03575_ sky130_fd_sc_hd__xnor2_1
Xfanout428 u_interface.u_gelu_fp32.u_synth_top.s2_dx\[22\] VGND VGND VPWR VPWR net428
+ sky130_fd_sc_hd__buf_1
Xfanout417 net418 VGND VGND VPWR VPWR net417 sky130_fd_sc_hd__buf_2
Xfanout439 net440 VGND VGND VPWR VPWR net439 sky130_fd_sc_hd__buf_1
Xfanout406 net409 VGND VGND VPWR VPWR net406 sky130_fd_sc_hd__buf_2
X_09752_ _03469_ _03504_ _03505_ VGND VGND VPWR VPWR _03507_ sky130_fd_sc_hd__and3_1
X_08703_ net690 net515 net519 net697 VGND VGND VPWR VPWR _02462_ sky130_fd_sc_hd__a22oi_1
XFILLER_104_26 VGND VGND VPWR VPWR sky130_fd_sc_hd__fill_2
X_06964_ u_interface.u_gelu_fp32.u_synth_top.s1_x\[30\] net273 VGND VGND VPWR VPWR
+ _01492_ sky130_fd_sc_hd__nand2_1
XFILLER_67_662 VGND VGND VPWR VPWR sky130_fd_sc_hd__decap_8
XFILLER_39_331 VGND VGND VPWR VPWR sky130_fd_sc_hd__decap_4
X_09683_ _03436_ _03437_ _03435_ VGND VGND VPWR VPWR _03438_ sky130_fd_sc_hd__a21o_1
XFILLER_104_37 VGND VGND VPWR VPWR sky130_fd_sc_hd__decap_3
X_06895_ _01184_ _01436_ u_interface.u_gelu_fp32.u_synth_top.s1_x\[16\] VGND VGND
+ VPWR VPWR _01437_ sky130_fd_sc_hd__a21oi_1
XTAP_TAPCELL_ROW_87_1725 VGND VPWR sky130_fd_sc_hd__tapvpwrvgnd_1
XFILLER_27_526 VPWR VGND VPWR VGND sky130_ef_sc_hd__decap_12
X_08634_ net157 _02405_ VGND VGND VPWR VPWR _02406_ sky130_fd_sc_hd__nand2_1
XFILLER_55_857 VGND VGND VPWR VPWR sky130_fd_sc_hd__fill_2
XFILLER_39_397 VGND VGND VPWR VPWR sky130_fd_sc_hd__fill_2
XFILLER_82_676 VPWR VGND VPWR VGND sky130_ef_sc_hd__decap_12
XFILLER_54_356 VGND VGND VPWR VPWR sky130_fd_sc_hd__fill_2
X_08565_ _02325_ _02328_ _02347_ _02348_ VGND VGND VPWR VPWR _02356_ sky130_fd_sc_hd__and4_1
X_07516_ _01609_ _01601_ net550 VGND VGND VPWR VPWR _01646_ sky130_fd_sc_hd__mux2_1
XFILLER_23_721 VGND VGND VPWR VPWR sky130_fd_sc_hd__decap_6
XTAP_TAPCELL_ROW_25_738 VGND VPWR sky130_fd_sc_hd__tapvpwrvgnd_1
XFILLER_23_765 VPWR VGND VPWR VGND sky130_ef_sc_hd__decap_12
X_08496_ u_interface.u_gelu_fp32.u_synth_top.s3_mult\[47\] u_interface.u_gelu_fp32.u_synth_top.s3_mult\[46\]
+ u_interface.u_gelu_fp32.u_synth_top.s3_mult\[45\] u_interface.u_gelu_fp32.u_synth_top.s3_mult\[44\]
+ net522 VGND VGND VPWR VPWR _02287_ sky130_fd_sc_hd__o41a_1
X_07447_ u_interface.u_gelu_fp32.u_fp32_to_q16.s2_norm_mag\[29\] u_interface.u_gelu_fp32.u_fp32_to_q16.s2_norm_mag\[30\]
+ net559 VGND VGND VPWR VPWR _01582_ sky130_fd_sc_hd__mux2_1
XFILLER_22_253 VPWR VGND VPWR VGND sky130_ef_sc_hd__decap_12
XFILLER_22_286 VPWR VGND VPWR VGND sky130_ef_sc_hd__decap_12
XTAP_TAPCELL_ROW_118_2224 VGND VPWR sky130_fd_sc_hd__tapvpwrvgnd_1
X_07378_ net996 net362 net240 VGND VGND VPWR VPWR _00408_ sky130_fd_sc_hd__mux2_1
XFILLER_7_909 VPWR VGND VPWR VGND sky130_ef_sc_hd__decap_12
X_09117_ net582 net487 net492 net592 VGND VGND VPWR VPWR _02876_ sky130_fd_sc_hd__a22o_1
XFILLER_108_325 VPWR VGND VPWR VGND sky130_ef_sc_hd__decap_12
X_09048_ _02756_ _02805_ _02804_ VGND VGND VPWR VPWR _02807_ sky130_fd_sc_hd__a21oi_1
XTAP_TAPCELL_ROW_131_2424 VGND VPWR sky130_fd_sc_hd__tapvpwrvgnd_1
XFILLER_129_89 VGND VGND VPWR VPWR sky130_fd_sc_hd__decap_4
XTAP_TAPCELL_ROW_98_1898 VGND VPWR sky130_fd_sc_hd__tapvpwrvgnd_1
XFILLER_135_177 VGND VGND VPWR VPWR sky130_fd_sc_hd__fill_1
XTAP_TAPCELL_ROW_131_2435 VGND VPWR sky130_fd_sc_hd__tapvpwrvgnd_1
Xhold471 u_interface.fifo_data\[9\]\[7\] VGND VGND VPWR VPWR net1336 sky130_fd_sc_hd__dlygate4sd3_1
Xhold460 u_interface.fifo_data\[15\]\[11\] VGND VGND VPWR VPWR net1325 sky130_fd_sc_hd__dlygate4sd3_1
XFILLER_1_113 VPWR VGND VPWR VGND sky130_ef_sc_hd__decap_12
XFILLER_2_625 VPWR VGND VPWR VGND sky130_ef_sc_hd__decap_12
Xhold482 u_interface.fifo_data\[11\]\[22\] VGND VGND VPWR VPWR net1347 sky130_fd_sc_hd__dlygate4sd3_1
Xhold493 u_interface.u_gelu_fp32.u_fp32_to_q16.s1_mant\[4\] VGND VGND VPWR VPWR net1358
+ sky130_fd_sc_hd__dlygate4sd3_1
XFILLER_145_55 VGND VGND VPWR VPWR sky130_fd_sc_hd__fill_1
XFILLER_104_542 VGND VGND VPWR VPWR sky130_fd_sc_hd__decap_3
X_11010_ net611 net404 net400 net602 VGND VGND VPWR VPWR _04754_ sky130_fd_sc_hd__a22oi_1
XFILLER_2_669 VPWR VGND VPWR VGND sky130_ef_sc_hd__decap_12
XFILLER_104_597 VPWR VGND VPWR VGND sky130_ef_sc_hd__decap_12
XTAP_TAPCELL_ROW_51_1150 VGND VPWR sky130_fd_sc_hd__tapvpwrvgnd_1
X_12961_ u_interface.fifo_count\[2\] _06468_ _06480_ net790 VGND VGND VPWR VPWR _01061_
+ sky130_fd_sc_hd__o211a_1
XTAP_TAPCELL_ROW_129_2397 VGND VPWR sky130_fd_sc_hd__tapvpwrvgnd_1
XFILLER_46_813 VGND VGND VPWR VPWR sky130_fd_sc_hd__decap_4
XFILLER_45_312 VPWR VGND VPWR VGND sky130_ef_sc_hd__decap_12
XFILLER_38_64 VGND VGND VPWR VPWR sky130_fd_sc_hd__fill_1
XFILLER_38_97 VGND VGND VPWR VPWR sky130_fd_sc_hd__decap_3
X_12892_ net789 net939 VGND VGND VPWR VPWR _01034_ sky130_fd_sc_hd__and2_1
X_11912_ _05641_ _05646_ VGND VGND VPWR VPWR _05647_ sky130_fd_sc_hd__nor2_1
X_11843_ net214 _05505_ _05577_ VGND VGND VPWR VPWR _05578_ sky130_fd_sc_hd__a21o_1
XFILLER_54_52 VPWR VGND VPWR VGND sky130_ef_sc_hd__decap_12
XFILLER_54_85 VGND VGND VPWR VPWR sky130_fd_sc_hd__decap_8
X_11774_ _05508_ _05509_ VGND VGND VPWR VPWR _05510_ sky130_fd_sc_hd__nor2_1
X_13513_ clknet_leaf_49_clk _00523_ VGND VGND VPWR VPWR u_interface.core_data_out\[24\]
+ sky130_fd_sc_hd__dfxtp_1
X_10725_ net452 net457 net687 net695 VGND VGND VPWR VPWR _04471_ sky130_fd_sc_hd__nand4_1
X_13444_ clknet_leaf_10_clk _00454_ VGND VGND VPWR VPWR u_interface.u_gelu_fp32.u_fp32_to_q16.s3_mag\[15\]
+ sky130_fd_sc_hd__dfxtp_1
XFILLER_110_91 VGND VGND VPWR VPWR sky130_fd_sc_hd__decap_8
X_10656_ _04401_ _04402_ _04279_ VGND VGND VPWR VPWR _04403_ sky130_fd_sc_hd__a21o_1
XFILLER_9_235 VGND VGND VPWR VPWR sky130_fd_sc_hd__decap_8
XFILLER_139_494 VGND VGND VPWR VPWR sky130_fd_sc_hd__decap_8
XFILLER_139_483 VGND VGND VPWR VPWR sky130_fd_sc_hd__fill_1
XFILLER_126_111 VGND VGND VPWR VPWR sky130_fd_sc_hd__decap_4
Xclkload16 clknet_leaf_57_clk VGND VGND VPWR VPWR clkload16/Y sky130_fd_sc_hd__inv_6
Xclkload38 clknet_leaf_28_clk VGND VGND VPWR VPWR clkload38/Y sky130_fd_sc_hd__inv_12
Xclkload27 clknet_leaf_12_clk VGND VGND VPWR VPWR clkload27/Y sky130_fd_sc_hd__inv_12
XFILLER_126_133 VGND VGND VPWR VPWR sky130_fd_sc_hd__decap_6
X_10587_ _04331_ _04332_ _04333_ VGND VGND VPWR VPWR _04334_ sky130_fd_sc_hd__a21o_1
X_13375_ clknet_leaf_70_clk _00385_ VGND VGND VPWR VPWR u_interface.fifo_data\[7\]\[20\]
+ sky130_fd_sc_hd__dfxtp_1
Xclkload49 clknet_leaf_82_clk VGND VGND VPWR VPWR clkload49/Y sky130_fd_sc_hd__bufinv_16
XFILLER_154_464 VPWR VGND VPWR VGND sky130_ef_sc_hd__decap_12
XFILLER_114_317 VPWR VGND VPWR VGND sky130_ef_sc_hd__decap_12
X_12326_ net192 _06053_ VGND VGND VPWR VPWR _06055_ sky130_fd_sc_hd__nand2_1
XTAP_TAPCELL_ROW_149_2718 VGND VPWR sky130_fd_sc_hd__tapvpwrvgnd_1
XFILLER_5_485 VPWR VGND VPWR VGND sky130_ef_sc_hd__decap_12
X_12257_ _05984_ _05985_ VGND VGND VPWR VPWR _05987_ sky130_fd_sc_hd__xor2_1
X_11208_ _04948_ _04949_ VGND VGND VPWR VPWR _04950_ sky130_fd_sc_hd__or2_1
X_12188_ _05804_ _05852_ _05851_ VGND VGND VPWR VPWR _05919_ sky130_fd_sc_hd__o21ai_1
XFILLER_122_383 VGND VGND VPWR VPWR sky130_fd_sc_hd__decap_4
XFILLER_110_512 VGND VGND VPWR VPWR sky130_fd_sc_hd__fill_1
XFILLER_96_746 VGND VGND VPWR VPWR sky130_fd_sc_hd__fill_2
XFILLER_95_212 VPWR VGND VPWR VGND sky130_ef_sc_hd__decap_12
XFILLER_95_245 VPWR VGND VPWR VGND sky130_ef_sc_hd__decap_12
X_11139_ _04751_ _04766_ _04765_ VGND VGND VPWR VPWR _04882_ sky130_fd_sc_hd__a21oi_1
XFILLER_49_640 VGND VGND VPWR VPWR sky130_fd_sc_hd__decap_4
XFILLER_110_589 VPWR VGND VPWR VGND sky130_ef_sc_hd__decap_12
XFILLER_95_267 VPWR VGND VPWR VGND sky130_ef_sc_hd__decap_12
XFILLER_48_150 VGND VGND VPWR VPWR sky130_fd_sc_hd__fill_2
XFILLER_36_301 VGND VGND VPWR VPWR sky130_fd_sc_hd__decap_6
XTAP_TAPCELL_ROW_69_1444 VGND VPWR sky130_fd_sc_hd__tapvpwrvgnd_1
XTAP_TAPCELL_ROW_69_1433 VGND VPWR sky130_fd_sc_hd__tapvpwrvgnd_1
X_06680_ net320 _01248_ net725 VGND VGND VPWR VPWR _01249_ sky130_fd_sc_hd__o21a_1
XFILLER_37_857 VGND VGND VPWR VPWR sky130_fd_sc_hd__fill_2
XFILLER_91_473 VPWR VGND VPWR VGND sky130_ef_sc_hd__decap_12
XFILLER_63_197 VGND VGND VPWR VPWR sky130_fd_sc_hd__decap_3
XFILLER_51_337 VGND VGND VPWR VPWR sky130_fd_sc_hd__fill_1
XFILLER_51_326 VGND VGND VPWR VPWR sky130_fd_sc_hd__decap_8
X_08350_ _02144_ _02145_ VGND VGND VPWR VPWR _00771_ sky130_fd_sc_hd__nor2_1
XTAP_TAPCELL_ROW_82_1655 VGND VPWR sky130_fd_sc_hd__tapvpwrvgnd_1
XTAP_TAPCELL_ROW_82_1644 VGND VPWR sky130_fd_sc_hd__tapvpwrvgnd_1
X_07301_ net1391 net564 net245 VGND VGND VPWR VPWR _00331_ sky130_fd_sc_hd__mux2_1
XFILLER_51_348 VGND VGND VPWR VPWR sky130_fd_sc_hd__fill_1
XFILLER_149_236 VGND VGND VPWR VPWR sky130_fd_sc_hd__fill_1
XFILLER_149_225 VGND VGND VPWR VPWR sky130_fd_sc_hd__fill_2
X_08281_ net532 net1606 _02092_ net805 VGND VGND VPWR VPWR _02094_ sky130_fd_sc_hd__a31o_1
XFILLER_20_713 VPWR VGND VPWR VGND sky130_ef_sc_hd__decap_12
X_07232_ net1711 _01530_ net790 VGND VGND VPWR VPWR _01533_ sky130_fd_sc_hd__o21ai_1
XFILLER_20_757 VPWR VGND VPWR VGND sky130_ef_sc_hd__decap_12
XFILLER_118_601 VPWR VGND VPWR VGND sky130_ef_sc_hd__decap_12
X_07163_ net1375 net378 net261 VGND VGND VPWR VPWR _00203_ sky130_fd_sc_hd__mux2_1
XFILLER_118_645 VGND VGND VPWR VPWR sky130_fd_sc_hd__fill_2
XFILLER_133_615 VGND VGND VPWR VPWR sky130_fd_sc_hd__fill_1
X_07094_ net1084 net358 net227 VGND VGND VPWR VPWR _00134_ sky130_fd_sc_hd__mux2_1
XTAP_TAPCELL_ROW_113_2143 VGND VPWR sky130_fd_sc_hd__tapvpwrvgnd_1
XFILLER_105_317 VPWR VGND VPWR VGND sky130_ef_sc_hd__decap_12
XFILLER_59_19 VGND VGND VPWR VPWR sky130_fd_sc_hd__fill_1
XFILLER_120_309 VGND VGND VPWR VPWR sky130_fd_sc_hd__decap_8
Xfanout203 _05582_ VGND VGND VPWR VPWR net203 sky130_fd_sc_hd__buf_2
Xfanout214 _05240_ VGND VGND VPWR VPWR net214 sky130_fd_sc_hd__clkbuf_4
Xfanout236 _01518_ VGND VGND VPWR VPWR net236 sky130_fd_sc_hd__clkbuf_8
Xfanout247 _01514_ VGND VGND VPWR VPWR net247 sky130_fd_sc_hd__buf_4
X_09804_ _03495_ _03497_ _03555_ _03556_ VGND VGND VPWR VPWR _03558_ sky130_fd_sc_hd__o211a_1
XFILLER_86_201 VGND VGND VPWR VPWR sky130_fd_sc_hd__fill_1
Xfanout225 net226 VGND VGND VPWR VPWR net225 sky130_fd_sc_hd__buf_4
XFILLER_59_426 VGND VGND VPWR VPWR sky130_fd_sc_hd__decap_4
XFILLER_140_180 VGND VGND VPWR VPWR sky130_fd_sc_hd__decap_6
X_07996_ net312 _01669_ _01861_ VGND VGND VPWR VPWR _01862_ sky130_fd_sc_hd__o21a_1
XFILLER_115_47 VGND VGND VPWR VPWR sky130_fd_sc_hd__decap_8
Xfanout258 _01510_ VGND VGND VPWR VPWR net258 sky130_fd_sc_hd__clkbuf_4
Xfanout269 _01503_ VGND VGND VPWR VPWR net269 sky130_fd_sc_hd__buf_4
X_09735_ _03488_ _03489_ _03485_ VGND VGND VPWR VPWR _03490_ sky130_fd_sc_hd__a21o_1
XPHY_EDGE_ROW_105_Left_261 VGND VGND VPWR VPWR sky130_fd_sc_hd__decap_3
X_06947_ _01476_ _01477_ _01475_ VGND VGND VPWR VPWR _01479_ sky130_fd_sc_hd__a21oi_1
XFILLER_28_813 VPWR VGND VPWR VGND sky130_ef_sc_hd__decap_12
X_09666_ _03172_ _03379_ _03378_ VGND VGND VPWR VPWR _03421_ sky130_fd_sc_hd__o21ba_1
XFILLER_131_57 VGND VGND VPWR VPWR sky130_fd_sc_hd__fill_2
X_08617_ _02179_ _02237_ _02239_ VGND VGND VPWR VPWR _02393_ sky130_fd_sc_hd__nand3_1
XFILLER_55_654 VGND VGND VPWR VPWR sky130_fd_sc_hd__fill_1
XFILLER_27_345 VGND VGND VPWR VPWR sky130_fd_sc_hd__decap_3
XFILLER_27_378 VPWR VGND VPWR VGND sky130_ef_sc_hd__decap_12
X_06878_ u_interface.fifo_data\[8\]\[31\] u_interface.fifo_data\[9\]\[31\] u_interface.fifo_data\[10\]\[31\]
+ u_interface.fifo_data\[11\]\[31\] net755 net738 VGND VGND VPWR VPWR _01422_ sky130_fd_sc_hd__mux4_1
X_09597_ _03352_ _03345_ VGND VGND VPWR VPWR _03353_ sky130_fd_sc_hd__and2b_1
XFILLER_91_39 VGND VGND VPWR VPWR sky130_fd_sc_hd__fill_1
XFILLER_15_529 VPWR VGND VPWR VGND sky130_ef_sc_hd__decap_12
XFILLER_152_6 VPWR VGND VPWR VGND sky130_ef_sc_hd__decap_12
X_08548_ _02299_ _02338_ VGND VGND VPWR VPWR _02339_ sky130_fd_sc_hd__xnor2_1
X_08479_ net526 u_interface.u_gelu_fp32.u_synth_top.s3_mult\[40\] VGND VGND VPWR VPWR
+ _02270_ sky130_fd_sc_hd__xnor2_1
XFILLER_23_573 VGND VGND VPWR VPWR sky130_fd_sc_hd__fill_2
XPHY_EDGE_ROW_114_Left_270 VGND VGND VPWR VPWR sky130_fd_sc_hd__decap_3
X_10510_ _04166_ _04168_ VGND VGND VPWR VPWR _04258_ sky130_fd_sc_hd__nand2_1
X_11490_ _05223_ _05228_ VGND VGND VPWR VPWR _05229_ sky130_fd_sc_hd__nand2_1
XFILLER_24_77 VGND VGND VPWR VPWR sky130_fd_sc_hd__decap_6
X_10441_ net195 _04189_ VGND VGND VPWR VPWR _04190_ sky130_fd_sc_hd__xnor2_1
XFILLER_136_431 VGND VGND VPWR VPWR sky130_fd_sc_hd__decap_6
XFILLER_108_122 VPWR VGND VPWR VGND sky130_ef_sc_hd__decap_12
X_10372_ _04118_ _04120_ VGND VGND VPWR VPWR _04121_ sky130_fd_sc_hd__nor2_1
X_13160_ clknet_leaf_72_clk _00170_ VGND VGND VPWR VPWR u_interface.fifo_data\[9\]\[2\]
+ sky130_fd_sc_hd__dfxtp_1
XFILLER_151_445 VGND VGND VPWR VPWR sky130_fd_sc_hd__decap_3
XFILLER_136_497 VPWR VGND VPWR VGND sky130_ef_sc_hd__decap_12
X_13091_ clknet_leaf_65_clk _00101_ VGND VGND VPWR VPWR u_interface.fifo_data\[15\]\[12\]
+ sky130_fd_sc_hd__dfxtp_1
X_12111_ _05842_ _05841_ VGND VGND VPWR VPWR _05843_ sky130_fd_sc_hd__nand2b_1
XFILLER_123_169 VGND VGND VPWR VPWR sky130_fd_sc_hd__fill_2
XFILLER_111_309 VGND VGND VPWR VPWR sky130_fd_sc_hd__fill_2
XFILLER_2_433 VPWR VGND VPWR VGND sky130_ef_sc_hd__decap_12
X_12042_ _05774_ _05773_ VGND VGND VPWR VPWR _05775_ sky130_fd_sc_hd__and2b_1
XFILLER_104_372 VGND VGND VPWR VPWR sky130_fd_sc_hd__decap_3
Xhold290 u_interface.fifo_data\[9\]\[25\] VGND VGND VPWR VPWR net1155 sky130_fd_sc_hd__dlygate4sd3_1
XFILLER_77_223 VGND VGND VPWR VPWR sky130_fd_sc_hd__fill_1
XFILLER_2_477 VPWR VGND VPWR VGND sky130_ef_sc_hd__decap_12
XFILLER_78_757 VGND VGND VPWR VPWR sky130_fd_sc_hd__decap_4
XFILLER_77_234 VGND VGND VPWR VPWR sky130_fd_sc_hd__fill_1
Xfanout770 net771 VGND VGND VPWR VPWR net770 sky130_fd_sc_hd__buf_4
XTAP_TAPCELL_ROW_144_2637 VGND VPWR sky130_fd_sc_hd__tapvpwrvgnd_1
Xfanout792 _01104_ VGND VGND VPWR VPWR net792 sky130_fd_sc_hd__clkbuf_4
Xfanout781 net782 VGND VGND VPWR VPWR net781 sky130_fd_sc_hd__buf_2
X_13993_ clknet_leaf_55_clk _00919_ VGND VGND VPWR VPWR u_interface.u_gelu_fp32.u_q16_to_fp32.s3_norm_mag\[20\]
+ sky130_fd_sc_hd__dfxtp_1
XFILLER_1_15 VPWR VGND VPWR VGND sky130_ef_sc_hd__decap_12
X_12944_ u_interface.core_valid_out _01527_ VGND VGND VPWR VPWR _06466_ sky130_fd_sc_hd__and2_1
XFILLER_18_334 VGND VGND VPWR VPWR sky130_fd_sc_hd__decap_3
X_12875_ net1619 u_interface.u_gelu_fp32.u_fp32_to_q16.s2_norm_mag\[30\] net819 VGND
+ VGND VPWR VPWR _01019_ sky130_fd_sc_hd__mux2_1
XFILLER_73_473 VGND VGND VPWR VPWR sky130_fd_sc_hd__decap_8
XFILLER_60_112 VGND VGND VPWR VPWR sky130_fd_sc_hd__decap_4
XFILLER_33_337 VGND VGND VPWR VPWR sky130_fd_sc_hd__decap_4
XFILLER_34_849 VPWR VGND VPWR VGND sky130_ef_sc_hd__decap_12
XTAP_TAPCELL_ROW_64_1352 VGND VPWR sky130_fd_sc_hd__tapvpwrvgnd_1
X_11826_ _05487_ _05560_ VGND VGND VPWR VPWR _05562_ sky130_fd_sc_hd__nand2_1
XTAP_TAPCELL_ROW_64_1363 VGND VPWR sky130_fd_sc_hd__tapvpwrvgnd_1
X_11757_ net205 _05407_ _05405_ VGND VGND VPWR VPWR _05493_ sky130_fd_sc_hd__o21a_1
XFILLER_119_409 VGND VGND VPWR VPWR sky130_fd_sc_hd__decap_3
X_10708_ _04452_ _04453_ net189 VGND VGND VPWR VPWR _04454_ sky130_fd_sc_hd__a21o_1
XFILLER_146_206 VGND VGND VPWR VPWR sky130_fd_sc_hd__fill_1
X_11688_ _05424_ _05414_ VGND VGND VPWR VPWR _05425_ sky130_fd_sc_hd__and2b_1
XFILLER_139_291 VGND VGND VPWR VPWR sky130_fd_sc_hd__decap_6
XFILLER_127_420 VPWR VGND VPWR VGND sky130_ef_sc_hd__decap_12
X_13427_ clknet_leaf_11_clk _00437_ VGND VGND VPWR VPWR u_interface.u_gelu_fp32.u_fp32_to_q16.s3_frac\[7\]
+ sky130_fd_sc_hd__dfxtp_1
X_10639_ _04382_ _04383_ _04384_ VGND VGND VPWR VPWR _04386_ sky130_fd_sc_hd__nand3_1
XFILLER_155_762 VGND VGND VPWR VPWR sky130_fd_sc_hd__decap_4
X_13358_ clknet_leaf_73_clk _00368_ VGND VGND VPWR VPWR u_interface.fifo_data\[7\]\[3\]
+ sky130_fd_sc_hd__dfxtp_1
X_12309_ _06014_ _06037_ VGND VGND VPWR VPWR _06038_ sky130_fd_sc_hd__xor2_1
XFILLER_102_309 VPWR VGND VPWR VGND sky130_ef_sc_hd__decap_12
X_13289_ clknet_leaf_75_clk _00299_ VGND VGND VPWR VPWR u_interface.fifo_data\[0\]\[31\]
+ sky130_fd_sc_hd__dfxtp_1
XFILLER_46_3 VPWR VGND VPWR VGND sky130_ef_sc_hd__decap_12
XFILLER_5_293 VPWR VGND VPWR VGND sky130_ef_sc_hd__decap_12
XPHY_EDGE_ROW_18_Right_18 VGND VGND VPWR VPWR sky130_fd_sc_hd__decap_3
X_07850_ net353 net1388 net284 VGND VGND VPWR VPWR _00611_ sky130_fd_sc_hd__mux2_1
XFILLER_68_234 VGND VGND VPWR VPWR sky130_fd_sc_hd__fill_1
X_07781_ net1090 net362 net236 VGND VGND VPWR VPWR _00542_ sky130_fd_sc_hd__mux2_1
XFILLER_56_429 VGND VGND VPWR VPWR sky130_fd_sc_hd__fill_1
X_06801_ u_interface.fifo_data\[0\]\[21\] u_interface.fifo_data\[1\]\[21\] u_interface.fifo_data\[2\]\[21\]
+ u_interface.fifo_data\[3\]\[21\] net755 net738 VGND VGND VPWR VPWR _01355_ sky130_fd_sc_hd__mux4_1
Xinput3 s_axil_araddr[0] VGND VGND VPWR VPWR net3 sky130_fd_sc_hd__clkbuf_1
X_09520_ _03151_ _03153_ _03152_ VGND VGND VPWR VPWR _03277_ sky130_fd_sc_hd__o21ba_1
X_06732_ _01289_ _01291_ _01294_ net317 VGND VGND VPWR VPWR net112 sky130_fd_sc_hd__a22o_1
X_09451_ _02695_ _02697_ _03206_ _03207_ VGND VGND VPWR VPWR _03209_ sky130_fd_sc_hd__a211o_1
X_06663_ net731 _01233_ VGND VGND VPWR VPWR _01234_ sky130_fd_sc_hd__or2_1
XFILLER_52_624 VGND VGND VPWR VPWR sky130_fd_sc_hd__decap_4
X_09382_ net472 net631 VGND VGND VPWR VPWR _03140_ sky130_fd_sc_hd__and2_1
X_06594_ net536 _01106_ u_interface.u_gelu_fp32.s1_data\[17\] VGND VGND VPWR VPWR
+ _01178_ sky130_fd_sc_hd__and3_1
X_08402_ u_interface.u_gelu_fp32.u_synth_top.s3_mult\[25\] u_interface.u_gelu_fp32.u_synth_top.s3_b\[9\]
+ VGND VGND VPWR VPWR _02193_ sky130_fd_sc_hd__and2_1
XPHY_EDGE_ROW_27_Right_27 VGND VGND VPWR VPWR sky130_fd_sc_hd__decap_3
XFILLER_36_197 VGND VGND VPWR VPWR sky130_fd_sc_hd__decap_4
XFILLER_51_167 VGND VGND VPWR VPWR sky130_fd_sc_hd__fill_1
X_08333_ net529 net1630 _02131_ net796 VGND VGND VPWR VPWR _02133_ sky130_fd_sc_hd__a31o_1
XTAP_TAPCELL_ROW_35_888 VGND VPWR sky130_fd_sc_hd__tapvpwrvgnd_1
XTAP_TAPCELL_ROW_35_899 VGND VPWR sky130_fd_sc_hd__tapvpwrvgnd_1
X_08264_ u_interface.u_gelu_fp32.s2_data\[5\] u_interface.u_gelu_fp32.s2_data\[4\]
+ _02076_ net533 VGND VGND VPWR VPWR _02081_ sky130_fd_sc_hd__o31a_1
XFILLER_32_381 VPWR VGND VPWR VGND sky130_ef_sc_hd__decap_12
XFILLER_137_206 VPWR VGND VPWR VGND sky130_ef_sc_hd__decap_12
X_07215_ net577 net1529 net259 VGND VGND VPWR VPWR _00255_ sky130_fd_sc_hd__mux2_1
X_08195_ net166 _02027_ _02028_ net162 VGND VGND VPWR VPWR _02029_ sky130_fd_sc_hd__a31oi_1
XFILLER_20_587 VGND VGND VPWR VPWR sky130_fd_sc_hd__fill_1
XFILLER_146_784 VGND VGND VPWR VPWR sky130_fd_sc_hd__fill_1
XFILLER_118_475 VGND VGND VPWR VPWR sky130_fd_sc_hd__fill_1
X_07146_ net1123 net349 net218 VGND VGND VPWR VPWR _00186_ sky130_fd_sc_hd__mux2_1
X_07077_ net1373 net568 net209 VGND VGND VPWR VPWR _00117_ sky130_fd_sc_hd__mux2_1
XTAP_TAPCELL_ROW_95_1857 VGND VPWR sky130_fd_sc_hd__tapvpwrvgnd_1
XFILLER_133_445 VGND VGND VPWR VPWR sky130_fd_sc_hd__decap_3
XPHY_EDGE_ROW_36_Right_36 VGND VGND VPWR VPWR sky130_fd_sc_hd__decap_3
XFILLER_120_117 VGND VGND VPWR VPWR sky130_fd_sc_hd__decap_8
XFILLER_101_320 VPWR VGND VPWR VGND sky130_ef_sc_hd__decap_12
XFILLER_59_223 VGND VGND VPWR VPWR sky130_fd_sc_hd__fill_1
XFILLER_75_727 VGND VGND VPWR VPWR sky130_fd_sc_hd__fill_1
XFILLER_19_55 VGND VGND VPWR VPWR sky130_fd_sc_hd__fill_1
X_07979_ net774 net993 _01851_ VGND VGND VPWR VPWR _00694_ sky130_fd_sc_hd__o21a_1
XTAP_TAPCELL_ROW_126_2356 VGND VPWR sky130_fd_sc_hd__tapvpwrvgnd_1
XTAP_TAPCELL_ROW_126_2345 VGND VPWR sky130_fd_sc_hd__tapvpwrvgnd_1
X_09718_ net500 net713 net723 net505 VGND VGND VPWR VPWR _03473_ sky130_fd_sc_hd__a22o_1
XFILLER_28_643 VGND VGND VPWR VPWR sky130_fd_sc_hd__fill_1
X_10990_ _04725_ _04733_ VGND VGND VPWR VPWR _04734_ sky130_fd_sc_hd__nand2_1
XFILLER_16_805 VGND VGND VPWR VPWR sky130_fd_sc_hd__decap_6
XFILLER_27_120 VPWR VGND VPWR VGND sky130_ef_sc_hd__decap_12
X_09649_ _03364_ net176 _03402_ _03403_ VGND VGND VPWR VPWR _03405_ sky130_fd_sc_hd__nor4_1
XPHY_EDGE_ROW_45_Right_45 VGND VGND VPWR VPWR sky130_fd_sc_hd__decap_3
XFILLER_15_326 VGND VGND VPWR VPWR sky130_fd_sc_hd__decap_8
XFILLER_16_849 VPWR VGND VPWR VGND sky130_ef_sc_hd__decap_12
XFILLER_42_112 VGND VGND VPWR VPWR sky130_fd_sc_hd__decap_6
XFILLER_150_3 VPWR VGND VPWR VGND sky130_ef_sc_hd__decap_12
XFILLER_82_292 VGND VGND VPWR VPWR sky130_fd_sc_hd__decap_8
X_12660_ u_interface.u_gelu_fp32.u_q16_to_fp32.s1_mag\[15\] net1675 net804 VGND VGND
+ VPWR VPWR _00896_ sky130_fd_sc_hd__mux2_1
XFILLER_42_145 VGND VGND VPWR VPWR sky130_fd_sc_hd__fill_1
XTAP_TAPCELL_ROW_46_1071 VGND VPWR sky130_fd_sc_hd__tapvpwrvgnd_1
X_11611_ _05348_ VGND VGND VPWR VPWR _05349_ sky130_fd_sc_hd__inv_2
XTAP_TAPCELL_ROW_104_1997 VGND VPWR sky130_fd_sc_hd__tapvpwrvgnd_1
X_12591_ u_interface.u_gelu_fp32.u_q16_to_fp32.s1_mag\[21\] u_interface.u_gelu_fp32.u_q16_to_fp32.s1_mag\[20\]
+ u_interface.u_gelu_fp32.u_q16_to_fp32.s1_mag\[23\] u_interface.u_gelu_fp32.u_q16_to_fp32.s1_mag\[22\]
+ VGND VGND VPWR VPWR _06294_ sky130_fd_sc_hd__or4_1
XTAP_TAPCELL_ROW_13_538 VGND VPWR sky130_fd_sc_hd__tapvpwrvgnd_1
XTAP_TAPCELL_ROW_13_549 VGND VPWR sky130_fd_sc_hd__tapvpwrvgnd_1
XFILLER_23_381 VGND VGND VPWR VPWR sky130_fd_sc_hd__fill_1
XFILLER_24_893 VPWR VGND VPWR VGND sky130_ef_sc_hd__decap_12
XFILLER_129_729 VGND VGND VPWR VPWR sky130_fd_sc_hd__decap_4
XFILLER_7_503 VGND VGND VPWR VPWR sky130_fd_sc_hd__fill_1
X_11542_ _05176_ _05185_ _05184_ VGND VGND VPWR VPWR _05281_ sky130_fd_sc_hd__a21boi_2
X_11473_ _05122_ _05211_ VGND VGND VPWR VPWR _05213_ sky130_fd_sc_hd__xnor2_1
XFILLER_51_75 VGND VGND VPWR VPWR sky130_fd_sc_hd__decap_3
X_13212_ clknet_leaf_37_clk _00222_ VGND VGND VPWR VPWR u_interface.fifo_data\[12\]\[22\]
+ sky130_fd_sc_hd__dfxtp_1
XFILLER_136_250 VGND VGND VPWR VPWR sky130_fd_sc_hd__fill_2
X_10424_ _04152_ _04171_ _04172_ VGND VGND VPWR VPWR _04173_ sky130_fd_sc_hd__and3_1
XFILLER_152_743 VGND VGND VPWR VPWR sky130_fd_sc_hd__fill_1
X_13143_ clknet_leaf_36_clk _00153_ VGND VGND VPWR VPWR u_interface.fifo_tlast\[14\]
+ sky130_fd_sc_hd__dfxtp_1
XPHY_EDGE_ROW_54_Right_54 VGND VGND VPWR VPWR sky130_fd_sc_hd__decap_3
XFILLER_151_253 VPWR VGND VPWR VGND sky130_ef_sc_hd__decap_12
XFILLER_140_916 VGND VGND VPWR VPWR sky130_fd_sc_hd__decap_4
XFILLER_124_445 VGND VGND VPWR VPWR sky130_fd_sc_hd__decap_4
X_10355_ _04102_ _04103_ _04084_ VGND VGND VPWR VPWR _04104_ sky130_fd_sc_hd__a21oi_1
XFILLER_3_753 VPWR VGND VPWR VGND sky130_ef_sc_hd__decap_12
XFILLER_105_681 VGND VGND VPWR VPWR sky130_fd_sc_hd__decap_8
X_13074_ clknet_leaf_67_clk _00084_ VGND VGND VPWR VPWR u_interface.fifo_data\[14\]\[27\]
+ sky130_fd_sc_hd__dfxtp_1
XFILLER_78_510 VGND VGND VPWR VPWR sky130_fd_sc_hd__decap_6
X_10286_ net587 net417 net413 net580 VGND VGND VPWR VPWR _04036_ sky130_fd_sc_hd__a22oi_1
XFILLER_3_797 VPWR VGND VPWR VGND sky130_ef_sc_hd__decap_12
X_12025_ net675 net389 VGND VGND VPWR VPWR _05758_ sky130_fd_sc_hd__nand2_1
XFILLER_76_83 VGND VGND VPWR VPWR sky130_fd_sc_hd__fill_1
XFILLER_65_237 VPWR VGND VPWR VGND sky130_ef_sc_hd__decap_12
XPHY_EDGE_ROW_63_Right_63 VGND VGND VPWR VPWR sky130_fd_sc_hd__decap_3
X_13976_ clknet_leaf_84_clk net1702 VGND VGND VPWR VPWR u_interface.u_gelu_fp32.u_q16_to_fp32.s2_mag\[21\]
+ sky130_fd_sc_hd__dfxtp_1
XFILLER_19_665 VGND VGND VPWR VPWR sky130_fd_sc_hd__decap_6
X_12927_ u_interface.in_flight_count\[2\] _06452_ _06441_ VGND VGND VPWR VPWR _06453_
+ sky130_fd_sc_hd__mux2_1
XFILLER_46_462 VPWR VGND VPWR VGND sky130_ef_sc_hd__decap_12
XFILLER_34_613 VPWR VGND VPWR VGND sky130_ef_sc_hd__decap_12
X_12858_ net952 u_interface.u_gelu_fp32.u_fp32_to_q16.s2_norm_mag\[13\] net819 VGND
+ VGND VPWR VPWR _01002_ sky130_fd_sc_hd__mux2_1
XFILLER_34_657 VPWR VGND VPWR VGND sky130_ef_sc_hd__decap_12
XFILLER_21_307 VPWR VGND VPWR VGND sky130_ef_sc_hd__decap_12
XFILLER_33_167 VGND VGND VPWR VPWR sky130_fd_sc_hd__fill_1
X_11809_ _05427_ _05459_ _05458_ VGND VGND VPWR VPWR _05545_ sky130_fd_sc_hd__a21oi_1
X_12789_ u_interface.u_gelu_fp32.u_q16_to_fp32.s3_norm_mag\[23\] _01785_ net295 VGND
+ VGND VPWR VPWR _06411_ sky130_fd_sc_hd__o21ai_1
XTAP_TAPCELL_ROW_32_847 VGND VPWR sky130_fd_sc_hd__tapvpwrvgnd_1
XFILLER_119_239 VPWR VGND VPWR VGND sky130_ef_sc_hd__decap_12
X_07000_ net1083 net326 net239 VGND VGND VPWR VPWR _00049_ sky130_fd_sc_hd__mux2_1
XPHY_EDGE_ROW_72_Right_72 VGND VGND VPWR VPWR sky130_fd_sc_hd__decap_3
XTAP_TAPCELL_ROW_77_1565 VGND VPWR sky130_fd_sc_hd__tapvpwrvgnd_1
XFILLER_142_253 VGND VGND VPWR VPWR sky130_fd_sc_hd__fill_1
XFILLER_115_467 VGND VGND VPWR VPWR sky130_fd_sc_hd__fill_1
XTAP_TAPCELL_ROW_110_2102 VGND VPWR sky130_fd_sc_hd__tapvpwrvgnd_1
X_08951_ _02602_ _02709_ VGND VGND VPWR VPWR _02710_ sky130_fd_sc_hd__and2_1
XFILLER_103_629 VGND VGND VPWR VPWR sky130_fd_sc_hd__decap_4
XFILLER_69_510 VPWR VGND VPWR VGND sky130_ef_sc_hd__decap_12
X_07902_ net817 net90 net97 _01805_ VGND VGND VPWR VPWR _01806_ sky130_fd_sc_hd__or4_1
XFILLER_130_459 VPWR VGND VPWR VGND sky130_ef_sc_hd__decap_12
X_08882_ _02637_ _02640_ VGND VGND VPWR VPWR _02641_ sky130_fd_sc_hd__xnor2_1
XFILLER_102_139 VGND VGND VPWR VPWR sky130_fd_sc_hd__fill_1
XTAP_TAPCELL_ROW_90_1776 VGND VPWR sky130_fd_sc_hd__tapvpwrvgnd_1
XFILLER_69_543 VPWR VGND VPWR VGND sky130_ef_sc_hd__decap_12
XFILLER_111_673 VGND VGND VPWR VPWR sky130_fd_sc_hd__fill_2
X_07833_ net1170 net561 net229 VGND VGND VPWR VPWR _00594_ sky130_fd_sc_hd__mux2_1
XFILLER_96_384 VGND VGND VPWR VPWR sky130_fd_sc_hd__fill_1
XFILLER_84_524 VGND VGND VPWR VPWR sky130_fd_sc_hd__decap_8
XPHY_EDGE_ROW_81_Right_81 VGND VGND VPWR VPWR sky130_fd_sc_hd__decap_3
XFILLER_69_598 VGND VGND VPWR VPWR sky130_fd_sc_hd__fill_1
XTAP_TAPCELL_ROW_108_2064 VGND VPWR sky130_fd_sc_hd__tapvpwrvgnd_1
X_07764_ u_interface.u_gelu_fp32.u_q16_to_fp32.s3_exp\[4\] u_interface.u_gelu_fp32.u_q16_to_fp32.s3_exp\[5\]
+ _01798_ VGND VGND VPWR VPWR _01803_ sky130_fd_sc_hd__and3_1
X_06715_ _01278_ _01279_ net736 VGND VGND VPWR VPWR _01280_ sky130_fd_sc_hd__mux2_1
X_09503_ _03258_ _03259_ _03199_ _03201_ VGND VGND VPWR VPWR _03260_ sky130_fd_sc_hd__a211oi_1
XFILLER_112_26 VGND VGND VPWR VPWR sky130_fd_sc_hd__fill_2
X_07695_ net386 u_interface.u_gelu_fp32.u_synth_top.s1_hits\[6\] _01428_ VGND VGND
+ VPWR VPWR _01762_ sky130_fd_sc_hd__or3_1
X_09434_ net498 net680 _03190_ _03191_ VGND VGND VPWR VPWR _03192_ sky130_fd_sc_hd__a22o_1
XFILLER_52_421 VPWR VGND VPWR VGND sky130_ef_sc_hd__decap_12
X_06646_ net729 _01218_ VGND VGND VPWR VPWR _01219_ sky130_fd_sc_hd__or2_1
XTAP_TAPCELL_ROW_121_2275 VGND VPWR sky130_fd_sc_hd__tapvpwrvgnd_1
XTAP_TAPCELL_ROW_121_2264 VGND VPWR sky130_fd_sc_hd__tapvpwrvgnd_1
XFILLER_52_454 VPWR VGND VPWR VGND sky130_ef_sc_hd__decap_12
XFILLER_24_156 VGND VGND VPWR VPWR sky130_fd_sc_hd__decap_4
X_09365_ _03112_ _03117_ _03119_ _03120_ _03122_ VGND VGND VPWR VPWR _03124_ sky130_fd_sc_hd__o2111a_1
X_06577_ _01151_ _01159_ _01167_ VGND VGND VPWR VPWR _01168_ sky130_fd_sc_hd__or3_1
XFILLER_12_329 VGND VGND VPWR VPWR sky130_fd_sc_hd__fill_1
XFILLER_21_841 VPWR VGND VPWR VGND sky130_ef_sc_hd__decap_12
X_09296_ _03051_ _03053_ _03054_ VGND VGND VPWR VPWR _03055_ sky130_fd_sc_hd__nand3_1
X_08316_ net530 _02119_ net1628 VGND VGND VPWR VPWR _02120_ sky130_fd_sc_hd__a21oi_1
X_08247_ net782 u_interface.u_gelu_fp32.s2_data\[0\] VGND VGND VPWR VPWR _00744_ sky130_fd_sc_hd__and2_1
XPHY_EDGE_ROW_90_Right_90 VGND VGND VPWR VPWR sky130_fd_sc_hd__decap_3
XFILLER_137_12 VGND VGND VPWR VPWR sky130_fd_sc_hd__fill_1
XFILLER_137_45 VGND VGND VPWR VPWR sky130_fd_sc_hd__fill_1
X_08178_ u_interface.u_gelu_fp32.u_fp32_to_q16.s3_mag\[21\] _01887_ VGND VGND VPWR
+ VPWR _02014_ sky130_fd_sc_hd__xnor2_1
XFILLER_134_765 VGND VGND VPWR VPWR sky130_fd_sc_hd__decap_3
X_07129_ net1132 net383 net219 VGND VGND VPWR VPWR _00169_ sky130_fd_sc_hd__mux2_1
XFILLER_133_264 VGND VGND VPWR VPWR sky130_fd_sc_hd__fill_1
X_10140_ _03889_ _03890_ VGND VGND VPWR VPWR _03891_ sky130_fd_sc_hd__and2b_1
XFILLER_0_701 VPWR VGND VPWR VGND sky130_ef_sc_hd__decap_12
X_10071_ net620 net450 _03671_ _03670_ VGND VGND VPWR VPWR _03823_ sky130_fd_sc_hd__a31o_1
XFILLER_153_55 VGND VGND VPWR VPWR sky130_fd_sc_hd__fill_1
XFILLER_153_77 VGND VGND VPWR VPWR sky130_fd_sc_hd__decap_8
X_13830_ clknet_leaf_79_clk _00840_ VGND VGND VPWR VPWR u_interface.u_gelu_fp32.u_synth_top.s3_mult\[48\]
+ sky130_fd_sc_hd__dfxtp_1
X_10973_ _04714_ _04715_ _04589_ _04592_ VGND VGND VPWR VPWR _04717_ sky130_fd_sc_hd__o211a_1
XTAP_TAPCELL_ROW_48_1111 VGND VPWR sky130_fd_sc_hd__tapvpwrvgnd_1
XTAP_TAPCELL_ROW_48_1100 VGND VPWR sky130_fd_sc_hd__tapvpwrvgnd_1
X_13761_ clknet_leaf_82_clk _00771_ VGND VGND VPWR VPWR u_interface.u_gelu_fp32.u_q16_to_fp32.s1_mag\[27\]
+ sky130_fd_sc_hd__dfxtp_1
XFILLER_16_613 VPWR VGND VPWR VGND sky130_ef_sc_hd__decap_12
XTAP_TAPCELL_ROW_18_619 VGND VPWR sky130_fd_sc_hd__tapvpwrvgnd_1
XFILLER_71_741 VGND VGND VPWR VPWR sky130_fd_sc_hd__decap_8
X_12712_ u_interface.u_gelu_fp32.u_q16_to_fp32.s2_mag\[23\] u_interface.u_gelu_fp32.u_q16_to_fp32.s2_mag\[22\]
+ u_interface.u_gelu_fp32.u_q16_to_fp32.s2_mag\[21\] u_interface.u_gelu_fp32.u_q16_to_fp32.s2_mag\[20\]
+ net336 net332 VGND VGND VPWR VPWR _06367_ sky130_fd_sc_hd__mux4_1
XFILLER_16_657 VPWR VGND VPWR VGND sky130_ef_sc_hd__decap_12
X_13692_ clknet_leaf_13_clk _00702_ VGND VGND VPWR VPWR u_interface.u_gelu_fp32.u_fp32_to_q16.s3_frac\[28\]
+ sky130_fd_sc_hd__dfxtp_1
XFILLER_70_251 VGND VGND VPWR VPWR sky130_fd_sc_hd__fill_1
XFILLER_15_167 VGND VGND VPWR VPWR sky130_fd_sc_hd__fill_1
X_12643_ net825 net985 _06339_ VGND VGND VPWR VPWR _00879_ sky130_fd_sc_hd__a21o_1
XTAP_TAPCELL_ROW_61_1311 VGND VPWR sky130_fd_sc_hd__tapvpwrvgnd_1
XFILLER_30_104 VGND VGND VPWR VPWR sky130_fd_sc_hd__decap_8
XFILLER_30_126 VGND VGND VPWR VPWR sky130_fd_sc_hd__decap_8
XTAP_TAPCELL_ROW_139_2558 VGND VPWR sky130_fd_sc_hd__tapvpwrvgnd_1
XFILLER_62_85 VPWR VGND VPWR VGND sky130_ef_sc_hd__decap_12
X_12574_ net773 u_interface.u_gelu_fp32.u_synth_top.s2_b\[18\] VGND VGND VPWR VPWR
+ _00872_ sky130_fd_sc_hd__and2_1
XFILLER_129_559 VGND VGND VPWR VPWR sky130_fd_sc_hd__fill_1
XFILLER_129_537 VGND VGND VPWR VPWR sky130_fd_sc_hd__decap_8
XFILLER_11_373 VGND VGND VPWR VPWR sky130_fd_sc_hd__decap_4
X_11525_ _05255_ _05261_ _05262_ VGND VGND VPWR VPWR _05264_ sky130_fd_sc_hd__and3_1
XFILLER_8_867 VGND VGND VPWR VPWR sky130_fd_sc_hd__fill_1
XFILLER_7_69 VPWR VGND VPWR VGND sky130_ef_sc_hd__decap_12
XTAP_TAPCELL_ROW_152_2769 VGND VPWR sky130_fd_sc_hd__tapvpwrvgnd_1
Xwire286 _01442_ VGND VGND VPWR VPWR net286 sky130_fd_sc_hd__clkbuf_1
X_11456_ _05063_ _05097_ _05096_ VGND VGND VPWR VPWR _05196_ sky130_fd_sc_hd__a21oi_2
X_10407_ net644 net445 net440 net636 VGND VGND VPWR VPWR _04156_ sky130_fd_sc_hd__a22o_1
XTAP_TAPCELL_ROW_59_1284 VGND VPWR sky130_fd_sc_hd__tapvpwrvgnd_1
XTAP_TAPCELL_ROW_59_1273 VGND VPWR sky130_fd_sc_hd__tapvpwrvgnd_1
X_11387_ net184 _05126_ VGND VGND VPWR VPWR _05127_ sky130_fd_sc_hd__xor2_1
XFILLER_152_562 VGND VGND VPWR VPWR sky130_fd_sc_hd__decap_8
XFILLER_124_253 VGND VGND VPWR VPWR sky130_fd_sc_hd__fill_1
X_13126_ clknet_leaf_49_clk _00136_ VGND VGND VPWR VPWR u_interface.fifo_data\[2\]\[15\]
+ sky130_fd_sc_hd__dfxtp_1
X_10338_ _03982_ _03984_ VGND VGND VPWR VPWR _04087_ sky130_fd_sc_hd__nand2_1
XFILLER_3_561 VPWR VGND VPWR VGND sky130_ef_sc_hd__decap_12
X_13057_ clknet_leaf_38_clk _00067_ VGND VGND VPWR VPWR u_interface.fifo_data\[14\]\[10\]
+ sky130_fd_sc_hd__dfxtp_1
XFILLER_112_437 VGND VGND VPWR VPWR sky130_fd_sc_hd__fill_2
XFILLER_140_779 VGND VGND VPWR VPWR sky130_fd_sc_hd__fill_1
X_10269_ net453 net653 net661 net457 VGND VGND VPWR VPWR _04019_ sky130_fd_sc_hd__a22o_1
XTAP_TAPCELL_ROW_72_1495 VGND VPWR sky130_fd_sc_hd__tapvpwrvgnd_1
XTAP_TAPCELL_ROW_72_1484 VGND VPWR sky130_fd_sc_hd__tapvpwrvgnd_1
X_12008_ net701 net407 _05680_ _05678_ VGND VGND VPWR VPWR _05741_ sky130_fd_sc_hd__a31o_1
XFILLER_66_568 VGND VGND VPWR VPWR sky130_fd_sc_hd__decap_4
X_13959_ clknet_leaf_59_clk net1674 VGND VGND VPWR VPWR u_interface.u_gelu_fp32.u_q16_to_fp32.s2_mag\[4\]
+ sky130_fd_sc_hd__dfxtp_1
XTAP_TAPCELL_ROW_37_928 VGND VPWR sky130_fd_sc_hd__tapvpwrvgnd_1
X_06500_ u_interface.core_valid_out VGND VGND VPWR VPWR _01100_ sky130_fd_sc_hd__inv_2
X_07480_ _01607_ _01613_ net311 VGND VGND VPWR VPWR _01614_ sky130_fd_sc_hd__mux2_1
XFILLER_148_813 VGND VGND VPWR VPWR sky130_fd_sc_hd__decap_8
X_09150_ _02857_ _02907_ _02908_ VGND VGND VPWR VPWR _02909_ sky130_fd_sc_hd__or3_1
XFILLER_147_301 VGND VGND VPWR VPWR sky130_fd_sc_hd__fill_2
XFILLER_21_137 VGND VGND VPWR VPWR sky130_fd_sc_hd__decap_8
X_09081_ _02837_ _02838_ _02836_ VGND VGND VPWR VPWR _02840_ sky130_fd_sc_hd__o21bai_1
X_08101_ _01948_ _01949_ VGND VGND VPWR VPWR _01950_ sky130_fd_sc_hd__xnor2_1
XTAP_TAPCELL_ROW_79_1605 VGND VPWR sky130_fd_sc_hd__tapvpwrvgnd_1
X_08032_ u_interface.u_gelu_fp32.u_fp32_to_q16.s3_mag\[23\] _01888_ VGND VGND VPWR
+ VPWR _01889_ sky130_fd_sc_hd__and2_1
XFILLER_30_693 VGND VGND VPWR VPWR sky130_fd_sc_hd__decap_6
Xinput72 s_axil_wstrb[0] VGND VGND VPWR VPWR net72 sky130_fd_sc_hd__clkbuf_1
Xinput61 s_axil_awaddr[3] VGND VGND VPWR VPWR net61 sky130_fd_sc_hd__clkbuf_1
Xinput50 s_axil_awaddr[22] VGND VGND VPWR VPWR net50 sky130_fd_sc_hd__dlymetal6s2s_1
XFILLER_128_570 VGND VGND VPWR VPWR sky130_fd_sc_hd__decap_3
Xhold801 u_interface.u_gelu_fp32.s2_data\[7\] VGND VGND VPWR VPWR net1666 sky130_fd_sc_hd__dlygate4sd3_1
Xhold812 u_interface.u_gelu_fp32.u_q16_to_fp32.s2_mag\[18\] VGND VGND VPWR VPWR net1677
+ sky130_fd_sc_hd__dlygate4sd3_1
Xhold845 net146 VGND VGND VPWR VPWR net1710 sky130_fd_sc_hd__dlygate4sd3_1
Xinput83 s_axis_tdata[18] VGND VGND VPWR VPWR net83 sky130_fd_sc_hd__clkbuf_1
Xinput94 s_axis_tdata[28] VGND VGND VPWR VPWR net94 sky130_fd_sc_hd__clkbuf_1
XFILLER_116_765 VGND VGND VPWR VPWR sky130_fd_sc_hd__decap_8
XTAP_TAPCELL_ROW_92_1805 VGND VPWR sky130_fd_sc_hd__tapvpwrvgnd_1
Xhold823 u_interface.u_gelu_fp32.u_q16_to_fp32.s2_mag\[2\] VGND VGND VPWR VPWR net1688
+ sky130_fd_sc_hd__dlygate4sd3_1
Xhold834 u_interface.u_gelu_fp32.u_q16_to_fp32.s2_mag\[17\] VGND VGND VPWR VPWR net1699
+ sky130_fd_sc_hd__dlygate4sd3_1
XFILLER_131_724 VGND VGND VPWR VPWR sky130_fd_sc_hd__decap_4
Xhold867 u_interface.u_gelu_fp32.u_fp32_to_q16.s3_mag\[17\] VGND VGND VPWR VPWR net1732
+ sky130_fd_sc_hd__dlygate4sd3_1
XFILLER_107_48 VGND VGND VPWR VPWR sky130_fd_sc_hd__decap_8
Xhold889 _00506_ VGND VGND VPWR VPWR net1754 sky130_fd_sc_hd__dlygate4sd3_1
X_09983_ _03734_ _03735_ _03632_ VGND VGND VPWR VPWR _03736_ sky130_fd_sc_hd__a21oi_1
Xhold878 u_interface.u_gelu_fp32.u_synth_top.s2_b\[5\] VGND VGND VPWR VPWR net1743
+ sky130_fd_sc_hd__dlygate4sd3_1
XFILLER_89_638 VGND VGND VPWR VPWR sky130_fd_sc_hd__decap_4
Xhold856 _00908_ VGND VGND VPWR VPWR net1721 sky130_fd_sc_hd__dlygate4sd3_1
XFILLER_130_234 VGND VGND VPWR VPWR sky130_fd_sc_hd__fill_1
X_08934_ _02691_ _02692_ _02546_ _02548_ VGND VGND VPWR VPWR _02693_ sky130_fd_sc_hd__a211oi_1
XFILLER_103_459 VGND VGND VPWR VPWR sky130_fd_sc_hd__decap_3
XFILLER_103_426 VGND VGND VPWR VPWR sky130_fd_sc_hd__decap_6
X_08865_ _02622_ _02623_ VGND VGND VPWR VPWR _02624_ sky130_fd_sc_hd__nand2_1
XFILLER_84_321 VPWR VGND VPWR VGND sky130_ef_sc_hd__decap_12
X_08796_ _02472_ _02554_ VGND VGND VPWR VPWR _02555_ sky130_fd_sc_hd__or2_1
XTAP_TAPCELL_ROW_123_2304 VGND VPWR sky130_fd_sc_hd__tapvpwrvgnd_1
X_07816_ net1226 net356 net231 VGND VGND VPWR VPWR _00577_ sky130_fd_sc_hd__mux2_1
X_07747_ u_interface.u_gelu_fp32.u_q16_to_fp32.s3_exp\[0\] _01790_ VGND VGND VPWR
+ VPWR _01791_ sky130_fd_sc_hd__and2_1
XFILLER_84_376 VPWR VGND VPWR VGND sky130_ef_sc_hd__decap_12
XFILLER_84_365 VGND VGND VPWR VPWR sky130_fd_sc_hd__decap_6
XPHY_EDGE_ROW_154_Right_154 VGND VGND VPWR VPWR sky130_fd_sc_hd__decap_3
XFILLER_53_741 VGND VGND VPWR VPWR sky130_fd_sc_hd__fill_1
XFILLER_37_281 VGND VGND VPWR VPWR sky130_fd_sc_hd__decap_3
X_07678_ u_interface.u_gelu_fp32.u_synth_top.s1_hits\[18\] u_interface.u_gelu_fp32.u_synth_top.s1_hits\[2\]
+ _01187_ VGND VGND VPWR VPWR _01754_ sky130_fd_sc_hd__or3_1
XPHY_EDGE_ROW_0_Right_0 VGND VGND VPWR VPWR sky130_fd_sc_hd__decap_3
X_09417_ net500 net505 net689 net697 VGND VGND VPWR VPWR _03175_ sky130_fd_sc_hd__and4_1
X_06629_ u_interface.fifo_data\[8\]\[0\] u_interface.fifo_data\[9\]\[0\] u_interface.fifo_data\[10\]\[0\]
+ u_interface.fifo_data\[11\]\[0\] net756 net739 VGND VGND VPWR VPWR _01204_ sky130_fd_sc_hd__mux4_1
XFILLER_25_487 VPWR VGND VPWR VGND sky130_ef_sc_hd__decap_12
XFILLER_138_301 VGND VGND VPWR VPWR sky130_fd_sc_hd__decap_6
X_09348_ _03098_ _03105_ _03106_ VGND VGND VPWR VPWR _03107_ sky130_fd_sc_hd__o21a_1
XTAP_TAPCELL_ROW_101_1956 VGND VPWR sky130_fd_sc_hd__tapvpwrvgnd_1
XTAP_TAPCELL_ROW_101_1945 VGND VPWR sky130_fd_sc_hd__tapvpwrvgnd_1
XTAP_TAPCELL_ROW_43_1030 VGND VPWR sky130_fd_sc_hd__tapvpwrvgnd_1
XFILLER_9_609 VGND VGND VPWR VPWR sky130_fd_sc_hd__decap_6
XFILLER_21_671 VGND VGND VPWR VPWR sky130_fd_sc_hd__fill_1
XTAP_TAPCELL_ROW_23_699 VGND VPWR sky130_fd_sc_hd__tapvpwrvgnd_1
X_09279_ _02993_ _03036_ _03037_ VGND VGND VPWR VPWR _03038_ sky130_fd_sc_hd__and3_1
X_11310_ net677 net686 net430 net425 VGND VGND VPWR VPWR _05051_ sky130_fd_sc_hd__nand4_1
XFILLER_154_838 VGND VGND VPWR VPWR sky130_fd_sc_hd__decap_8
XTAP_TAPCELL_ROW_134_2477 VGND VPWR sky130_fd_sc_hd__tapvpwrvgnd_1
XFILLER_126_529 VGND VGND VPWR VPWR sky130_fd_sc_hd__decap_3
XFILLER_113_3 VGND VGND VPWR VPWR sky130_fd_sc_hd__decap_3
X_12290_ _05815_ _06018_ VGND VGND VPWR VPWR _06019_ sky130_fd_sc_hd__xnor2_4
XFILLER_134_540 VPWR VGND VPWR VGND sky130_ef_sc_hd__decap_12
X_11241_ _04979_ _04982_ VGND VGND VPWR VPWR _04983_ sky130_fd_sc_hd__xnor2_1
X_11172_ _04906_ _04912_ _04904_ VGND VGND VPWR VPWR _04914_ sky130_fd_sc_hd__o21a_1
X_10123_ _03866_ _03871_ _03872_ VGND VGND VPWR VPWR _03874_ sky130_fd_sc_hd__nand3_1
XFILLER_121_245 VGND VGND VPWR VPWR sky130_fd_sc_hd__fill_2
X_10054_ net482 net707 VGND VGND VPWR VPWR _03806_ sky130_fd_sc_hd__nand2_1
XFILLER_87_181 VPWR VGND VPWR VGND sky130_ef_sc_hd__decap_12
XTAP_TAPCELL_ROW_54_1192 VGND VPWR sky130_fd_sc_hd__tapvpwrvgnd_1
X_13813_ clknet_leaf_87_clk _00823_ VGND VGND VPWR VPWR u_interface.u_gelu_fp32.u_synth_top.s3_mult\[31\]
+ sky130_fd_sc_hd__dfxtp_1
XFILLER_63_527 VGND VGND VPWR VPWR sky130_fd_sc_hd__fill_1
XFILLER_63_505 VGND VGND VPWR VPWR sky130_fd_sc_hd__fill_2
XTAP_TAPCELL_ROW_3_380 VGND VPWR sky130_fd_sc_hd__tapvpwrvgnd_1
XFILLER_35_207 VPWR VGND VPWR VGND sky130_ef_sc_hd__decap_12
XFILLER_35_229 VGND VGND VPWR VPWR sky130_fd_sc_hd__fill_1
XPHY_EDGE_ROW_121_Right_121 VGND VGND VPWR VPWR sky130_fd_sc_hd__decap_3
XFILLER_91_858 VGND VGND VPWR VPWR sky130_fd_sc_hd__decap_6
XTAP_TAPCELL_ROW_3_391 VGND VPWR sky130_fd_sc_hd__tapvpwrvgnd_1
XFILLER_16_421 VGND VGND VPWR VPWR sky130_fd_sc_hd__fill_1
X_13744_ clknet_leaf_59_clk _00754_ VGND VGND VPWR VPWR u_interface.u_gelu_fp32.u_q16_to_fp32.s1_mag\[10\]
+ sky130_fd_sc_hd__dfxtp_1
X_10956_ net460 net712 _04582_ _04581_ VGND VGND VPWR VPWR _04700_ sky130_fd_sc_hd__a31oi_2
X_13675_ clknet_leaf_11_clk _00685_ VGND VGND VPWR VPWR u_interface.u_gelu_fp32.u_fp32_to_q16.s3_frac\[11\]
+ sky130_fd_sc_hd__dfxtp_1
XFILLER_71_582 VGND VGND VPWR VPWR sky130_fd_sc_hd__fill_2
X_10887_ _04628_ _04631_ VGND VGND VPWR VPWR _04632_ sky130_fd_sc_hd__xnor2_1
X_12626_ u_interface.u_gelu_fp32.u_q16_to_fp32.s1_is_zero net823 VGND VGND VPWR VPWR
+ _06329_ sky130_fd_sc_hd__nor2_2
XFILLER_129_312 VPWR VGND VPWR VGND sky130_ef_sc_hd__decap_12
X_12557_ net783 u_interface.u_gelu_fp32.u_synth_top.s2_b\[1\] VGND VGND VPWR VPWR
+ _00855_ sky130_fd_sc_hd__and2_1
XFILLER_11_181 VPWR VGND VPWR VGND sky130_ef_sc_hd__decap_12
XFILLER_12_693 VGND VGND VPWR VPWR sky130_fd_sc_hd__decap_6
Xhold108 u_interface.u_gelu_fp32.u_fp32_to_q16.s3_frac\[19\] VGND VGND VPWR VPWR net973
+ sky130_fd_sc_hd__dlygate4sd3_1
X_12488_ _06164_ _06167_ _06213_ VGND VGND VPWR VPWR _06214_ sky130_fd_sc_hd__nand3_1
X_11508_ _05244_ _05245_ _05246_ VGND VGND VPWR VPWR _05247_ sky130_fd_sc_hd__a21o_1
Xhold119 u_interface.fifo_data\[1\]\[22\] VGND VGND VPWR VPWR net984 sky130_fd_sc_hd__dlygate4sd3_1
XTAP_TAPCELL_ROW_74_1513 VGND VPWR sky130_fd_sc_hd__tapvpwrvgnd_1
X_11439_ net617 net389 VGND VGND VPWR VPWR _05179_ sky130_fd_sc_hd__nand2_1
XFILLER_98_402 VPWR VGND VPWR VGND sky130_ef_sc_hd__decap_12
X_14158_ clknet_leaf_49_clk _01084_ VGND VGND VPWR VPWR u_interface.fifo_data\[1\]\[18\]
+ sky130_fd_sc_hd__dfxtp_1
XTAP_TAPCELL_ROW_74_1524 VGND VPWR sky130_fd_sc_hd__tapvpwrvgnd_1
X_13109_ clknet_leaf_68_clk _00119_ VGND VGND VPWR VPWR u_interface.fifo_data\[15\]\[30\]
+ sky130_fd_sc_hd__dfxtp_1
XFILLER_4_881 VPWR VGND VPWR VGND sky130_ef_sc_hd__decap_12
X_14089_ clknet_leaf_16_clk net1303 VGND VGND VPWR VPWR u_interface.u_gelu_fp32.u_fp32_to_q16.s2_norm_mag\[26\]
+ sky130_fd_sc_hd__dfxtp_1
X_06980_ _01502_ _01504_ VGND VGND VPWR VPWR _01505_ sky130_fd_sc_hd__nor2_2
XFILLER_112_245 VGND VGND VPWR VPWR sky130_fd_sc_hd__decap_6
XFILLER_79_660 VGND VGND VPWR VPWR sky130_fd_sc_hd__decap_4
XFILLER_3_391 VGND VGND VPWR VPWR sky130_fd_sc_hd__fill_1
XFILLER_140_598 VGND VGND VPWR VPWR sky130_fd_sc_hd__fill_2
XFILLER_140_587 VGND VGND VPWR VPWR sky130_fd_sc_hd__fill_1
XFILLER_66_321 VGND VGND VPWR VPWR sky130_fd_sc_hd__fill_1
XFILLER_78_192 VGND VGND VPWR VPWR sky130_fd_sc_hd__decap_4
XFILLER_78_181 VGND VGND VPWR VPWR sky130_fd_sc_hd__decap_6
XFILLER_66_343 VPWR VGND VPWR VGND sky130_ef_sc_hd__decap_12
X_08650_ net152 _02417_ net793 VGND VGND VPWR VPWR _00799_ sky130_fd_sc_hd__a21oi_1
XTAP_TAPCELL_ROW_105_2023 VGND VPWR sky130_fd_sc_hd__tapvpwrvgnd_1
XTAP_TAPCELL_ROW_105_2012 VGND VPWR sky130_fd_sc_hd__tapvpwrvgnd_1
XFILLER_93_162 VGND VGND VPWR VPWR sky130_fd_sc_hd__fill_1
X_07601_ net307 net298 VGND VGND VPWR VPWR _01697_ sky130_fd_sc_hd__nand2_1
XFILLER_81_313 VGND VGND VPWR VPWR sky130_fd_sc_hd__decap_6
XFILLER_66_376 VGND VGND VPWR VPWR sky130_fd_sc_hd__decap_3
XFILLER_66_365 VGND VGND VPWR VPWR sky130_fd_sc_hd__fill_2
XFILLER_54_527 VGND VGND VPWR VPWR sky130_fd_sc_hd__decap_4
X_08581_ net154 _02368_ net824 VGND VGND VPWR VPWR _00779_ sky130_fd_sc_hd__a21oi_1
XFILLER_82_858 VGND VGND VPWR VPWR sky130_fd_sc_hd__fill_2
XFILLER_82_847 VGND VGND VPWR VPWR sky130_fd_sc_hd__fill_2
XFILLER_19_281 VGND VGND VPWR VPWR sky130_fd_sc_hd__decap_4
X_07532_ _01658_ _01659_ net310 VGND VGND VPWR VPWR _01660_ sky130_fd_sc_hd__mux2_1
X_07463_ net552 _01597_ VGND VGND VPWR VPWR _01598_ sky130_fd_sc_hd__and2_1
XTAP_TAPCELL_ROW_85_1697 VGND VPWR sky130_fd_sc_hd__tapvpwrvgnd_1
XFILLER_50_744 VGND VGND VPWR VPWR sky130_fd_sc_hd__decap_3
XFILLER_35_785 VPWR VGND VPWR VGND sky130_ef_sc_hd__decap_12
X_09202_ _02955_ _02957_ _02956_ VGND VGND VPWR VPWR _02961_ sky130_fd_sc_hd__a21o_1
X_09133_ net647 net516 net519 net655 VGND VGND VPWR VPWR _02892_ sky130_fd_sc_hd__a22oi_1
X_07394_ net1311 net569 net238 VGND VGND VPWR VPWR _00424_ sky130_fd_sc_hd__mux2_1
XFILLER_147_142 VGND VGND VPWR VPWR sky130_fd_sc_hd__decap_4
XTAP_TAPCELL_ROW_20_658 VGND VPWR sky130_fd_sc_hd__tapvpwrvgnd_1
X_09064_ net590 net597 net487 net492 VGND VGND VPWR VPWR _02823_ sky130_fd_sc_hd__nand4_1
XFILLER_108_529 VGND VGND VPWR VPWR sky130_fd_sc_hd__decap_3
XFILLER_135_337 VGND VGND VPWR VPWR sky130_fd_sc_hd__decap_8
Xhold620 u_interface.fifo_tuser\[3\] VGND VGND VPWR VPWR net1485 sky130_fd_sc_hd__dlygate4sd3_1
X_08015_ net816 u_interface.u_gelu_fp32.u_fp32_to_q16.s3_is_zero VGND VGND VPWR VPWR
+ _01872_ sky130_fd_sc_hd__or2_1
XTAP_TAPCELL_ROW_116_2196 VGND VPWR sky130_fd_sc_hd__tapvpwrvgnd_1
XTAP_TAPCELL_ROW_116_2185 VGND VPWR sky130_fd_sc_hd__tapvpwrvgnd_1
Xhold642 u_interface.fifo_data\[8\]\[7\] VGND VGND VPWR VPWR net1507 sky130_fd_sc_hd__dlygate4sd3_1
Xhold631 u_interface.fifo_data\[3\]\[4\] VGND VGND VPWR VPWR net1496 sky130_fd_sc_hd__dlygate4sd3_1
Xhold653 u_interface.fifo_data\[3\]\[3\] VGND VGND VPWR VPWR net1518 sky130_fd_sc_hd__dlygate4sd3_1
XFILLER_131_543 VPWR VGND VPWR VGND sky130_ef_sc_hd__decap_12
Xhold664 u_interface.fifo_data\[11\]\[23\] VGND VGND VPWR VPWR net1529 sky130_fd_sc_hd__dlygate4sd3_1
XFILLER_104_735 VGND VGND VPWR VPWR sky130_fd_sc_hd__decap_3
Xhold675 u_interface.u_gelu_fp32.u_q16_to_fp32.s2_exp\[1\] VGND VGND VPWR VPWR net1540
+ sky130_fd_sc_hd__dlygate4sd3_1
Xhold686 _00936_ VGND VGND VPWR VPWR net1551 sky130_fd_sc_hd__dlygate4sd3_1
XFILLER_89_435 VGND VGND VPWR VPWR sky130_fd_sc_hd__decap_6
Xhold697 u_interface.u_gelu_fp32.u_q16_to_fp32.s3_norm_mag\[0\] VGND VGND VPWR VPWR
+ net1562 sky130_fd_sc_hd__dlygate4sd3_1
XFILLER_1_317 VPWR VGND VPWR VGND sky130_ef_sc_hd__decap_12
X_09966_ _03717_ _03718_ _03576_ VGND VGND VPWR VPWR _03719_ sky130_fd_sc_hd__a21o_1
X_08917_ _02439_ _02674_ VGND VGND VPWR VPWR _02676_ sky130_fd_sc_hd__xnor2_1
X_09897_ _03549_ _03551_ _03646_ _03647_ VGND VGND VPWR VPWR _03650_ sky130_fd_sc_hd__a211oi_1
X_08848_ _02603_ _02606_ VGND VGND VPWR VPWR _02607_ sky130_fd_sc_hd__xnor2_1
XFILLER_58_866 VGND VGND VPWR VPWR sky130_fd_sc_hd__fill_2
XFILLER_84_151 VPWR VGND VPWR VGND sky130_ef_sc_hd__decap_12
X_08779_ net646 net489 net654 net494 VGND VGND VPWR VPWR _02538_ sky130_fd_sc_hd__a22o_1
XFILLER_84_195 VGND VGND VPWR VPWR sky130_fd_sc_hd__fill_1
XFILLER_73_847 VGND VGND VPWR VPWR sky130_fd_sc_hd__decap_8
XFILLER_27_55 VGND VGND VPWR VPWR sky130_fd_sc_hd__fill_1
X_10810_ _04442_ _04554_ VGND VGND VPWR VPWR _04556_ sky130_fd_sc_hd__nand2_1
XFILLER_72_357 VGND VGND VPWR VPWR sky130_fd_sc_hd__decap_6
X_11790_ _05524_ _05525_ VGND VGND VPWR VPWR _05526_ sky130_fd_sc_hd__nor2_1
X_10741_ _04390_ _04392_ _04483_ net187 VGND VGND VPWR VPWR _04487_ sky130_fd_sc_hd__a211oi_4
XFILLER_53_593 VGND VGND VPWR VPWR sky130_fd_sc_hd__fill_1
XFILLER_41_722 VGND VGND VPWR VPWR sky130_fd_sc_hd__decap_6
X_13460_ clknet_leaf_60_clk _00470_ VGND VGND VPWR VPWR u_interface.u_gelu_fp32.u_q16_to_fp32.s3_norm_mag\[0\]
+ sky130_fd_sc_hd__dfxtp_1
XFILLER_13_435 VPWR VGND VPWR VGND sky130_ef_sc_hd__decap_12
XFILLER_41_777 VGND VGND VPWR VPWR sky130_fd_sc_hd__decap_6
XTAP_TAPCELL_ROW_136_2517 VGND VPWR sky130_fd_sc_hd__tapvpwrvgnd_1
XTAP_TAPCELL_ROW_136_2506 VGND VPWR sky130_fd_sc_hd__tapvpwrvgnd_1
X_10672_ _04298_ _04300_ _04416_ _04417_ VGND VGND VPWR VPWR _04419_ sky130_fd_sc_hd__o211ai_4
X_12411_ _06084_ _06086_ _06137_ _06082_ _01111_ VGND VGND VPWR VPWR _06138_ sky130_fd_sc_hd__o32a_1
Xclkbuf_leaf_20_clk clknet_3_3__leaf_clk VGND VGND VPWR VPWR clknet_leaf_20_clk sky130_fd_sc_hd__clkbuf_8
XFILLER_139_654 VGND VGND VPWR VPWR sky130_fd_sc_hd__fill_1
XFILLER_138_131 VGND VGND VPWR VPWR sky130_fd_sc_hd__decap_8
X_13391_ clknet_leaf_48_clk _00401_ VGND VGND VPWR VPWR u_interface.fifo_data\[6\]\[4\]
+ sky130_fd_sc_hd__dfxtp_1
X_12342_ _06068_ _06069_ VGND VGND VPWR VPWR _06070_ sky130_fd_sc_hd__nor2_1
XFILLER_138_197 VGND VGND VPWR VPWR sky130_fd_sc_hd__fill_1
XFILLER_4_133 VGND VGND VPWR VPWR sky130_fd_sc_hd__decap_6
X_12273_ _05944_ _05947_ net177 VGND VGND VPWR VPWR _06002_ sky130_fd_sc_hd__o21a_1
XFILLER_141_307 VGND VGND VPWR VPWR sky130_fd_sc_hd__decap_8
XTAP_TAPCELL_ROW_56_1232 VGND VPWR sky130_fd_sc_hd__tapvpwrvgnd_1
X_14012_ clknet_leaf_83_clk net1202 VGND VGND VPWR VPWR u_interface.u_gelu_fp32.u_q16_to_fp32.s3_sign
+ sky130_fd_sc_hd__dfxtp_1
X_11224_ net651 net420 _04855_ _04854_ VGND VGND VPWR VPWR _04966_ sky130_fd_sc_hd__a31o_1
XFILLER_4_15 VPWR VGND VPWR VGND sky130_ef_sc_hd__decap_12
XFILLER_4_177 VPWR VGND VPWR VGND sky130_ef_sc_hd__decap_12
XFILLER_95_405 VGND VGND VPWR VPWR sky130_fd_sc_hd__decap_4
X_11155_ _04674_ _04782_ _04781_ VGND VGND VPWR VPWR _04898_ sky130_fd_sc_hd__a21o_1
XTAP_TAPCELL_ROW_8_461 VGND VPWR sky130_fd_sc_hd__tapvpwrvgnd_1
XFILLER_122_587 VGND VGND VPWR VPWR sky130_fd_sc_hd__fill_1
X_10106_ _03748_ _03855_ _03856_ VGND VGND VPWR VPWR _03858_ sky130_fd_sc_hd__and3_1
X_11086_ _04811_ _04826_ _04827_ VGND VGND VPWR VPWR _04829_ sky130_fd_sc_hd__and3_1
XFILLER_0_361 VGND VGND VPWR VPWR sky130_fd_sc_hd__decap_3
XFILLER_1_895 VGND VGND VPWR VPWR sky130_fd_sc_hd__fill_1
X_10037_ _03787_ _03788_ VGND VGND VPWR VPWR _03789_ sky130_fd_sc_hd__and2b_1
Xclkbuf_leaf_87_clk clknet_3_4__leaf_clk VGND VGND VPWR VPWR clknet_leaf_87_clk sky130_fd_sc_hd__clkbuf_8
XFILLER_84_50 VGND VGND VPWR VPWR sky130_fd_sc_hd__fill_2
XFILLER_76_674 VGND VGND VPWR VPWR sky130_fd_sc_hd__decap_6
XFILLER_63_313 VPWR VGND VPWR VGND sky130_ef_sc_hd__decap_12
XFILLER_48_365 VPWR VGND VPWR VGND sky130_ef_sc_hd__decap_12
XFILLER_63_335 VGND VGND VPWR VPWR sky130_fd_sc_hd__fill_1
XFILLER_17_741 VPWR VGND VPWR VGND sky130_ef_sc_hd__decap_12
X_11988_ _05640_ _05647_ VGND VGND VPWR VPWR _05722_ sky130_fd_sc_hd__or2_1
X_13727_ clknet_leaf_7_clk _00737_ VGND VGND VPWR VPWR u_interface.u_gelu_fp32.s1_data\[27\]
+ sky130_fd_sc_hd__dfxtp_1
X_10939_ _04681_ _04682_ VGND VGND VPWR VPWR _04683_ sky130_fd_sc_hd__nand2_1
XFILLER_17_785 VPWR VGND VPWR VGND sky130_ef_sc_hd__decap_12
XFILLER_31_210 VPWR VGND VPWR VGND sky130_ef_sc_hd__decap_12
XFILLER_149_429 VGND VGND VPWR VPWR sky130_fd_sc_hd__fill_1
XFILLER_20_917 VGND VGND VPWR VPWR sky130_fd_sc_hd__decap_4
XFILLER_32_755 VGND VGND VPWR VPWR sky130_fd_sc_hd__fill_1
X_13658_ clknet_leaf_14_clk _00668_ VGND VGND VPWR VPWR u_interface.u_gelu_fp32.u_fp32_to_q16.s1_exp\[4\]
+ sky130_fd_sc_hd__dfxtp_1
XFILLER_31_254 VGND VGND VPWR VPWR sky130_fd_sc_hd__decap_3
Xclkbuf_leaf_11_clk clknet_3_2__leaf_clk VGND VGND VPWR VPWR clknet_leaf_11_clk sky130_fd_sc_hd__clkbuf_8
X_13589_ clknet_leaf_48_clk _00599_ VGND VGND VPWR VPWR u_interface.fifo_data\[3\]\[4\]
+ sky130_fd_sc_hd__dfxtp_1
XFILLER_76_3 VPWR VGND VPWR VGND sky130_ef_sc_hd__decap_12
X_12609_ _06302_ _06306_ _06309_ _06311_ VGND VGND VPWR VPWR _06312_ sky130_fd_sc_hd__or4_1
XFILLER_145_613 VGND VGND VPWR VPWR sky130_fd_sc_hd__decap_3
XFILLER_144_134 VGND VGND VPWR VPWR sky130_fd_sc_hd__decap_6
XFILLER_132_307 VGND VGND VPWR VPWR sky130_fd_sc_hd__fill_1
XFILLER_98_243 VGND VGND VPWR VPWR sky130_fd_sc_hd__decap_8
X_09820_ _03568_ _03573_ VGND VGND VPWR VPWR _03574_ sky130_fd_sc_hd__nand2_1
Xfanout418 net419 VGND VGND VPWR VPWR net418 sky130_fd_sc_hd__clkbuf_2
Xfanout429 net430 VGND VGND VPWR VPWR net429 sky130_fd_sc_hd__buf_2
Xfanout407 net409 VGND VGND VPWR VPWR net407 sky130_fd_sc_hd__buf_2
X_09751_ _03504_ _03505_ _03469_ VGND VGND VPWR VPWR _03506_ sky130_fd_sc_hd__a21oi_1
X_06963_ u_interface.u_gelu_fp32.u_synth_top.s1_x\[30\] net273 VGND VGND VPWR VPWR
+ _01491_ sky130_fd_sc_hd__and2_1
XFILLER_58_129 VGND VGND VPWR VPWR sky130_fd_sc_hd__decap_8
XFILLER_58_107 VGND VGND VPWR VPWR sky130_fd_sc_hd__fill_1
X_08702_ _02450_ _02455_ _02460_ VGND VGND VPWR VPWR _02461_ sky130_fd_sc_hd__or3_1
Xclkbuf_leaf_78_clk clknet_3_4__leaf_clk VGND VGND VPWR VPWR clknet_leaf_78_clk sky130_fd_sc_hd__clkbuf_8
X_09682_ net466 net640 net648 net471 VGND VGND VPWR VPWR _03437_ sky130_fd_sc_hd__a22o_1
XFILLER_94_471 VGND VGND VPWR VPWR sky130_fd_sc_hd__decap_4
X_06894_ net386 _01186_ _01435_ VGND VGND VPWR VPWR _01436_ sky130_fd_sc_hd__nor3_1
XTAP_TAPCELL_ROW_87_1726 VGND VPWR sky130_fd_sc_hd__tapvpwrvgnd_1
XFILLER_27_505 VGND VGND VPWR VPWR sky130_fd_sc_hd__decap_6
XFILLER_81_110 VGND VGND VPWR VPWR sky130_fd_sc_hd__fill_2
XFILLER_66_195 VGND VGND VPWR VPWR sky130_fd_sc_hd__fill_1
X_08633_ _02244_ _02404_ VGND VGND VPWR VPWR _02405_ sky130_fd_sc_hd__xnor2_1
XFILLER_27_538 VPWR VGND VPWR VGND sky130_ef_sc_hd__decap_12
XFILLER_82_688 VGND VGND VPWR VPWR sky130_fd_sc_hd__fill_1
X_08564_ _02318_ _02326_ _02329_ _02354_ VGND VGND VPWR VPWR _02355_ sky130_fd_sc_hd__and4_1
X_07515_ _01611_ _01608_ net551 VGND VGND VPWR VPWR _01645_ sky130_fd_sc_hd__mux2_1
XFILLER_120_37 VGND VGND VPWR VPWR sky130_fd_sc_hd__decap_3
XTAP_TAPCELL_ROW_25_728 VGND VPWR sky130_fd_sc_hd__tapvpwrvgnd_1
XTAP_TAPCELL_ROW_25_739 VGND VPWR sky130_fd_sc_hd__tapvpwrvgnd_1
X_08495_ u_interface.u_gelu_fp32.u_synth_top.s3_mult\[45\] u_interface.u_gelu_fp32.u_synth_top.s3_mult\[44\]
+ net522 VGND VGND VPWR VPWR _02286_ sky130_fd_sc_hd__o21ai_1
X_07446_ _01580_ VGND VGND VPWR VPWR _01581_ sky130_fd_sc_hd__inv_2
XFILLER_50_585 VGND VGND VPWR VPWR sky130_fd_sc_hd__decap_3
XFILLER_10_405 VGND VGND VPWR VPWR sky130_fd_sc_hd__fill_1
XFILLER_11_917 VGND VGND VPWR VPWR sky130_fd_sc_hd__fill_1
XFILLER_23_777 VGND VGND VPWR VPWR sky130_fd_sc_hd__decap_6
X_07377_ net1253 net364 net239 VGND VGND VPWR VPWR _00407_ sky130_fd_sc_hd__mux2_1
XTAP_TAPCELL_ROW_118_2225 VGND VPWR sky130_fd_sc_hd__tapvpwrvgnd_1
XFILLER_13_57 VPWR VGND VPWR VGND sky130_ef_sc_hd__decap_12
XFILLER_22_298 VGND VGND VPWR VPWR sky130_fd_sc_hd__decap_8
XFILLER_148_484 VGND VGND VPWR VPWR sky130_fd_sc_hd__decap_6
XFILLER_148_462 VGND VGND VPWR VPWR sky130_fd_sc_hd__decap_8
X_09116_ net597 net496 VGND VGND VPWR VPWR _02875_ sky130_fd_sc_hd__nand2_1
XFILLER_129_57 VPWR VGND VPWR VGND sky130_ef_sc_hd__decap_12
X_09047_ _02756_ _02804_ _02805_ VGND VGND VPWR VPWR _02806_ sky130_fd_sc_hd__and3_1
XTAP_TAPCELL_ROW_131_2425 VGND VPWR sky130_fd_sc_hd__tapvpwrvgnd_1
XFILLER_108_337 VGND VGND VPWR VPWR sky130_fd_sc_hd__fill_2
XTAP_TAPCELL_ROW_98_1899 VGND VPWR sky130_fd_sc_hd__tapvpwrvgnd_1
XFILLER_89_28 VPWR VGND VPWR VGND sky130_ef_sc_hd__decap_12
XFILLER_136_679 VGND VGND VPWR VPWR sky130_fd_sc_hd__fill_2
XTAP_TAPCELL_ROW_131_2436 VGND VPWR sky130_fd_sc_hd__tapvpwrvgnd_1
XFILLER_150_115 VGND VGND VPWR VPWR sky130_fd_sc_hd__fill_1
Xhold461 u_interface.fifo_data\[4\]\[16\] VGND VGND VPWR VPWR net1326 sky130_fd_sc_hd__dlygate4sd3_1
XFILLER_132_841 VGND VGND VPWR VPWR sky130_fd_sc_hd__decap_4
Xhold450 u_interface.fifo_tlast\[1\] VGND VGND VPWR VPWR net1315 sky130_fd_sc_hd__dlygate4sd3_1
XFILLER_117_893 VGND VGND VPWR VPWR sky130_fd_sc_hd__decap_3
XFILLER_104_510 VGND VGND VPWR VPWR sky130_fd_sc_hd__decap_3
Xhold472 u_interface.fifo_data\[9\]\[31\] VGND VGND VPWR VPWR net1337 sky130_fd_sc_hd__dlygate4sd3_1
XFILLER_1_125 VPWR VGND VPWR VGND sky130_ef_sc_hd__decap_12
XFILLER_2_637 VGND VGND VPWR VPWR sky130_fd_sc_hd__decap_6
Xhold494 _01001_ VGND VGND VPWR VPWR net1359 sky130_fd_sc_hd__dlygate4sd3_1
Xhold483 u_interface.fifo_data\[4\]\[18\] VGND VGND VPWR VPWR net1348 sky130_fd_sc_hd__dlygate4sd3_1
XFILLER_131_362 VPWR VGND VPWR VGND sky130_ef_sc_hd__decap_12
X_09949_ _03699_ _03701_ VGND VGND VPWR VPWR _03702_ sky130_fd_sc_hd__nor2_1
XTAP_TAPCELL_ROW_5_420 VGND VPWR sky130_fd_sc_hd__tapvpwrvgnd_1
XFILLER_1_169 VPWR VGND VPWR VGND sky130_ef_sc_hd__decap_12
XFILLER_58_641 VGND VGND VPWR VPWR sky130_fd_sc_hd__decap_3
Xclkbuf_leaf_69_clk clknet_3_5__leaf_clk VGND VGND VPWR VPWR clknet_leaf_69_clk sky130_fd_sc_hd__clkbuf_8
XTAP_TAPCELL_ROW_51_1151 VGND VPWR sky130_fd_sc_hd__tapvpwrvgnd_1
X_12960_ _06478_ _06479_ _06468_ VGND VGND VPWR VPWR _06480_ sky130_fd_sc_hd__o21ai_1
XTAP_TAPCELL_ROW_129_2398 VGND VPWR sky130_fd_sc_hd__tapvpwrvgnd_1
XFILLER_100_760 VGND VGND VPWR VPWR sky130_fd_sc_hd__decap_8
XFILLER_58_685 VGND VGND VPWR VPWR sky130_fd_sc_hd__decap_3
XFILLER_46_825 VGND VGND VPWR VPWR sky130_fd_sc_hd__decap_6
X_12891_ net789 net107 _01535_ VGND VGND VPWR VPWR _01033_ sky130_fd_sc_hd__and3_1
XFILLER_57_195 VGND VGND VPWR VPWR sky130_fd_sc_hd__fill_2
X_11911_ _04912_ _05311_ _05643_ _05644_ _05645_ VGND VGND VPWR VPWR _05646_ sky130_fd_sc_hd__o311a_1
XFILLER_45_324 VPWR VGND VPWR VGND sky130_ef_sc_hd__decap_12
XFILLER_18_549 VGND VGND VPWR VPWR sky130_fd_sc_hd__decap_6
XFILLER_45_368 VPWR VGND VPWR VGND sky130_ef_sc_hd__decap_12
X_11842_ net435 _05416_ VGND VGND VPWR VPWR _05577_ sky130_fd_sc_hd__and2_1
XFILLER_72_165 VPWR VGND VPWR VGND sky130_ef_sc_hd__decap_12
X_13512_ clknet_leaf_51_clk _00522_ VGND VGND VPWR VPWR u_interface.core_data_out\[23\]
+ sky130_fd_sc_hd__dfxtp_1
XFILLER_53_390 VGND VGND VPWR VPWR sky130_fd_sc_hd__fill_2
XFILLER_14_755 VGND VGND VPWR VPWR sky130_fd_sc_hd__fill_1
X_11773_ _05500_ _05507_ VGND VGND VPWR VPWR _05509_ sky130_fd_sc_hd__and2_1
X_10724_ net669 net448 _04376_ _04375_ VGND VGND VPWR VPWR _04470_ sky130_fd_sc_hd__a31o_1
XFILLER_9_225 VGND VGND VPWR VPWR sky130_fd_sc_hd__decap_4
XFILLER_13_276 VGND VGND VPWR VPWR sky130_fd_sc_hd__decap_4
X_13443_ clknet_leaf_9_clk _00453_ VGND VGND VPWR VPWR u_interface.u_gelu_fp32.u_fp32_to_q16.s3_mag\[14\]
+ sky130_fd_sc_hd__dfxtp_1
X_10655_ net618 net422 _04399_ _04400_ VGND VGND VPWR VPWR _04402_ sky130_fd_sc_hd__nand4_1
X_13374_ clknet_leaf_34_clk _00384_ VGND VGND VPWR VPWR u_interface.fifo_data\[7\]\[19\]
+ sky130_fd_sc_hd__dfxtp_1
Xclkload17 clknet_leaf_86_clk VGND VGND VPWR VPWR clkload17/Y sky130_fd_sc_hd__inv_12
XFILLER_154_421 VPWR VGND VPWR VGND sky130_ef_sc_hd__decap_12
Xclkload39 clknet_leaf_29_clk VGND VGND VPWR VPWR clkload39/Y sky130_fd_sc_hd__inv_8
Xclkload28 clknet_leaf_13_clk VGND VGND VPWR VPWR clkload28/Y sky130_fd_sc_hd__bufinv_16
X_10586_ _04204_ _04211_ _04212_ VGND VGND VPWR VPWR _04333_ sky130_fd_sc_hd__a21bo_1
XFILLER_5_420 VPWR VGND VPWR VGND sky130_ef_sc_hd__decap_12
X_12325_ net192 _06053_ VGND VGND VPWR VPWR _06054_ sky130_fd_sc_hd__or2_1
XFILLER_142_627 VGND VGND VPWR VPWR sky130_fd_sc_hd__fill_2
XFILLER_115_819 VGND VGND VPWR VPWR sky130_fd_sc_hd__fill_1
XFILLER_123_841 VGND VGND VPWR VPWR sky130_fd_sc_hd__decap_3
XFILLER_114_329 VGND VGND VPWR VPWR sky130_fd_sc_hd__decap_8
XFILLER_5_497 VGND VGND VPWR VPWR sky130_fd_sc_hd__decap_6
X_12256_ _05984_ _05985_ VGND VGND VPWR VPWR _05986_ sky130_fd_sc_hd__and2_1
XTAP_TAPCELL_ROW_149_2719 VGND VPWR sky130_fd_sc_hd__tapvpwrvgnd_1
XFILLER_79_83 VGND VGND VPWR VPWR sky130_fd_sc_hd__fill_2
X_11207_ net703 net443 net439 net694 VGND VGND VPWR VPWR _04949_ sky130_fd_sc_hd__a22oi_1
X_12187_ _05871_ _05917_ VGND VGND VPWR VPWR _05918_ sky130_fd_sc_hd__xor2_1
X_11138_ _04863_ _04880_ VGND VGND VPWR VPWR _04881_ sky130_fd_sc_hd__xnor2_2
XFILLER_95_257 VGND VGND VPWR VPWR sky130_fd_sc_hd__decap_3
XFILLER_95_279 VGND VGND VPWR VPWR sky130_fd_sc_hd__fill_1
Xclkbuf_leaf_0_clk clknet_3_0__leaf_clk VGND VGND VPWR VPWR clknet_leaf_0_clk sky130_fd_sc_hd__clkbuf_8
XFILLER_76_471 VGND VGND VPWR VPWR sky130_fd_sc_hd__decap_4
X_11069_ _04700_ _04706_ _04707_ VGND VGND VPWR VPWR _04812_ sky130_fd_sc_hd__o21bai_1
XTAP_TAPCELL_ROW_69_1445 VGND VPWR sky130_fd_sc_hd__tapvpwrvgnd_1
XTAP_TAPCELL_ROW_69_1434 VGND VPWR sky130_fd_sc_hd__tapvpwrvgnd_1
XFILLER_64_633 VGND VGND VPWR VPWR sky130_fd_sc_hd__decap_8
XFILLER_63_110 VGND VGND VPWR VPWR sky130_fd_sc_hd__fill_2
XFILLER_36_346 VGND VGND VPWR VPWR sky130_fd_sc_hd__fill_1
XFILLER_91_485 VPWR VGND VPWR VGND sky130_ef_sc_hd__decap_12
XFILLER_149_204 VGND VGND VPWR VPWR sky130_fd_sc_hd__decap_4
X_07300_ net1488 net566 net247 VGND VGND VPWR VPWR _00330_ sky130_fd_sc_hd__mux2_1
XTAP_TAPCELL_ROW_82_1645 VGND VPWR sky130_fd_sc_hd__tapvpwrvgnd_1
XFILLER_60_850 VGND VGND VPWR VPWR sky130_fd_sc_hd__fill_1
X_08280_ net532 _02092_ net1606 VGND VGND VPWR VPWR _02093_ sky130_fd_sc_hd__a21oi_1
XFILLER_20_725 VPWR VGND VPWR VGND sky130_ef_sc_hd__decap_12
XFILLER_32_563 VPWR VGND VPWR VGND sky130_ef_sc_hd__decap_12
X_07231_ u_interface.fifo_rd_ptr\[2\] u_interface.fifo_rd_ptr\[1\] _01528_ VGND VGND
+ VPWR VPWR _01532_ sky130_fd_sc_hd__and3_1
XFILLER_118_613 VPWR VGND VPWR VGND sky130_ef_sc_hd__decap_12
XFILLER_20_769 VPWR VGND VPWR VGND sky130_ef_sc_hd__decap_12
X_07162_ net1069 net380 net261 VGND VGND VPWR VPWR _00202_ sky130_fd_sc_hd__mux2_1
XFILLER_8_280 VPWR VGND VPWR VGND sky130_ef_sc_hd__decap_12
XTAP_TAPCELL_ROW_113_2144 VGND VPWR sky130_fd_sc_hd__tapvpwrvgnd_1
X_07093_ net1233 net360 net226 VGND VGND VPWR VPWR _00133_ sky130_fd_sc_hd__mux2_1
XFILLER_105_329 VGND VGND VPWR VPWR sky130_fd_sc_hd__fill_1
XFILLER_99_530 VGND VGND VPWR VPWR sky130_fd_sc_hd__decap_6
Xfanout204 _05582_ VGND VGND VPWR VPWR net204 sky130_fd_sc_hd__clkbuf_2
XFILLER_115_15 VGND VGND VPWR VPWR sky130_fd_sc_hd__decap_6
Xfanout215 _03230_ VGND VGND VPWR VPWR net215 sky130_fd_sc_hd__buf_4
XFILLER_101_502 VGND VGND VPWR VPWR sky130_fd_sc_hd__fill_2
X_09803_ _03555_ _03556_ _03495_ _03497_ VGND VGND VPWR VPWR _03557_ sky130_fd_sc_hd__a211oi_1
Xfanout226 _01521_ VGND VGND VPWR VPWR net226 sky130_fd_sc_hd__buf_2
Xfanout237 net238 VGND VGND VPWR VPWR net237 sky130_fd_sc_hd__buf_4
XFILLER_59_405 VGND VGND VPWR VPWR sky130_fd_sc_hd__fill_2
Xfanout248 _01514_ VGND VGND VPWR VPWR net248 sky130_fd_sc_hd__clkbuf_4
X_07995_ net544 net304 _01625_ net278 VGND VGND VPWR VPWR _01861_ sky130_fd_sc_hd__a31o_1
Xfanout259 _01510_ VGND VGND VPWR VPWR net259 sky130_fd_sc_hd__buf_4
X_09734_ net499 net705 _03486_ _03487_ VGND VGND VPWR VPWR _03489_ sky130_fd_sc_hd__nand4_1
XFILLER_83_920 VGND VGND VPWR VPWR sky130_fd_sc_hd__fill_1
X_06946_ _01475_ _01476_ _01477_ VGND VGND VPWR VPWR _01478_ sky130_fd_sc_hd__and3_1
XFILLER_74_419 VGND VGND VPWR VPWR sky130_fd_sc_hd__fill_1
XFILLER_28_825 VPWR VGND VPWR VGND sky130_ef_sc_hd__decap_12
X_09665_ net826 _03420_ VGND VGND VPWR VPWR _00811_ sky130_fd_sc_hd__nor2_1
XFILLER_67_482 VPWR VGND VPWR VGND sky130_ef_sc_hd__decap_12
XFILLER_55_644 VGND VGND VPWR VPWR sky130_fd_sc_hd__fill_1
XFILLER_27_335 VGND VGND VPWR VPWR sky130_fd_sc_hd__fill_1
X_06877_ u_interface.fifo_data\[12\]\[31\] u_interface.fifo_data\[13\]\[31\] u_interface.fifo_data\[14\]\[31\]
+ u_interface.fifo_data\[15\]\[31\] net755 net738 VGND VGND VPWR VPWR _01421_ sky130_fd_sc_hd__mux4_1
X_08616_ net153 _02392_ net800 VGND VGND VPWR VPWR _00790_ sky130_fd_sc_hd__a21oi_1
XFILLER_28_869 VPWR VGND VPWR VGND sky130_ef_sc_hd__decap_12
X_09596_ _03270_ _03350_ VGND VGND VPWR VPWR _03352_ sky130_fd_sc_hd__xnor2_1
XFILLER_23_541 VGND VGND VPWR VPWR sky130_fd_sc_hd__fill_1
X_08547_ _02304_ _02320_ VGND VGND VPWR VPWR _02338_ sky130_fd_sc_hd__nand2_1
XFILLER_35_390 VGND VGND VPWR VPWR sky130_fd_sc_hd__fill_2
XFILLER_42_349 VGND VGND VPWR VPWR sky130_fd_sc_hd__decap_6
XFILLER_50_360 VGND VGND VPWR VPWR sky130_fd_sc_hd__decap_4
X_08478_ _02268_ VGND VGND VPWR VPWR _02269_ sky130_fd_sc_hd__inv_2
X_07429_ u_interface.u_gelu_fp32.u_fp32_to_q16.s2_norm_mag\[14\] u_interface.u_gelu_fp32.u_fp32_to_q16.s2_norm_mag\[15\]
+ net558 VGND VGND VPWR VPWR _01565_ sky130_fd_sc_hd__mux2_1
XFILLER_50_371 VGND VGND VPWR VPWR sky130_fd_sc_hd__decap_6
XFILLER_10_224 VGND VGND VPWR VPWR sky130_fd_sc_hd__fill_2
XFILLER_149_782 VGND VGND VPWR VPWR sky130_fd_sc_hd__fill_2
XFILLER_109_602 VPWR VGND VPWR VGND sky130_ef_sc_hd__decap_12
X_10440_ _04187_ _04188_ VGND VGND VPWR VPWR _04189_ sky130_fd_sc_hd__xnor2_1
XFILLER_10_268 VGND VGND VPWR VPWR sky130_fd_sc_hd__fill_2
XFILLER_10_246 VGND VGND VPWR VPWR sky130_fd_sc_hd__decap_6
XFILLER_7_729 VPWR VGND VPWR VGND sky130_ef_sc_hd__decap_12
XFILLER_108_134 VGND VGND VPWR VPWR sky130_fd_sc_hd__decap_6
XFILLER_109_668 VGND VGND VPWR VPWR sky130_fd_sc_hd__decap_4
X_10371_ _04115_ _04116_ _04117_ VGND VGND VPWR VPWR _04120_ sky130_fd_sc_hd__and3_1
X_13090_ clknet_leaf_52_clk _00100_ VGND VGND VPWR VPWR u_interface.fifo_data\[15\]\[11\]
+ sky130_fd_sc_hd__dfxtp_1
XFILLER_108_178 VGND VGND VPWR VPWR sky130_fd_sc_hd__fill_1
XFILLER_2_401 VPWR VGND VPWR VGND sky130_ef_sc_hd__decap_12
X_12110_ _05750_ _05768_ _05767_ VGND VGND VPWR VPWR _05842_ sky130_fd_sc_hd__o21a_1
Xhold280 u_interface.fifo_data\[2\]\[28\] VGND VGND VPWR VPWR net1145 sky130_fd_sc_hd__dlygate4sd3_1
XFILLER_6_3 VPWR VGND VPWR VGND sky130_ef_sc_hd__decap_12
XFILLER_2_445 VPWR VGND VPWR VGND sky130_ef_sc_hd__decap_12
X_12041_ _05666_ _05700_ _05699_ VGND VGND VPWR VPWR _05774_ sky130_fd_sc_hd__a21oi_1
XFILLER_120_833 VGND VGND VPWR VPWR sky130_fd_sc_hd__decap_4
Xhold291 u_interface.fifo_data\[8\]\[1\] VGND VGND VPWR VPWR net1156 sky130_fd_sc_hd__dlygate4sd3_1
XFILLER_2_489 VPWR VGND VPWR VGND sky130_ef_sc_hd__decap_12
XFILLER_132_693 VGND VGND VPWR VPWR sky130_fd_sc_hd__decap_6
Xfanout760 net762 VGND VGND VPWR VPWR net760 sky130_fd_sc_hd__buf_4
XFILLER_49_86 VPWR VGND VPWR VGND sky130_ef_sc_hd__decap_12
XFILLER_49_75 VGND VGND VPWR VPWR sky130_fd_sc_hd__fill_1
Xfanout771 _00000_ VGND VGND VPWR VPWR net771 sky130_fd_sc_hd__buf_4
XTAP_TAPCELL_ROW_144_2638 VGND VPWR sky130_fd_sc_hd__tapvpwrvgnd_1
Xfanout782 net783 VGND VGND VPWR VPWR net782 sky130_fd_sc_hd__clkbuf_2
X_13992_ clknet_leaf_55_clk _00918_ VGND VGND VPWR VPWR u_interface.u_gelu_fp32.u_q16_to_fp32.s3_norm_mag\[19\]
+ sky130_fd_sc_hd__dfxtp_1
Xfanout793 net794 VGND VGND VPWR VPWR net793 sky130_fd_sc_hd__buf_2
XFILLER_1_27 VPWR VGND VPWR VGND sky130_ef_sc_hd__decap_12
X_12943_ net1715 _06464_ _06465_ VGND VGND VPWR VPWR _01058_ sky130_fd_sc_hd__o21a_1
XFILLER_74_920 VGND VGND VPWR VPWR sky130_fd_sc_hd__fill_1
XFILLER_45_110 VGND VGND VPWR VPWR sky130_fd_sc_hd__fill_2
XFILLER_18_357 VGND VGND VPWR VPWR sky130_fd_sc_hd__decap_4
X_12874_ net1616 u_interface.u_gelu_fp32.u_fp32_to_q16.s2_norm_mag\[29\] net819 VGND
+ VGND VPWR VPWR _01018_ sky130_fd_sc_hd__mux2_1
XFILLER_33_305 VGND VGND VPWR VPWR sky130_fd_sc_hd__decap_8
X_11825_ _05487_ _05560_ VGND VGND VPWR VPWR _05561_ sky130_fd_sc_hd__nor2_1
XFILLER_33_349 VGND VGND VPWR VPWR sky130_fd_sc_hd__fill_2
XTAP_TAPCELL_ROW_64_1364 VGND VPWR sky130_fd_sc_hd__tapvpwrvgnd_1
XTAP_TAPCELL_ROW_64_1353 VGND VPWR sky130_fd_sc_hd__tapvpwrvgnd_1
X_11756_ net184 _05491_ VGND VGND VPWR VPWR _05492_ sky130_fd_sc_hd__xnor2_1
X_10707_ _04449_ _04450_ _04451_ VGND VGND VPWR VPWR _04453_ sky130_fd_sc_hd__nand3_1
XFILLER_41_393 VPWR VGND VPWR VGND sky130_ef_sc_hd__decap_12
X_13426_ clknet_leaf_11_clk _00436_ VGND VGND VPWR VPWR u_interface.u_gelu_fp32.u_fp32_to_q16.s3_frac\[6\]
+ sky130_fd_sc_hd__dfxtp_1
X_11687_ net214 _05423_ VGND VGND VPWR VPWR _05424_ sky130_fd_sc_hd__xnor2_1
XFILLER_155_741 VGND VGND VPWR VPWR sky130_fd_sc_hd__decap_4
XFILLER_139_281 VGND VGND VPWR VPWR sky130_fd_sc_hd__decap_3
XFILLER_127_432 VGND VGND VPWR VPWR sky130_fd_sc_hd__decap_4
X_10638_ _04382_ _04383_ _04384_ VGND VGND VPWR VPWR _04385_ sky130_fd_sc_hd__a21o_1
XFILLER_155_785 VGND VGND VPWR VPWR sky130_fd_sc_hd__fill_2
XFILLER_154_251 VGND VGND VPWR VPWR sky130_fd_sc_hd__fill_1
X_10569_ _04192_ _04199_ VGND VGND VPWR VPWR _04317_ sky130_fd_sc_hd__nor2_1
X_13357_ clknet_leaf_73_clk _00367_ VGND VGND VPWR VPWR u_interface.fifo_data\[7\]\[2\]
+ sky130_fd_sc_hd__dfxtp_1
XFILLER_114_104 VPWR VGND VPWR VGND sky130_ef_sc_hd__decap_12
X_13288_ clknet_leaf_68_clk _00298_ VGND VGND VPWR VPWR u_interface.fifo_data\[0\]\[30\]
+ sky130_fd_sc_hd__dfxtp_1
XFILLER_5_261 VPWR VGND VPWR VGND sky130_ef_sc_hd__decap_12
X_12308_ _06033_ _06034_ VGND VGND VPWR VPWR _06037_ sky130_fd_sc_hd__xnor2_1
XFILLER_114_148 VGND VGND VPWR VPWR sky130_fd_sc_hd__decap_3
X_12239_ _05892_ _05901_ _05900_ VGND VGND VPWR VPWR _05969_ sky130_fd_sc_hd__a21oi_1
XFILLER_68_213 VGND VGND VPWR VPWR sky130_fd_sc_hd__decap_8
XFILLER_39_3 VPWR VGND VPWR VGND sky130_ef_sc_hd__decap_12
XFILLER_122_192 VGND VGND VPWR VPWR sky130_fd_sc_hd__decap_4
XFILLER_110_321 VPWR VGND VPWR VGND sky130_ef_sc_hd__decap_12
XFILLER_68_246 VGND VGND VPWR VPWR sky130_fd_sc_hd__decap_6
X_07780_ net1029 net364 net235 VGND VGND VPWR VPWR _00541_ sky130_fd_sc_hd__mux2_1
XFILLER_110_365 VGND VGND VPWR VPWR sky130_fd_sc_hd__decap_4
XFILLER_84_728 VPWR VGND VPWR VGND sky130_ef_sc_hd__decap_12
XFILLER_68_268 VPWR VGND VPWR VGND sky130_ef_sc_hd__decap_12
X_06800_ net320 _01353_ net725 VGND VGND VPWR VPWR _01354_ sky130_fd_sc_hd__o21a_1
Xinput4 s_axil_araddr[10] VGND VGND VPWR VPWR net4 sky130_fd_sc_hd__buf_1
X_06731_ _01292_ _01293_ net731 VGND VGND VPWR VPWR _01294_ sky130_fd_sc_hd__mux2_1
XFILLER_49_493 VGND VGND VPWR VPWR sky130_fd_sc_hd__decap_4
X_09450_ _03206_ _03207_ _02695_ _02697_ VGND VGND VPWR VPWR _03208_ sky130_fd_sc_hd__o211ai_1
XFILLER_37_677 VGND VGND VPWR VPWR sky130_fd_sc_hd__fill_1
XFILLER_91_271 VGND VGND VPWR VPWR sky130_fd_sc_hd__decap_8
X_06662_ u_interface.fifo_data\[8\]\[4\] u_interface.fifo_data\[9\]\[4\] u_interface.fifo_data\[10\]\[4\]
+ u_interface.fifo_data\[11\]\[4\] net761 net744 VGND VGND VPWR VPWR _01233_ sky130_fd_sc_hd__mux4_1
X_08401_ u_interface.u_gelu_fp32.u_synth_top.s3_mult\[25\] u_interface.u_gelu_fp32.u_synth_top.s3_b\[9\]
+ VGND VGND VPWR VPWR _02192_ sky130_fd_sc_hd__nor2_1
XFILLER_25_839 VGND VGND VPWR VPWR sky130_fd_sc_hd__fill_1
X_09381_ _03135_ _03138_ VGND VGND VPWR VPWR _03139_ sky130_fd_sc_hd__xnor2_1
X_06593_ net537 u_interface.u_gelu_fp32.s1_data\[14\] _01105_ u_interface.u_gelu_fp32.s1_data\[16\]
+ VGND VGND VPWR VPWR _01177_ sky130_fd_sc_hd__a211o_1
X_08332_ net529 _02131_ net1630 VGND VGND VPWR VPWR _02132_ sky130_fd_sc_hd__a21oi_1
XTAP_TAPCELL_ROW_35_889 VGND VPWR sky130_fd_sc_hd__tapvpwrvgnd_1
X_08263_ net1561 _02079_ _02080_ VGND VGND VPWR VPWR _00749_ sky130_fd_sc_hd__a21oi_1
XTAP_TAPCELL_ROW_15_580 VGND VPWR sky130_fd_sc_hd__tapvpwrvgnd_1
XFILLER_20_533 VGND VGND VPWR VPWR sky130_fd_sc_hd__decap_3
XFILLER_32_393 VGND VGND VPWR VPWR sky130_fd_sc_hd__fill_1
X_07214_ net340 net1347 net260 VGND VGND VPWR VPWR _00254_ sky130_fd_sc_hd__mux2_1
XFILLER_137_218 VGND VGND VPWR VPWR sky130_fd_sc_hd__decap_6
XFILLER_118_421 VPWR VGND VPWR VGND sky130_ef_sc_hd__decap_12
X_08194_ net539 _02026_ _02025_ VGND VGND VPWR VPWR _02028_ sky130_fd_sc_hd__a21o_1
X_07145_ net1210 net350 net219 VGND VGND VPWR VPWR _00185_ sky130_fd_sc_hd__mux2_1
XFILLER_145_262 VPWR VGND VPWR VGND sky130_ef_sc_hd__decap_12
XFILLER_133_413 VPWR VGND VPWR VGND sky130_ef_sc_hd__decap_12
XTAP_TAPCELL_ROW_95_1858 VGND VPWR sky130_fd_sc_hd__tapvpwrvgnd_1
X_07076_ net1429 net570 net208 VGND VGND VPWR VPWR _00116_ sky130_fd_sc_hd__mux2_1
XFILLER_121_608 VGND VGND VPWR VPWR sky130_fd_sc_hd__decap_8
XFILLER_114_671 VGND VGND VPWR VPWR sky130_fd_sc_hd__fill_1
XFILLER_102_811 VGND VGND VPWR VPWR sky130_fd_sc_hd__fill_1
XFILLER_86_29 VPWR VGND VPWR VGND sky130_ef_sc_hd__decap_12
XFILLER_101_332 VGND VGND VPWR VPWR sky130_fd_sc_hd__decap_4
XFILLER_99_393 VPWR VGND VPWR VGND sky130_ef_sc_hd__decap_12
XFILLER_87_555 VGND VGND VPWR VPWR sky130_fd_sc_hd__decap_4
X_07978_ net542 _01687_ net279 _01635_ net813 VGND VGND VPWR VPWR _01851_ sky130_fd_sc_hd__a221o_1
XFILLER_59_257 VPWR VGND VPWR VGND sky130_ef_sc_hd__decap_12
XTAP_TAPCELL_ROW_126_2357 VGND VPWR sky130_fd_sc_hd__tapvpwrvgnd_1
XTAP_TAPCELL_ROW_126_2346 VGND VPWR sky130_fd_sc_hd__tapvpwrvgnd_1
X_09717_ net500 net505 net713 net723 VGND VGND VPWR VPWR _03472_ sky130_fd_sc_hd__nand4_1
X_06929_ _01461_ _01464_ VGND VGND VPWR VPWR _01465_ sky130_fd_sc_hd__or2_1
XFILLER_27_132 VGND VGND VPWR VPWR sky130_fd_sc_hd__decap_4
X_09648_ _03364_ net176 _03402_ _03403_ VGND VGND VPWR VPWR _03404_ sky130_fd_sc_hd__o22a_1
XFILLER_83_783 VGND VGND VPWR VPWR sky130_fd_sc_hd__fill_1
XFILLER_28_699 VGND VGND VPWR VPWR sky130_fd_sc_hd__fill_1
X_09579_ net466 net471 net631 net640 VGND VGND VPWR VPWR _03335_ sky130_fd_sc_hd__nand4_1
XFILLER_31_809 VPWR VGND VPWR VGND sky130_ef_sc_hd__decap_12
XFILLER_35_55 VGND VGND VPWR VPWR sky130_fd_sc_hd__fill_1
X_12590_ u_interface.u_gelu_fp32.u_q16_to_fp32.s1_mag\[25\] u_interface.u_gelu_fp32.u_q16_to_fp32.s1_mag\[24\]
+ _06292_ VGND VGND VPWR VPWR _06293_ sky130_fd_sc_hd__or3_1
XFILLER_24_861 VGND VGND VPWR VPWR sky130_fd_sc_hd__decap_6
X_11610_ net676 net685 net416 net410 VGND VGND VPWR VPWR _05348_ sky130_fd_sc_hd__and4_1
XTAP_TAPCELL_ROW_104_1998 VGND VPWR sky130_fd_sc_hd__tapvpwrvgnd_1
XTAP_TAPCELL_ROW_46_1072 VGND VPWR sky130_fd_sc_hd__tapvpwrvgnd_1
XTAP_TAPCELL_ROW_13_539 VGND VPWR sky130_fd_sc_hd__tapvpwrvgnd_1
XFILLER_23_393 VPWR VGND VPWR VGND sky130_ef_sc_hd__decap_12
X_11541_ _05270_ _05279_ VGND VGND VPWR VPWR _05280_ sky130_fd_sc_hd__xnor2_2
XFILLER_51_54 VGND VGND VPWR VPWR sky130_fd_sc_hd__fill_2
X_11472_ _05122_ _05211_ VGND VGND VPWR VPWR _05212_ sky130_fd_sc_hd__and2_1
X_10423_ _04153_ _04169_ _04170_ VGND VGND VPWR VPWR _04172_ sky130_fd_sc_hd__nand3_2
XFILLER_7_559 VGND VGND VPWR VPWR sky130_fd_sc_hd__fill_1
X_13211_ clknet_leaf_76_clk _00221_ VGND VGND VPWR VPWR u_interface.fifo_data\[12\]\[21\]
+ sky130_fd_sc_hd__dfxtp_1
XFILLER_137_796 VGND VGND VPWR VPWR sky130_fd_sc_hd__decap_3
XFILLER_137_785 VGND VGND VPWR VPWR sky130_fd_sc_hd__fill_2
X_10354_ _04085_ _04100_ _04101_ VGND VGND VPWR VPWR _04103_ sky130_fd_sc_hd__nand3_2
X_13142_ clknet_leaf_76_clk _00152_ VGND VGND VPWR VPWR u_interface.fifo_data\[2\]\[31\]
+ sky130_fd_sc_hd__dfxtp_1
XFILLER_3_721 VGND VGND VPWR VPWR sky130_fd_sc_hd__decap_6
XFILLER_151_265 VPWR VGND VPWR VGND sky130_ef_sc_hd__decap_12
X_13073_ clknet_leaf_41_clk _00083_ VGND VGND VPWR VPWR u_interface.fifo_data\[14\]\[26\]
+ sky130_fd_sc_hd__dfxtp_1
X_10285_ net580 net587 net417 net413 VGND VGND VPWR VPWR _04035_ sky130_fd_sc_hd__and4_1
XFILLER_3_765 VPWR VGND VPWR VGND sky130_ef_sc_hd__decap_12
XFILLER_2_253 VPWR VGND VPWR VGND sky130_ef_sc_hd__decap_12
XFILLER_104_192 VGND VGND VPWR VPWR sky130_fd_sc_hd__decap_4
XFILLER_78_533 VGND VGND VPWR VPWR sky130_fd_sc_hd__fill_1
X_12024_ net666 net387 VGND VGND VPWR VPWR _05757_ sky130_fd_sc_hd__and2b_1
XFILLER_38_419 VGND VGND VPWR VPWR sky130_fd_sc_hd__fill_1
Xfanout590 net591 VGND VGND VPWR VPWR net590 sky130_fd_sc_hd__clkbuf_2
XFILLER_65_249 VGND VGND VPWR VPWR sky130_fd_sc_hd__decap_8
X_13975_ clknet_leaf_84_clk net1698 VGND VGND VPWR VPWR u_interface.u_gelu_fp32.u_q16_to_fp32.s2_mag\[20\]
+ sky130_fd_sc_hd__dfxtp_1
XFILLER_46_441 VGND VGND VPWR VPWR sky130_fd_sc_hd__decap_4
XFILLER_18_121 VPWR VGND VPWR VGND sky130_ef_sc_hd__decap_12
X_12926_ _06450_ _06451_ VGND VGND VPWR VPWR _06452_ sky130_fd_sc_hd__nor2_1
XFILLER_73_271 VGND VGND VPWR VPWR sky130_fd_sc_hd__fill_1
XFILLER_46_474 VGND VGND VPWR VPWR sky130_fd_sc_hd__fill_2
XFILLER_18_176 VGND VGND VPWR VPWR sky130_fd_sc_hd__decap_3
XFILLER_34_625 VPWR VGND VPWR VGND sky130_ef_sc_hd__decap_12
X_12857_ net1358 u_interface.u_gelu_fp32.u_fp32_to_q16.s2_norm_mag\[12\] net819 VGND
+ VGND VPWR VPWR _01001_ sky130_fd_sc_hd__mux2_1
XFILLER_73_293 VGND VGND VPWR VPWR sky130_fd_sc_hd__decap_4
XFILLER_61_433 VGND VGND VPWR VPWR sky130_fd_sc_hd__decap_8
XFILLER_34_669 VPWR VGND VPWR VGND sky130_ef_sc_hd__decap_12
XFILLER_21_319 VPWR VGND VPWR VGND sky130_ef_sc_hd__decap_12
X_11808_ _05510_ _05543_ VGND VGND VPWR VPWR _05544_ sky130_fd_sc_hd__xnor2_1
XFILLER_33_146 VGND VGND VPWR VPWR sky130_fd_sc_hd__fill_2
XFILLER_33_179 VPWR VGND VPWR VGND sky130_ef_sc_hd__decap_12
X_12788_ _01785_ _06410_ VGND VGND VPWR VPWR _00954_ sky130_fd_sc_hd__nor2_1
XTAP_TAPCELL_ROW_32_848 VGND VPWR sky130_fd_sc_hd__tapvpwrvgnd_1
X_11739_ net193 _05475_ VGND VGND VPWR VPWR _05476_ sky130_fd_sc_hd__xnor2_1
X_13409_ clknet_leaf_35_clk _00419_ VGND VGND VPWR VPWR u_interface.fifo_data\[6\]\[22\]
+ sky130_fd_sc_hd__dfxtp_1
XFILLER_128_752 VGND VGND VPWR VPWR sky130_fd_sc_hd__decap_4
XFILLER_143_711 VGND VGND VPWR VPWR sky130_fd_sc_hd__decap_6
XPHY_EDGE_ROW_133_Left_289 VGND VGND VPWR VPWR sky130_fd_sc_hd__decap_3
XTAP_TAPCELL_ROW_77_1566 VGND VPWR sky130_fd_sc_hd__tapvpwrvgnd_1
XFILLER_6_581 VGND VGND VPWR VPWR sky130_fd_sc_hd__decap_6
XFILLER_143_744 VGND VGND VPWR VPWR sky130_fd_sc_hd__fill_1
XTAP_TAPCELL_ROW_110_2103 VGND VPWR sky130_fd_sc_hd__tapvpwrvgnd_1
X_08950_ _02600_ _02601_ VGND VGND VPWR VPWR _02709_ sky130_fd_sc_hd__nand2_1
X_07901_ net89 net92 net91 net94 VGND VGND VPWR VPWR _01805_ sky130_fd_sc_hd__or4_1
XPHY_EDGE_ROW_135_Right_135 VGND VGND VPWR VPWR sky130_fd_sc_hd__decap_3
X_08881_ _02638_ _02639_ VGND VGND VPWR VPWR _02640_ sky130_fd_sc_hd__and2b_1
XTAP_TAPCELL_ROW_90_1777 VGND VPWR sky130_fd_sc_hd__tapvpwrvgnd_1
XFILLER_69_522 VGND VGND VPWR VPWR sky130_fd_sc_hd__decap_6
XFILLER_111_641 VGND VGND VPWR VPWR sky130_fd_sc_hd__fill_1
X_07832_ net1476 net563 net229 VGND VGND VPWR VPWR _00593_ sky130_fd_sc_hd__mux2_1
XFILLER_29_419 VGND VGND VPWR VPWR sky130_fd_sc_hd__fill_1
XFILLER_110_151 VGND VGND VPWR VPWR sky130_fd_sc_hd__fill_1
X_09502_ _03195_ _03197_ _03255_ _03256_ VGND VGND VPWR VPWR _03259_ sky130_fd_sc_hd__a211o_1
XFILLER_110_195 VGND VGND VPWR VPWR sky130_fd_sc_hd__fill_1
XTAP_TAPCELL_ROW_108_2065 VGND VPWR sky130_fd_sc_hd__tapvpwrvgnd_1
X_07763_ u_interface.u_gelu_fp32.u_q16_to_fp32.s3_exp\[4\] _01798_ u_interface.u_gelu_fp32.u_q16_to_fp32.s3_exp\[5\]
+ VGND VGND VPWR VPWR _01802_ sky130_fd_sc_hd__a21o_1
XFILLER_37_430 VGND VGND VPWR VPWR sky130_fd_sc_hd__fill_1
XFILLER_37_452 VGND VGND VPWR VPWR sky130_fd_sc_hd__decap_4
XPHY_EDGE_ROW_142_Left_298 VGND VGND VPWR VPWR sky130_fd_sc_hd__decap_3
X_06714_ u_interface.fifo_data\[4\]\[10\] u_interface.fifo_data\[5\]\[10\] u_interface.fifo_data\[6\]\[10\]
+ u_interface.fifo_data\[7\]\[10\] net769 net752 VGND VGND VPWR VPWR _01279_ sky130_fd_sc_hd__mux4_1
X_07694_ _01428_ _01753_ _01754_ VGND VGND VPWR VPWR _00498_ sky130_fd_sc_hd__or3_1
XFILLER_52_411 VGND VGND VPWR VPWR sky130_fd_sc_hd__decap_8
X_09433_ net489 net664 net671 net494 VGND VGND VPWR VPWR _03191_ sky130_fd_sc_hd__a22o_1
XFILLER_52_433 VGND VGND VPWR VPWR sky130_fd_sc_hd__decap_8
X_06645_ u_interface.fifo_data\[8\]\[2\] u_interface.fifo_data\[9\]\[2\] u_interface.fifo_data\[10\]\[2\]
+ u_interface.fifo_data\[11\]\[2\] net757 net740 VGND VGND VPWR VPWR _01218_ sky130_fd_sc_hd__mux4_1
X_09364_ _03117_ _03119_ VGND VGND VPWR VPWR _03123_ sky130_fd_sc_hd__nand2b_1
XTAP_TAPCELL_ROW_121_2276 VGND VPWR sky130_fd_sc_hd__tapvpwrvgnd_1
XTAP_TAPCELL_ROW_121_2265 VGND VPWR sky130_fd_sc_hd__tapvpwrvgnd_1
XFILLER_52_477 VGND VGND VPWR VPWR sky130_fd_sc_hd__decap_6
XFILLER_52_466 VGND VGND VPWR VPWR sky130_fd_sc_hd__decap_8
XFILLER_13_809 VPWR VGND VPWR VGND sky130_ef_sc_hd__decap_12
X_06576_ _01147_ _01166_ _01150_ VGND VGND VPWR VPWR _01167_ sky130_fd_sc_hd__o21a_1
X_08315_ u_interface.u_gelu_fp32.s2_data\[18\] _02116_ VGND VGND VPWR VPWR _02119_
+ sky130_fd_sc_hd__or2_1
X_09295_ _03017_ _03045_ _03050_ VGND VGND VPWR VPWR _03054_ sky130_fd_sc_hd__a21o_1
XFILLER_21_853 VPWR VGND VPWR VGND sky130_ef_sc_hd__decap_12
X_08246_ net779 net68 net73 _02069_ VGND VGND VPWR VPWR _00743_ sky130_fd_sc_hd__and4_1
XFILLER_21_897 VPWR VGND VPWR VGND sky130_ef_sc_hd__decap_12
XFILLER_119_774 VGND VGND VPWR VPWR sky130_fd_sc_hd__decap_6
X_08177_ net290 _02013_ VGND VGND VPWR VPWR _00730_ sky130_fd_sc_hd__nor2_1
XFILLER_146_571 VPWR VGND VPWR VGND sky130_ef_sc_hd__decap_12
X_07128_ net1056 net385 net217 VGND VGND VPWR VPWR _00168_ sky130_fd_sc_hd__mux2_1
XFILLER_21_57 VPWR VGND VPWR VGND sky130_ef_sc_hd__decap_12
XFILLER_137_57 VPWR VGND VPWR VGND sky130_ef_sc_hd__decap_12
XFILLER_133_221 VGND VGND VPWR VPWR sky130_fd_sc_hd__decap_3
XFILLER_118_295 VGND VGND VPWR VPWR sky130_fd_sc_hd__fill_2
X_07059_ net1269 net365 net209 VGND VGND VPWR VPWR _00099_ sky130_fd_sc_hd__mux2_1
XFILLER_0_713 VPWR VGND VPWR VGND sky130_ef_sc_hd__decap_12
XFILLER_121_449 VGND VGND VPWR VPWR sky130_fd_sc_hd__fill_1
XFILLER_102_630 VGND VGND VPWR VPWR sky130_fd_sc_hd__decap_3
X_10070_ _03706_ _03709_ VGND VGND VPWR VPWR _03822_ sky130_fd_sc_hd__nand2_1
XPHY_EDGE_ROW_102_Right_102 VGND VGND VPWR VPWR sky130_fd_sc_hd__decap_3
XFILLER_48_728 VGND VGND VPWR VPWR sky130_fd_sc_hd__decap_3
XFILLER_48_717 VGND VGND VPWR VPWR sky130_fd_sc_hd__decap_6
XFILLER_0_757 VPWR VGND VPWR VGND sky130_ef_sc_hd__decap_12
X_10972_ _04614_ _04616_ _04713_ VGND VGND VPWR VPWR _04716_ sky130_fd_sc_hd__a21o_1
XTAP_TAPCELL_ROW_48_1101 VGND VPWR sky130_fd_sc_hd__tapvpwrvgnd_1
X_13760_ clknet_leaf_82_clk _00770_ VGND VGND VPWR VPWR u_interface.u_gelu_fp32.u_q16_to_fp32.s1_mag\[26\]
+ sky130_fd_sc_hd__dfxtp_1
XFILLER_46_54 VGND VGND VPWR VPWR sky130_fd_sc_hd__decap_6
XFILLER_16_625 VPWR VGND VPWR VGND sky130_ef_sc_hd__decap_12
XFILLER_28_474 VGND VGND VPWR VPWR sky130_fd_sc_hd__fill_2
X_13691_ clknet_leaf_13_clk _00701_ VGND VGND VPWR VPWR u_interface.u_gelu_fp32.u_fp32_to_q16.s3_frac\[27\]
+ sky130_fd_sc_hd__dfxtp_1
X_12711_ net781 net1746 _06363_ _06366_ VGND VGND VPWR VPWR _00921_ sky130_fd_sc_hd__o211a_1
XFILLER_15_113 VPWR VGND VPWR VGND sky130_ef_sc_hd__decap_12
X_12642_ net825 net1584 _06339_ _06340_ VGND VGND VPWR VPWR _00878_ sky130_fd_sc_hd__a22o_1
XFILLER_16_669 VPWR VGND VPWR VGND sky130_ef_sc_hd__decap_12
XFILLER_31_617 VPWR VGND VPWR VGND sky130_ef_sc_hd__decap_12
XFILLER_62_42 VGND VGND VPWR VPWR sky130_fd_sc_hd__decap_6
XTAP_TAPCELL_ROW_61_1312 VGND VPWR sky130_fd_sc_hd__tapvpwrvgnd_1
XTAP_TAPCELL_ROW_139_2559 VGND VPWR sky130_fd_sc_hd__tapvpwrvgnd_1
XFILLER_129_505 VGND VGND VPWR VPWR sky130_fd_sc_hd__decap_3
X_12573_ net773 u_interface.u_gelu_fp32.u_synth_top.s2_b\[17\] VGND VGND VPWR VPWR
+ _00871_ sky130_fd_sc_hd__and2_1
XFILLER_62_97 VGND VGND VPWR VPWR sky130_fd_sc_hd__decap_8
XFILLER_8_813 VPWR VGND VPWR VGND sky130_ef_sc_hd__decap_12
XFILLER_30_138 VGND VGND VPWR VPWR sky130_fd_sc_hd__fill_2
XFILLER_7_15 VPWR VGND VPWR VGND sky130_ef_sc_hd__decap_12
X_11524_ _05261_ _05262_ _05255_ VGND VGND VPWR VPWR _05263_ sky130_fd_sc_hd__a21oi_1
XFILLER_11_396 VPWR VGND VPWR VGND sky130_ef_sc_hd__decap_12
XFILLER_7_334 VGND VGND VPWR VPWR sky130_fd_sc_hd__fill_2
X_11455_ _05161_ _05194_ VGND VGND VPWR VPWR _05195_ sky130_fd_sc_hd__xnor2_2
XFILLER_137_571 VGND VGND VPWR VPWR sky130_fd_sc_hd__decap_6
XFILLER_125_733 VGND VGND VPWR VPWR sky130_fd_sc_hd__fill_1
Xwire287 _01143_ VGND VGND VPWR VPWR net287 sky130_fd_sc_hd__buf_1
Xwire276 _01189_ VGND VGND VPWR VPWR net276 sky130_fd_sc_hd__buf_1
X_10406_ net635 net644 net445 net440 VGND VGND VPWR VPWR _04155_ sky130_fd_sc_hd__and4_1
XFILLER_7_367 VPWR VGND VPWR VGND sky130_ef_sc_hd__decap_12
XFILLER_152_552 VGND VGND VPWR VPWR sky130_fd_sc_hd__fill_2
XFILLER_124_210 VGND VGND VPWR VPWR sky130_fd_sc_hd__decap_3
XTAP_TAPCELL_ROW_59_1285 VGND VPWR sky130_fd_sc_hd__tapvpwrvgnd_1
XTAP_TAPCELL_ROW_59_1274 VGND VPWR sky130_fd_sc_hd__tapvpwrvgnd_1
X_11386_ _05124_ _05125_ VGND VGND VPWR VPWR _05126_ sky130_fd_sc_hd__nor2_1
X_13125_ clknet_leaf_43_clk _00135_ VGND VGND VPWR VPWR u_interface.fifo_data\[2\]\[14\]
+ sky130_fd_sc_hd__dfxtp_1
XFILLER_112_405 VGND VGND VPWR VPWR sky130_fd_sc_hd__decap_6
X_10337_ _03977_ _03985_ _03986_ VGND VGND VPWR VPWR _04086_ sky130_fd_sc_hd__a21bo_1
XFILLER_3_573 VPWR VGND VPWR VGND sky130_ef_sc_hd__decap_12
X_10268_ net453 net457 net653 net661 VGND VGND VPWR VPWR _04018_ sky130_fd_sc_hd__nand4_1
X_13056_ clknet_leaf_71_clk _00066_ VGND VGND VPWR VPWR u_interface.fifo_data\[14\]\[9\]
+ sky130_fd_sc_hd__dfxtp_1
XTAP_TAPCELL_ROW_72_1485 VGND VPWR sky130_fd_sc_hd__tapvpwrvgnd_1
X_12007_ _05671_ _05673_ VGND VGND VPWR VPWR _05740_ sky130_fd_sc_hd__nand2_1
XFILLER_39_706 VGND VGND VPWR VPWR sky130_fd_sc_hd__decap_3
XFILLER_93_311 VGND VGND VPWR VPWR sky130_fd_sc_hd__fill_1
X_10199_ _03948_ _03949_ _03841_ VGND VGND VPWR VPWR _03950_ sky130_fd_sc_hd__a21o_1
XFILLER_93_333 VGND VGND VPWR VPWR sky130_fd_sc_hd__decap_3
X_13958_ clknet_leaf_57_clk net1705 VGND VGND VPWR VPWR u_interface.u_gelu_fp32.u_q16_to_fp32.s2_mag\[3\]
+ sky130_fd_sc_hd__dfxtp_1
XTAP_TAPCELL_ROW_37_929 VGND VPWR sky130_fd_sc_hd__tapvpwrvgnd_1
X_12909_ net787 _01524_ _06437_ VGND VGND VPWR VPWR _01052_ sky130_fd_sc_hd__and3_1
XFILLER_62_720 VGND VGND VPWR VPWR sky130_fd_sc_hd__fill_1
XFILLER_46_293 VGND VGND VPWR VPWR sky130_fd_sc_hd__fill_1
X_13889_ clknet_leaf_90_clk _00025_ VGND VGND VPWR VPWR u_interface.u_gelu_fp32.u_synth_top.s2_dx\[25\]
+ sky130_fd_sc_hd__dfxtp_1
XFILLER_61_252 VGND VGND VPWR VPWR sky130_fd_sc_hd__fill_1
XFILLER_34_477 VGND VGND VPWR VPWR sky130_fd_sc_hd__fill_1
XFILLER_21_105 VGND VGND VPWR VPWR sky130_fd_sc_hd__decap_6
XFILLER_148_836 VGND VGND VPWR VPWR sky130_fd_sc_hd__fill_1
XFILLER_147_313 VPWR VGND VPWR VGND sky130_ef_sc_hd__decap_12
X_09080_ _02836_ _02837_ _02838_ VGND VGND VPWR VPWR _02839_ sky130_fd_sc_hd__or3_1
X_08100_ _01942_ _01943_ net313 VGND VGND VPWR VPWR _01949_ sky130_fd_sc_hd__a21oi_1
XTAP_TAPCELL_ROW_79_1606 VGND VPWR sky130_fd_sc_hd__tapvpwrvgnd_1
Xinput40 s_axil_awaddr[13] VGND VGND VPWR VPWR net40 sky130_fd_sc_hd__clkbuf_1
X_08031_ u_interface.u_gelu_fp32.u_fp32_to_q16.s3_mag\[22\] u_interface.u_gelu_fp32.u_fp32_to_q16.s3_mag\[21\]
+ _01887_ VGND VGND VPWR VPWR _01888_ sky130_fd_sc_hd__and3_1
Xinput62 s_axil_awaddr[4] VGND VGND VPWR VPWR net62 sky130_fd_sc_hd__clkbuf_1
Xinput73 s_axil_wvalid VGND VGND VPWR VPWR net73 sky130_fd_sc_hd__buf_1
Xinput51 s_axil_awaddr[23] VGND VGND VPWR VPWR net51 sky130_fd_sc_hd__clkbuf_1
Xhold802 _00751_ VGND VGND VPWR VPWR net1667 sky130_fd_sc_hd__dlygate4sd3_1
Xinput84 s_axis_tdata[19] VGND VGND VPWR VPWR net84 sky130_fd_sc_hd__clkbuf_1
Xhold846 u_interface.fifo_rd_ptr\[2\] VGND VGND VPWR VPWR net1711 sky130_fd_sc_hd__dlygate4sd3_1
Xinput95 s_axis_tdata[29] VGND VGND VPWR VPWR net95 sky130_fd_sc_hd__clkbuf_1
XFILLER_116_755 VGND VGND VPWR VPWR sky130_fd_sc_hd__fill_1
XTAP_TAPCELL_ROW_92_1806 VGND VPWR sky130_fd_sc_hd__tapvpwrvgnd_1
Xhold824 _00883_ VGND VGND VPWR VPWR net1689 sky130_fd_sc_hd__dlygate4sd3_1
Xhold835 _00898_ VGND VGND VPWR VPWR net1700 sky130_fd_sc_hd__dlygate4sd3_1
Xhold813 _00899_ VGND VGND VPWR VPWR net1678 sky130_fd_sc_hd__dlygate4sd3_1
X_09982_ _03621_ _03623_ _03731_ _03733_ VGND VGND VPWR VPWR _03735_ sky130_fd_sc_hd__o211ai_1
Xhold879 u_interface.u_gelu_fp32.u_synth_top.s2_b\[8\] VGND VGND VPWR VPWR net1744
+ sky130_fd_sc_hd__dlygate4sd3_1
Xhold868 u_interface.u_gelu_fp32.u_q16_to_fp32.s3_norm_mag\[19\] VGND VGND VPWR VPWR
+ net1733 sky130_fd_sc_hd__dlygate4sd3_1
Xhold857 u_interface.u_gelu_fp32.u_q16_to_fp32.s2_mag\[26\] VGND VGND VPWR VPWR net1722
+ sky130_fd_sc_hd__dlygate4sd3_1
XFILLER_130_213 VGND VGND VPWR VPWR sky130_fd_sc_hd__decap_6
X_08933_ _02542_ _02544_ _02688_ _02689_ VGND VGND VPWR VPWR _02692_ sky130_fd_sc_hd__a211o_1
XFILLER_69_352 VPWR VGND VPWR VGND sky130_ef_sc_hd__decap_12
XFILLER_69_341 VGND VGND VPWR VPWR sky130_fd_sc_hd__fill_1
XFILLER_57_503 VGND VGND VPWR VPWR sky130_fd_sc_hd__fill_1
XFILLER_123_15 VGND VGND VPWR VPWR sky130_fd_sc_hd__fill_2
X_08864_ _02619_ _02621_ _02618_ VGND VGND VPWR VPWR _02623_ sky130_fd_sc_hd__a21o_1
XPHY_EDGE_ROW_150_Left_306 VGND VGND VPWR VPWR sky130_fd_sc_hd__decap_3
X_08795_ net582 net470 u_interface.u_gelu_fp32.u_synth_top.s2_dx\[11\] net590 VGND
+ VGND VPWR VPWR _02554_ sky130_fd_sc_hd__a22oi_1
X_07815_ net1319 net358 net231 VGND VGND VPWR VPWR _00576_ sky130_fd_sc_hd__mux2_1
XTAP_TAPCELL_ROW_123_2305 VGND VPWR sky130_fd_sc_hd__tapvpwrvgnd_1
XFILLER_84_333 VPWR VGND VPWR VGND sky130_ef_sc_hd__decap_12
XFILLER_84_388 VGND VGND VPWR VPWR sky130_fd_sc_hd__decap_4
X_07746_ u_interface.u_gelu_fp32.u_q16_to_fp32.s3_norm_mag\[29\] u_interface.u_gelu_fp32.u_q16_to_fp32.s3_norm_mag\[30\]
+ _01789_ VGND VGND VPWR VPWR _01790_ sky130_fd_sc_hd__and3_1
XFILLER_44_219 VGND VGND VPWR VPWR sky130_fd_sc_hd__fill_2
XFILLER_25_411 VGND VGND VPWR VPWR sky130_fd_sc_hd__decap_4
XFILLER_25_422 VPWR VGND VPWR VGND sky130_ef_sc_hd__decap_12
XFILLER_37_271 VGND VGND VPWR VPWR sky130_fd_sc_hd__decap_8
XFILLER_38_794 VGND VGND VPWR VPWR sky130_fd_sc_hd__fill_1
X_09416_ _03170_ _03173_ VGND VGND VPWR VPWR _03174_ sky130_fd_sc_hd__nor2_1
X_07677_ net386 u_interface.u_gelu_fp32.u_synth_top.s1_hits\[12\] _00486_ _01753_
+ VGND VGND VPWR VPWR _00489_ sky130_fd_sc_hd__or4_1
XFILLER_13_617 VPWR VGND VPWR VGND sky130_ef_sc_hd__decap_12
XFILLER_25_466 VGND VGND VPWR VPWR sky130_fd_sc_hd__decap_3
X_06628_ _01198_ _01200_ _01203_ net319 VGND VGND VPWR VPWR net141 sky130_fd_sc_hd__a22o_1
XFILLER_25_499 VGND VGND VPWR VPWR sky130_fd_sc_hd__decap_4
X_09347_ _03080_ _03082_ VGND VGND VPWR VPWR _03106_ sky130_fd_sc_hd__xnor2_1
XTAP_TAPCELL_ROW_101_1957 VGND VPWR sky130_fd_sc_hd__tapvpwrvgnd_1
XTAP_TAPCELL_ROW_101_1946 VGND VPWR sky130_fd_sc_hd__tapvpwrvgnd_1
X_06559_ _01140_ _01153_ VGND VGND VPWR VPWR _00011_ sky130_fd_sc_hd__and2b_1
XTAP_TAPCELL_ROW_43_1031 VGND VPWR sky130_fd_sc_hd__tapvpwrvgnd_1
XFILLER_8_109 VPWR VGND VPWR VGND sky130_ef_sc_hd__decap_12
XFILLER_40_458 VGND VGND VPWR VPWR sky130_fd_sc_hd__decap_3
XTAP_TAPCELL_ROW_43_1020 VGND VPWR sky130_fd_sc_hd__tapvpwrvgnd_1
X_09278_ _02991_ _02992_ _02986_ VGND VGND VPWR VPWR _03037_ sky130_fd_sc_hd__a21bo_1
XFILLER_148_45 VGND VGND VPWR VPWR sky130_fd_sc_hd__fill_1
X_08229_ _01893_ _02056_ VGND VGND VPWR VPWR _02057_ sky130_fd_sc_hd__or2_1
XFILLER_32_89 VGND VGND VPWR VPWR sky130_fd_sc_hd__fill_1
XFILLER_153_305 VPWR VGND VPWR VGND sky130_ef_sc_hd__decap_12
XFILLER_147_880 VGND VGND VPWR VPWR sky130_fd_sc_hd__decap_4
XTAP_TAPCELL_ROW_134_2478 VGND VPWR sky130_fd_sc_hd__tapvpwrvgnd_1
XFILLER_106_3 VGND VGND VPWR VPWR sky130_fd_sc_hd__fill_2
X_11240_ _04980_ _04981_ VGND VGND VPWR VPWR _04982_ sky130_fd_sc_hd__nor2_1
XFILLER_134_552 VGND VGND VPWR VPWR sky130_fd_sc_hd__fill_1
XFILLER_79_105 VGND VGND VPWR VPWR sky130_fd_sc_hd__fill_1
X_11171_ _04906_ _04912_ _04913_ VGND VGND VPWR VPWR _00824_ sky130_fd_sc_hd__o21a_1
XFILLER_134_585 VGND VGND VPWR VPWR sky130_fd_sc_hd__decap_3
X_10122_ _03871_ _03872_ _03866_ VGND VGND VPWR VPWR _03873_ sky130_fd_sc_hd__a21o_1
XFILLER_121_279 VGND VGND VPWR VPWR sky130_fd_sc_hd__fill_1
X_10053_ _03716_ _03718_ VGND VGND VPWR VPWR _03805_ sky130_fd_sc_hd__nand2b_1
XTAP_TAPCELL_ROW_54_1193 VGND VPWR sky130_fd_sc_hd__tapvpwrvgnd_1
XFILLER_87_193 VGND VGND VPWR VPWR sky130_fd_sc_hd__decap_8
XFILLER_91_837 VGND VGND VPWR VPWR sky130_fd_sc_hd__decap_3
X_13812_ clknet_leaf_87_clk _00822_ VGND VGND VPWR VPWR u_interface.u_gelu_fp32.u_synth_top.s3_mult\[30\]
+ sky130_fd_sc_hd__dfxtp_1
XTAP_TAPCELL_ROW_3_381 VGND VPWR sky130_fd_sc_hd__tapvpwrvgnd_1
XFILLER_29_783 VGND VGND VPWR VPWR sky130_fd_sc_hd__fill_1
XFILLER_35_219 VGND VGND VPWR VPWR sky130_fd_sc_hd__decap_4
XFILLER_90_336 VGND VGND VPWR VPWR sky130_fd_sc_hd__fill_1
XFILLER_28_293 VGND VGND VPWR VPWR sky130_fd_sc_hd__fill_1
X_13743_ clknet_leaf_59_clk _00753_ VGND VGND VPWR VPWR u_interface.u_gelu_fp32.u_q16_to_fp32.s1_mag\[9\]
+ sky130_fd_sc_hd__dfxtp_1
X_10955_ _04226_ _04698_ VGND VGND VPWR VPWR _04699_ sky130_fd_sc_hd__xnor2_1
X_13674_ clknet_leaf_11_clk _00684_ VGND VGND VPWR VPWR u_interface.u_gelu_fp32.u_fp32_to_q16.s3_frac\[10\]
+ sky130_fd_sc_hd__dfxtp_1
X_10886_ _04629_ _04630_ VGND VGND VPWR VPWR _04631_ sky130_fd_sc_hd__or2_1
XFILLER_16_477 VGND VGND VPWR VPWR sky130_fd_sc_hd__decap_3
XFILLER_16_488 VGND VGND VPWR VPWR sky130_fd_sc_hd__decap_6
X_12625_ _06323_ _06327_ _06320_ VGND VGND VPWR VPWR _06328_ sky130_fd_sc_hd__a21boi_1
XFILLER_31_447 VGND VGND VPWR VPWR sky130_fd_sc_hd__fill_1
XFILLER_129_324 VPWR VGND VPWR VGND sky130_ef_sc_hd__decap_12
X_12556_ net783 u_interface.u_gelu_fp32.u_synth_top.s2_b\[0\] VGND VGND VPWR VPWR
+ _00854_ sky130_fd_sc_hd__and2_1
XFILLER_8_643 VGND VGND VPWR VPWR sky130_fd_sc_hd__fill_1
X_11507_ _05149_ _05151_ _05150_ VGND VGND VPWR VPWR _05246_ sky130_fd_sc_hd__a21bo_1
XFILLER_11_193 VGND VGND VPWR VPWR sky130_fd_sc_hd__decap_6
X_12487_ net191 _06212_ VGND VGND VPWR VPWR _06213_ sky130_fd_sc_hd__xnor2_1
XTAP_TAPCELL_ROW_74_1514 VGND VPWR sky130_fd_sc_hd__tapvpwrvgnd_1
X_11438_ net611 net387 VGND VGND VPWR VPWR _05178_ sky130_fd_sc_hd__and2b_1
Xhold109 u_interface.fifo_data\[13\]\[2\] VGND VGND VPWR VPWR net974 sky130_fd_sc_hd__dlygate4sd3_1
X_14157_ clknet_leaf_26_clk _01083_ VGND VGND VPWR VPWR u_interface.fifo_data\[1\]\[17\]
+ sky130_fd_sc_hd__dfxtp_1
XFILLER_98_414 VGND VGND VPWR VPWR sky130_fd_sc_hd__decap_6
XTAP_TAPCELL_ROW_74_1525 VGND VPWR sky130_fd_sc_hd__tapvpwrvgnd_1
X_11369_ _05023_ _05109_ VGND VGND VPWR VPWR _05110_ sky130_fd_sc_hd__xnor2_1
XFILLER_140_533 VGND VGND VPWR VPWR sky130_fd_sc_hd__decap_4
XFILLER_112_202 VPWR VGND VPWR VGND sky130_ef_sc_hd__decap_12
X_13108_ clknet_leaf_45_clk _00118_ VGND VGND VPWR VPWR u_interface.fifo_data\[15\]\[29\]
+ sky130_fd_sc_hd__dfxtp_1
XFILLER_4_893 VPWR VGND VPWR VGND sky130_ef_sc_hd__decap_12
X_14088_ clknet_leaf_16_clk net1421 VGND VGND VPWR VPWR u_interface.u_gelu_fp32.u_fp32_to_q16.s2_norm_mag\[25\]
+ sky130_fd_sc_hd__dfxtp_1
X_13039_ clknet_leaf_35_clk _00049_ VGND VGND VPWR VPWR u_interface.fifo_tuser\[6\]
+ sky130_fd_sc_hd__dfxtp_1
XFILLER_21_3 VPWR VGND VPWR VGND sky130_ef_sc_hd__decap_12
XFILLER_27_709 VPWR VGND VPWR VGND sky130_ef_sc_hd__decap_12
XTAP_TAPCELL_ROW_105_2013 VGND VPWR sky130_fd_sc_hd__tapvpwrvgnd_1
X_08580_ _02218_ net159 _02367_ VGND VGND VPWR VPWR _02368_ sky130_fd_sc_hd__nand3b_1
X_07600_ net306 net298 VGND VGND VPWR VPWR _01696_ sky130_fd_sc_hd__and2_1
XFILLER_66_355 VGND VGND VPWR VPWR sky130_fd_sc_hd__decap_8
XFILLER_54_517 VGND VGND VPWR VPWR sky130_fd_sc_hd__fill_1
XFILLER_26_208 VGND VGND VPWR VPWR sky130_fd_sc_hd__fill_2
X_07531_ _01567_ _01549_ net547 VGND VGND VPWR VPWR _01659_ sky130_fd_sc_hd__mux2_1
XFILLER_19_260 VGND VGND VPWR VPWR sky130_fd_sc_hd__fill_2
XFILLER_19_271 VGND VGND VPWR VPWR sky130_fd_sc_hd__decap_8
XFILLER_19_293 VPWR VGND VPWR VGND sky130_ef_sc_hd__decap_12
XFILLER_50_701 VGND VGND VPWR VPWR sky130_fd_sc_hd__decap_6
X_07462_ net554 u_interface.u_gelu_fp32.u_fp32_to_q16.s2_norm_mag\[8\] net560 VGND
+ VGND VPWR VPWR _01597_ sky130_fd_sc_hd__and3_1
XTAP_TAPCELL_ROW_85_1698 VGND VPWR sky130_fd_sc_hd__tapvpwrvgnd_1
XFILLER_22_414 VGND VGND VPWR VPWR sky130_fd_sc_hd__decap_6
XFILLER_34_274 VGND VGND VPWR VPWR sky130_fd_sc_hd__decap_8
XFILLER_35_797 VPWR VGND VPWR VGND sky130_ef_sc_hd__decap_12
X_09201_ _02914_ _02915_ _02959_ VGND VGND VPWR VPWR _02960_ sky130_fd_sc_hd__nand3_1
X_07393_ net1407 net571 net240 VGND VGND VPWR VPWR _00423_ sky130_fd_sc_hd__mux2_1
XFILLER_22_458 VPWR VGND VPWR VGND sky130_ef_sc_hd__decap_12
XFILLER_147_110 VGND VGND VPWR VPWR sky130_fd_sc_hd__fill_2
X_09132_ _02839_ _02885_ _02890_ VGND VGND VPWR VPWR _02891_ sky130_fd_sc_hd__nand3_1
XTAP_TAPCELL_ROW_20_648 VGND VPWR sky130_fd_sc_hd__tapvpwrvgnd_1
X_09063_ _02781_ _02782_ _02799_ VGND VGND VPWR VPWR _02822_ sky130_fd_sc_hd__o21ai_1
XTAP_TAPCELL_ROW_20_659 VGND VPWR sky130_fd_sc_hd__tapvpwrvgnd_1
X_08014_ net788 net932 VGND VGND VPWR VPWR _00709_ sky130_fd_sc_hd__and2_1
XTAP_TAPCELL_ROW_116_2186 VGND VPWR sky130_fd_sc_hd__tapvpwrvgnd_1
Xhold621 u_interface.fifo_data\[15\]\[23\] VGND VGND VPWR VPWR net1486 sky130_fd_sc_hd__dlygate4sd3_1
Xhold610 u_interface.fifo_data\[4\]\[20\] VGND VGND VPWR VPWR net1475 sky130_fd_sc_hd__dlygate4sd3_1
Xhold632 u_interface.fifo_data\[11\]\[10\] VGND VGND VPWR VPWR net1497 sky130_fd_sc_hd__dlygate4sd3_1
XTAP_TAPCELL_ROW_116_2197 VGND VPWR sky130_fd_sc_hd__tapvpwrvgnd_1
Xhold654 u_interface.fifo_data\[7\]\[15\] VGND VGND VPWR VPWR net1519 sky130_fd_sc_hd__dlygate4sd3_1
Xhold643 u_interface.fifo_data\[3\]\[12\] VGND VGND VPWR VPWR net1508 sky130_fd_sc_hd__dlygate4sd3_1
Xhold687 u_interface.u_gelu_fp32.u_fp32_to_q16.s3_frac\[3\] VGND VGND VPWR VPWR net1552
+ sky130_fd_sc_hd__dlygate4sd3_1
XFILLER_116_585 VGND VGND VPWR VPWR sky130_fd_sc_hd__decap_3
Xhold676 _00931_ VGND VGND VPWR VPWR net1541 sky130_fd_sc_hd__dlygate4sd3_1
Xhold665 u_interface.fifo_data\[3\]\[0\] VGND VGND VPWR VPWR net1530 sky130_fd_sc_hd__dlygate4sd3_1
XFILLER_1_329 VGND VGND VPWR VPWR sky130_fd_sc_hd__decap_6
XFILLER_134_25 VGND VGND VPWR VPWR sky130_fd_sc_hd__decap_3
XFILLER_131_555 VGND VGND VPWR VPWR sky130_fd_sc_hd__decap_4
X_09965_ _03703_ _03715_ _03716_ VGND VGND VPWR VPWR _03718_ sky130_fd_sc_hd__or3_1
Xhold698 u_interface.fifo_data\[7\]\[9\] VGND VGND VPWR VPWR net1563 sky130_fd_sc_hd__dlygate4sd3_1
X_08916_ _02439_ _02674_ VGND VGND VPWR VPWR _02675_ sky130_fd_sc_hd__nand2_1
XFILLER_103_279 VGND VGND VPWR VPWR sky130_fd_sc_hd__fill_1
X_09896_ _03646_ _03647_ _03549_ _03551_ VGND VGND VPWR VPWR _03649_ sky130_fd_sc_hd__o211a_1
X_08847_ _02604_ _02605_ VGND VGND VPWR VPWR _02606_ sky130_fd_sc_hd__and2b_1
XFILLER_97_491 VPWR VGND VPWR VGND sky130_ef_sc_hd__decap_12
XFILLER_73_826 VPWR VGND VPWR VGND sky130_ef_sc_hd__decap_12
XFILLER_57_377 VGND VGND VPWR VPWR sky130_fd_sc_hd__decap_3
XFILLER_45_517 VGND VGND VPWR VPWR sky130_fd_sc_hd__fill_2
X_08778_ net646 net489 net654 net494 VGND VGND VPWR VPWR _02537_ sky130_fd_sc_hd__nand4_1
XFILLER_57_399 VPWR VGND VPWR VGND sky130_ef_sc_hd__decap_12
X_07729_ net1786 _01754_ _01772_ VGND VGND VPWR VPWR _00521_ sky130_fd_sc_hd__or3_1
XTAP_TAPCELL_ROW_0_340 VGND VPWR sky130_fd_sc_hd__tapvpwrvgnd_1
X_10740_ _04483_ _04484_ _04390_ _04392_ VGND VGND VPWR VPWR _04486_ sky130_fd_sc_hd__o211a_1
XFILLER_25_285 VGND VGND VPWR VPWR sky130_fd_sc_hd__fill_1
X_10671_ _04416_ _04417_ _04298_ _04300_ VGND VGND VPWR VPWR _04418_ sky130_fd_sc_hd__a211o_1
XFILLER_13_447 VGND VGND VPWR VPWR sky130_fd_sc_hd__fill_1
XFILLER_13_458 VGND VGND VPWR VPWR sky130_fd_sc_hd__decap_8
XFILLER_43_55 VGND VGND VPWR VPWR sky130_fd_sc_hd__fill_1
XTAP_TAPCELL_ROW_136_2518 VGND VPWR sky130_fd_sc_hd__tapvpwrvgnd_1
XTAP_TAPCELL_ROW_136_2507 VGND VPWR sky130_fd_sc_hd__tapvpwrvgnd_1
X_12410_ net718 _01112_ _06024_ _06082_ VGND VGND VPWR VPWR _06137_ sky130_fd_sc_hd__o211a_1
X_13390_ clknet_leaf_69_clk _00400_ VGND VGND VPWR VPWR u_interface.fifo_data\[6\]\[3\]
+ sky130_fd_sc_hd__dfxtp_1
XFILLER_21_491 VPWR VGND VPWR VGND sky130_ef_sc_hd__decap_12
X_12341_ _06006_ _06009_ net177 VGND VGND VPWR VPWR _06069_ sky130_fd_sc_hd__o21a_1
XFILLER_153_113 VGND VGND VPWR VPWR sky130_fd_sc_hd__decap_3
XFILLER_126_338 VGND VGND VPWR VPWR sky130_fd_sc_hd__decap_3
XFILLER_119_390 VGND VGND VPWR VPWR sky130_fd_sc_hd__fill_2
X_12272_ net177 _05944_ _05947_ VGND VGND VPWR VPWR _06001_ sky130_fd_sc_hd__nor3_1
XFILLER_141_319 VGND VGND VPWR VPWR sky130_fd_sc_hd__decap_4
XFILLER_135_850 VGND VGND VPWR VPWR sky130_fd_sc_hd__decap_6
X_14011_ clknet_leaf_54_clk _00937_ VGND VGND VPWR VPWR u_interface.u_gelu_fp32.u_q16_to_fp32.s3_is_zero
+ sky130_fd_sc_hd__dfxtp_1
X_11223_ _04946_ _04964_ VGND VGND VPWR VPWR _04965_ sky130_fd_sc_hd__xor2_2
XFILLER_134_360 VGND VGND VPWR VPWR sky130_fd_sc_hd__decap_4
XFILLER_122_533 VGND VGND VPWR VPWR sky130_fd_sc_hd__decap_6
XFILLER_122_522 VGND VGND VPWR VPWR sky130_fd_sc_hd__decap_8
XFILLER_122_511 VGND VGND VPWR VPWR sky130_fd_sc_hd__decap_3
XTAP_TAPCELL_ROW_56_1233 VGND VPWR sky130_fd_sc_hd__tapvpwrvgnd_1
XFILLER_4_189 VGND VGND VPWR VPWR sky130_fd_sc_hd__decap_6
XFILLER_4_27 VGND VGND VPWR VPWR sky130_fd_sc_hd__fill_1
X_11154_ _04794_ _04896_ VGND VGND VPWR VPWR _04897_ sky130_fd_sc_hd__xnor2_1
XTAP_TAPCELL_ROW_8_462 VGND VPWR sky130_fd_sc_hd__tapvpwrvgnd_1
XFILLER_1_841 VPWR VGND VPWR VGND sky130_ef_sc_hd__decap_12
XFILLER_95_417 VGND VGND VPWR VPWR sky130_fd_sc_hd__decap_6
X_10105_ _03855_ _03856_ _03748_ VGND VGND VPWR VPWR _03857_ sky130_fd_sc_hd__a21oi_1
XFILLER_68_85 VGND VGND VPWR VPWR sky130_fd_sc_hd__decap_8
X_11085_ _04826_ _04827_ _04811_ VGND VGND VPWR VPWR _04828_ sky130_fd_sc_hd__a21oi_1
X_10036_ net619 net446 net441 net610 VGND VGND VPWR VPWR _03788_ sky130_fd_sc_hd__a22o_1
XFILLER_48_377 VPWR VGND VPWR VGND sky130_ef_sc_hd__decap_12
XFILLER_76_697 VGND VGND VPWR VPWR sky130_fd_sc_hd__decap_3
XFILLER_36_528 VGND VGND VPWR VPWR sky130_fd_sc_hd__decap_4
XFILLER_16_230 VGND VGND VPWR VPWR sky130_fd_sc_hd__decap_8
XFILLER_17_753 VPWR VGND VPWR VGND sky130_ef_sc_hd__decap_12
X_11987_ _05649_ _05718_ VGND VGND VPWR VPWR _05721_ sky130_fd_sc_hd__xnor2_1
X_13726_ clknet_leaf_7_clk _00736_ VGND VGND VPWR VPWR u_interface.u_gelu_fp32.s1_data\[26\]
+ sky130_fd_sc_hd__dfxtp_1
XFILLER_72_892 VGND VGND VPWR VPWR sky130_fd_sc_hd__fill_1
X_10938_ _03172_ _04680_ VGND VGND VPWR VPWR _04682_ sky130_fd_sc_hd__or2_1
XFILLER_17_797 VPWR VGND VPWR VGND sky130_ef_sc_hd__decap_12
XTAP_TAPCELL_ROW_27_770 VGND VPWR sky130_fd_sc_hd__tapvpwrvgnd_1
XFILLER_32_701 VPWR VGND VPWR VGND sky130_ef_sc_hd__decap_12
XFILLER_149_419 VGND VGND VPWR VPWR sky130_fd_sc_hd__fill_1
XFILLER_31_222 VGND VGND VPWR VPWR sky130_fd_sc_hd__fill_2
X_13657_ clknet_leaf_14_clk _00667_ VGND VGND VPWR VPWR u_interface.u_gelu_fp32.u_fp32_to_q16.s1_exp\[3\]
+ sky130_fd_sc_hd__dfxtp_1
X_10869_ _04525_ _04527_ _04612_ VGND VGND VPWR VPWR _04614_ sky130_fd_sc_hd__a21o_1
X_12608_ _06307_ _06310_ VGND VGND VPWR VPWR _06311_ sky130_fd_sc_hd__and2_1
X_13588_ clknet_leaf_73_clk _00598_ VGND VGND VPWR VPWR u_interface.fifo_data\[3\]\[3\]
+ sky130_fd_sc_hd__dfxtp_1
XFILLER_12_491 VPWR VGND VPWR VGND sky130_ef_sc_hd__decap_12
XFILLER_117_316 VPWR VGND VPWR VGND sky130_ef_sc_hd__decap_12
XFILLER_117_305 VGND VGND VPWR VPWR sky130_fd_sc_hd__fill_2
X_12539_ _06184_ _06251_ VGND VGND VPWR VPWR _06263_ sky130_fd_sc_hd__xnor2_1
XFILLER_133_809 VGND VGND VPWR VPWR sky130_fd_sc_hd__decap_8
XFILLER_69_3 VPWR VGND VPWR VGND sky130_ef_sc_hd__decap_12
XFILLER_125_393 VGND VGND VPWR VPWR sky130_fd_sc_hd__fill_2
XFILLER_99_789 VGND VGND VPWR VPWR sky130_fd_sc_hd__fill_1
Xfanout419 u_interface.u_gelu_fp32.u_synth_top.s2_dx\[24\] VGND VGND VPWR VPWR net419
+ sky130_fd_sc_hd__clkbuf_2
Xfanout408 net409 VGND VGND VPWR VPWR net408 sky130_fd_sc_hd__buf_2
XFILLER_141_897 VGND VGND VPWR VPWR sky130_fd_sc_hd__fill_2
X_09750_ _03359_ _03502_ _03503_ VGND VGND VPWR VPWR _03505_ sky130_fd_sc_hd__nand3_2
XFILLER_86_417 VGND VGND VPWR VPWR sky130_fd_sc_hd__decap_3
X_06962_ u_interface.u_gelu_fp32.u_synth_top.s1_x\[30\] net273 VGND VGND VPWR VPWR
+ _01490_ sky130_fd_sc_hd__or2_1
XFILLER_39_300 VGND VGND VPWR VPWR sky130_fd_sc_hd__fill_1
XFILLER_140_396 VPWR VGND VPWR VGND sky130_ef_sc_hd__decap_12
X_08701_ net670 net511 _02458_ _02456_ VGND VGND VPWR VPWR _02460_ sky130_fd_sc_hd__a31oi_1
X_09681_ net466 net471 net640 net648 VGND VGND VPWR VPWR _03436_ sky130_fd_sc_hd__nand4_1
XFILLER_100_249 VGND VGND VPWR VPWR sky130_fd_sc_hd__decap_3
X_06893_ u_interface.u_gelu_fp32.u_synth_top.s1_hits\[15\] u_interface.u_gelu_fp32.u_synth_top.s1_hits\[16\]
+ VGND VGND VPWR VPWR _01435_ sky130_fd_sc_hd__or2_2
XTAP_TAPCELL_ROW_87_1727 VGND VPWR sky130_fd_sc_hd__tapvpwrvgnd_1
XFILLER_66_141 VGND VGND VPWR VPWR sky130_fd_sc_hd__decap_8
X_08632_ _02247_ _02401_ _02246_ VGND VGND VPWR VPWR _02404_ sky130_fd_sc_hd__o21ai_1
XFILLER_39_377 VGND VGND VPWR VPWR sky130_fd_sc_hd__fill_1
X_08563_ _02341_ _02343_ _02344_ _02345_ VGND VGND VPWR VPWR _02354_ sky130_fd_sc_hd__and4_1
X_07514_ net815 net1504 net300 _01644_ VGND VGND VPWR VPWR _00435_ sky130_fd_sc_hd__a22o_1
XFILLER_120_27 VGND VGND VPWR VPWR sky130_fd_sc_hd__fill_1
XTAP_TAPCELL_ROW_25_729 VGND VPWR sky130_fd_sc_hd__tapvpwrvgnd_1
X_08494_ net522 u_interface.u_gelu_fp32.u_synth_top.s3_mult\[43\] _02271_ _02284_
+ VGND VGND VPWR VPWR _02285_ sky130_fd_sc_hd__a211o_1
X_07445_ _01578_ _01579_ net554 VGND VGND VPWR VPWR _01580_ sky130_fd_sc_hd__mux2_1
XFILLER_62_391 VGND VGND VPWR VPWR sky130_fd_sc_hd__decap_6
XFILLER_50_531 VGND VGND VPWR VPWR sky130_fd_sc_hd__fill_1
XTAP_TAPCELL_ROW_118_2226 VGND VPWR sky130_fd_sc_hd__tapvpwrvgnd_1
X_07376_ net1169 net366 net237 VGND VGND VPWR VPWR _00406_ sky130_fd_sc_hd__mux2_1
XFILLER_50_597 VGND VGND VPWR VPWR sky130_fd_sc_hd__fill_2
X_09115_ net582 net590 net487 net492 VGND VGND VPWR VPWR _02874_ sky130_fd_sc_hd__and4_1
XFILLER_13_69 VPWR VGND VPWR VGND sky130_ef_sc_hd__decap_12
X_09046_ _02754_ _02755_ _02710_ VGND VGND VPWR VPWR _02805_ sky130_fd_sc_hd__a21o_1
XTAP_TAPCELL_ROW_131_2437 VGND VPWR sky130_fd_sc_hd__tapvpwrvgnd_1
XTAP_TAPCELL_ROW_131_2426 VGND VPWR sky130_fd_sc_hd__tapvpwrvgnd_1
XFILLER_150_127 VGND VGND VPWR VPWR sky130_fd_sc_hd__fill_1
Xhold462 u_interface.fifo_tuser\[1\] VGND VGND VPWR VPWR net1327 sky130_fd_sc_hd__dlygate4sd3_1
Xhold451 u_interface.fifo_data\[13\]\[26\] VGND VGND VPWR VPWR net1316 sky130_fd_sc_hd__dlygate4sd3_1
Xhold440 u_interface.fifo_data\[5\]\[7\] VGND VGND VPWR VPWR net1305 sky130_fd_sc_hd__dlygate4sd3_1
Xhold484 u_interface.fifo_tlast\[11\] VGND VGND VPWR VPWR net1349 sky130_fd_sc_hd__dlygate4sd3_1
XFILLER_145_57 VGND VGND VPWR VPWR sky130_fd_sc_hd__decap_4
XFILLER_116_393 VPWR VGND VPWR VGND sky130_ef_sc_hd__decap_12
Xhold473 u_interface.fifo_data\[14\]\[29\] VGND VGND VPWR VPWR net1338 sky130_fd_sc_hd__dlygate4sd3_1
XFILLER_104_533 VGND VGND VPWR VPWR sky130_fd_sc_hd__decap_4
Xmax_cap181 _04064_ VGND VGND VPWR VPWR net181 sky130_fd_sc_hd__buf_1
XFILLER_78_918 VGND VGND VPWR VPWR sky130_fd_sc_hd__decap_3
Xhold495 u_interface.fifo_data\[13\]\[15\] VGND VGND VPWR VPWR net1360 sky130_fd_sc_hd__dlygate4sd3_1
XFILLER_1_137 VPWR VGND VPWR VGND sky130_ef_sc_hd__decap_12
XFILLER_145_79 VPWR VGND VPWR VGND sky130_ef_sc_hd__decap_12
XFILLER_131_374 VPWR VGND VPWR VGND sky130_ef_sc_hd__decap_12
X_09948_ _03696_ _03697_ _03698_ VGND VGND VPWR VPWR _03701_ sky130_fd_sc_hd__and3_1
XTAP_TAPCELL_ROW_5_421 VGND VPWR sky130_fd_sc_hd__tapvpwrvgnd_1
XTAP_TAPCELL_ROW_5_410 VGND VPWR sky130_fd_sc_hd__tapvpwrvgnd_1
XTAP_TAPCELL_ROW_51_1152 VGND VPWR sky130_fd_sc_hd__tapvpwrvgnd_1
XFILLER_38_44 VGND VGND VPWR VPWR sky130_fd_sc_hd__decap_8
XTAP_TAPCELL_ROW_129_2399 VGND VPWR sky130_fd_sc_hd__tapvpwrvgnd_1
X_09879_ _03171_ _03539_ _03538_ VGND VGND VPWR VPWR _03632_ sky130_fd_sc_hd__a21o_1
XFILLER_92_409 VGND VGND VPWR VPWR sky130_fd_sc_hd__decap_3
X_12890_ net789 net949 VGND VGND VPWR VPWR _01032_ sky130_fd_sc_hd__and2_1
XFILLER_58_697 VGND VGND VPWR VPWR sky130_fd_sc_hd__decap_3
X_11910_ _05478_ _05561_ _05642_ _05482_ _05562_ VGND VGND VPWR VPWR _05645_ sky130_fd_sc_hd__o221a_1
XFILLER_46_848 VGND VGND VPWR VPWR sky130_fd_sc_hd__decap_4
X_11841_ _05574_ _05575_ VGND VGND VPWR VPWR _05576_ sky130_fd_sc_hd__nor2_1
XFILLER_72_177 VGND VGND VPWR VPWR sky130_fd_sc_hd__decap_8
XFILLER_14_701 VPWR VGND VPWR VGND sky130_ef_sc_hd__decap_12
X_11772_ _05500_ _05507_ VGND VGND VPWR VPWR _05508_ sky130_fd_sc_hd__nor2_1
X_13511_ clknet_leaf_4_clk _00521_ VGND VGND VPWR VPWR u_interface.u_gelu_fp32.u_synth_top.s2_m\[0\]
+ sky130_fd_sc_hd__dfxtp_1
X_10723_ _04354_ _04357_ VGND VGND VPWR VPWR _04469_ sky130_fd_sc_hd__nand2_1
XFILLER_9_204 VPWR VGND VPWR VGND sky130_ef_sc_hd__decap_12
XFILLER_139_430 VPWR VGND VPWR VGND sky130_ef_sc_hd__decap_12
X_13442_ clknet_leaf_10_clk _00452_ VGND VGND VPWR VPWR u_interface.u_gelu_fp32.u_fp32_to_q16.s3_mag\[13\]
+ sky130_fd_sc_hd__dfxtp_1
X_10654_ net618 net422 _04399_ _04400_ VGND VGND VPWR VPWR _04401_ sky130_fd_sc_hd__a22o_1
XFILLER_154_400 VPWR VGND VPWR VGND sky130_ef_sc_hd__decap_12
XFILLER_127_625 VGND VGND VPWR VPWR sky130_fd_sc_hd__fill_1
XFILLER_127_614 VGND VGND VPWR VPWR sky130_fd_sc_hd__fill_2
XFILLER_127_603 VGND VGND VPWR VPWR sky130_fd_sc_hd__fill_1
X_13373_ clknet_leaf_51_clk _00383_ VGND VGND VPWR VPWR u_interface.fifo_data\[7\]\[18\]
+ sky130_fd_sc_hd__dfxtp_1
X_10585_ _04321_ _04329_ _04330_ VGND VGND VPWR VPWR _04332_ sky130_fd_sc_hd__nand3_1
XFILLER_154_433 VGND VGND VPWR VPWR sky130_fd_sc_hd__fill_2
Xclkload29 clknet_leaf_14_clk VGND VGND VPWR VPWR clkload29/Y sky130_fd_sc_hd__inv_8
Xclkload18 clknet_leaf_88_clk VGND VGND VPWR VPWR clkload18/Y sky130_fd_sc_hd__inv_12
XFILLER_70_97 VPWR VGND VPWR VGND sky130_ef_sc_hd__decap_12
X_12324_ _06050_ _06051_ VGND VGND VPWR VPWR _06053_ sky130_fd_sc_hd__xnor2_1
XFILLER_154_477 VGND VGND VPWR VPWR sky130_fd_sc_hd__decap_6
XFILLER_126_168 VGND VGND VPWR VPWR sky130_fd_sc_hd__decap_4
XFILLER_5_432 VPWR VGND VPWR VGND sky130_ef_sc_hd__decap_12
X_12255_ _05871_ _05917_ _05916_ VGND VGND VPWR VPWR _05985_ sky130_fd_sc_hd__o21ai_1
XFILLER_107_393 VPWR VGND VPWR VGND sky130_ef_sc_hd__decap_12
XFILLER_79_95 VGND VGND VPWR VPWR sky130_fd_sc_hd__decap_3
XFILLER_79_73 VGND VGND VPWR VPWR sky130_fd_sc_hd__decap_3
X_11206_ net694 net703 net443 net438 VGND VGND VPWR VPWR _04948_ sky130_fd_sc_hd__and4_1
X_12186_ _05914_ _05915_ VGND VGND VPWR VPWR _05917_ sky130_fd_sc_hd__xnor2_1
XFILLER_122_363 VGND VGND VPWR VPWR sky130_fd_sc_hd__fill_1
XFILLER_96_726 VPWR VGND VPWR VGND sky130_ef_sc_hd__decap_12
X_11137_ _04878_ _04879_ VGND VGND VPWR VPWR _04880_ sky130_fd_sc_hd__xnor2_1
XFILLER_1_671 VGND VGND VPWR VPWR sky130_fd_sc_hd__fill_1
XFILLER_95_225 VGND VGND VPWR VPWR sky130_fd_sc_hd__decap_4
XFILLER_0_181 VPWR VGND VPWR VGND sky130_ef_sc_hd__decap_12
XFILLER_95_72 VGND VGND VPWR VPWR sky130_fd_sc_hd__decap_4
X_11068_ net206 _04712_ _04711_ VGND VGND VPWR VPWR _04811_ sky130_fd_sc_hd__o21ai_1
X_10019_ _03769_ _03770_ _03759_ VGND VGND VPWR VPWR _03771_ sky130_fd_sc_hd__a21oi_1
XTAP_TAPCELL_ROW_69_1446 VGND VPWR sky130_fd_sc_hd__tapvpwrvgnd_1
XTAP_TAPCELL_ROW_69_1435 VGND VPWR sky130_fd_sc_hd__tapvpwrvgnd_1
XFILLER_64_645 VPWR VGND VPWR VGND sky130_ef_sc_hd__decap_12
XFILLER_64_678 VGND VGND VPWR VPWR sky130_fd_sc_hd__fill_1
XFILLER_91_497 VGND VGND VPWR VPWR sky130_fd_sc_hd__decap_6
XFILLER_63_177 VGND VGND VPWR VPWR sky130_fd_sc_hd__fill_1
XFILLER_52_829 VGND VGND VPWR VPWR sky130_fd_sc_hd__fill_1
XFILLER_17_561 VPWR VGND VPWR VGND sky130_ef_sc_hd__decap_12
XTAP_TAPCELL_ROW_82_1646 VGND VPWR sky130_fd_sc_hd__tapvpwrvgnd_1
XFILLER_44_380 VGND VGND VPWR VPWR sky130_fd_sc_hd__decap_8
X_13709_ clknet_leaf_2_clk _00719_ VGND VGND VPWR VPWR u_interface.u_gelu_fp32.s1_data\[9\]
+ sky130_fd_sc_hd__dfxtp_1
XFILLER_32_575 VPWR VGND VPWR VGND sky130_ef_sc_hd__decap_12
X_07230_ _01530_ _01531_ VGND VGND VPWR VPWR _00265_ sky130_fd_sc_hd__nor2_1
XFILLER_20_737 VPWR VGND VPWR VGND sky130_ef_sc_hd__decap_12
XFILLER_118_625 VGND VGND VPWR VPWR sky130_fd_sc_hd__fill_1
X_07161_ net1023 net383 net264 VGND VGND VPWR VPWR _00201_ sky130_fd_sc_hd__mux2_1
XFILLER_145_444 VGND VGND VPWR VPWR sky130_fd_sc_hd__fill_1
XFILLER_145_433 VGND VGND VPWR VPWR sky130_fd_sc_hd__decap_3
XFILLER_117_113 VGND VGND VPWR VPWR sky130_fd_sc_hd__decap_4
XFILLER_133_617 VGND VGND VPWR VPWR sky130_fd_sc_hd__decap_8
X_07092_ net1280 net362 net228 VGND VGND VPWR VPWR _00132_ sky130_fd_sc_hd__mux2_1
XFILLER_8_292 VGND VGND VPWR VPWR sky130_fd_sc_hd__fill_2
XFILLER_133_639 VGND VGND VPWR VPWR sky130_fd_sc_hd__decap_8
XTAP_TAPCELL_ROW_113_2145 VGND VPWR sky130_fd_sc_hd__tapvpwrvgnd_1
XFILLER_113_341 VGND VGND VPWR VPWR sky130_fd_sc_hd__fill_1
Xfanout205 _04699_ VGND VGND VPWR VPWR net205 sky130_fd_sc_hd__clkbuf_4
XFILLER_5_81 VPWR VGND VPWR VGND sky130_ef_sc_hd__decap_12
Xfanout227 net228 VGND VGND VPWR VPWR net227 sky130_fd_sc_hd__buf_4
Xfanout216 _03230_ VGND VGND VPWR VPWR net216 sky130_fd_sc_hd__clkbuf_2
X_09802_ _03491_ _03493_ _03552_ _03553_ VGND VGND VPWR VPWR _03556_ sky130_fd_sc_hd__a211o_1
XFILLER_99_575 VGND VGND VPWR VPWR sky130_fd_sc_hd__fill_2
Xfanout238 _01517_ VGND VGND VPWR VPWR net238 sky130_fd_sc_hd__clkbuf_4
XFILLER_59_417 VGND VGND VPWR VPWR sky130_fd_sc_hd__fill_2
X_07994_ _01859_ _01860_ VGND VGND VPWR VPWR _00700_ sky130_fd_sc_hd__or2_1
XFILLER_101_547 VPWR VGND VPWR VGND sky130_ef_sc_hd__decap_12
XFILLER_101_525 VGND VGND VPWR VPWR sky130_fd_sc_hd__fill_1
Xfanout249 net250 VGND VGND VPWR VPWR net249 sky130_fd_sc_hd__buf_4
X_09733_ net499 net705 _03486_ _03487_ VGND VGND VPWR VPWR _03488_ sky130_fd_sc_hd__a22o_1
X_06945_ u_interface.u_gelu_fp32.u_synth_top.s1_x\[22\] u_interface.u_gelu_fp32.u_synth_top.s1_x\[23\]
+ u_interface.u_gelu_fp32.u_synth_top.s1_x\[24\] u_interface.u_gelu_fp32.u_synth_top.s1_x\[25\]
+ net273 VGND VGND VPWR VPWR _01477_ sky130_fd_sc_hd__o41ai_2
XFILLER_39_141 VGND VGND VPWR VPWR sky130_fd_sc_hd__decap_8
X_09664_ _03418_ _03419_ VGND VGND VPWR VPWR _03420_ sky130_fd_sc_hd__xnor2_1
XFILLER_95_781 VGND VGND VPWR VPWR sky130_fd_sc_hd__decap_3
X_06876_ _01415_ _01417_ _01420_ net317 VGND VGND VPWR VPWR net132 sky130_fd_sc_hd__a22o_1
XFILLER_67_494 VGND VGND VPWR VPWR sky130_fd_sc_hd__decap_3
XFILLER_28_837 VPWR VGND VPWR VGND sky130_ef_sc_hd__decap_12
X_09595_ _03270_ _03350_ VGND VGND VPWR VPWR _03351_ sky130_fd_sc_hd__and2_1
X_08615_ net157 _02391_ VGND VGND VPWR VPWR _02392_ sky130_fd_sc_hd__nand2_1
XPHY_EDGE_ROW_19_Left_175 VGND VGND VPWR VPWR sky130_fd_sc_hd__decap_3
XFILLER_54_188 VGND VGND VPWR VPWR sky130_fd_sc_hd__fill_2
XFILLER_54_155 VGND VGND VPWR VPWR sky130_fd_sc_hd__fill_1
XFILLER_42_317 VGND VGND VPWR VPWR sky130_fd_sc_hd__fill_1
XFILLER_70_659 VGND VGND VPWR VPWR sky130_fd_sc_hd__decap_3
X_08546_ _02276_ _02336_ VGND VGND VPWR VPWR _02337_ sky130_fd_sc_hd__xor2_1
X_08477_ net526 u_interface.u_gelu_fp32.u_synth_top.s3_mult\[41\] VGND VGND VPWR VPWR
+ _02268_ sky130_fd_sc_hd__xor2_2
XFILLER_23_553 VGND VGND VPWR VPWR sky130_fd_sc_hd__decap_6
X_07428_ u_interface.u_gelu_fp32.u_fp32_to_q16.s2_norm_mag\[12\] u_interface.u_gelu_fp32.u_fp32_to_q16.s2_norm_mag\[13\]
+ net558 VGND VGND VPWR VPWR _01564_ sky130_fd_sc_hd__mux2_1
XFILLER_109_614 VGND VGND VPWR VPWR sky130_fd_sc_hd__fill_2
X_07359_ net575 net1524 net244 VGND VGND VPWR VPWR _00389_ sky130_fd_sc_hd__mux2_1
XFILLER_148_282 VPWR VGND VPWR VGND sky130_ef_sc_hd__decap_12
XFILLER_109_625 VGND VGND VPWR VPWR sky130_fd_sc_hd__decap_3
XPHY_EDGE_ROW_149_Right_149 VGND VGND VPWR VPWR sky130_fd_sc_hd__decap_3
XFILLER_136_477 VGND VGND VPWR VPWR sky130_fd_sc_hd__decap_6
X_10370_ _04115_ _04116_ _04117_ VGND VGND VPWR VPWR _04119_ sky130_fd_sc_hd__a21o_1
XPHY_EDGE_ROW_28_Left_184 VGND VGND VPWR VPWR sky130_fd_sc_hd__decap_3
X_09029_ _02785_ _02786_ _02787_ VGND VGND VPWR VPWR _02788_ sky130_fd_sc_hd__or3_1
XFILLER_2_413 VGND VGND VPWR VPWR sky130_fd_sc_hd__decap_6
XFILLER_151_469 VPWR VGND VPWR VGND sky130_ef_sc_hd__decap_12
Xhold270 _00999_ VGND VGND VPWR VPWR net1135 sky130_fd_sc_hd__dlygate4sd3_1
XFILLER_105_864 VGND VGND VPWR VPWR sky130_fd_sc_hd__fill_1
XFILLER_2_457 VPWR VGND VPWR VGND sky130_ef_sc_hd__decap_12
X_12040_ _05738_ _05772_ VGND VGND VPWR VPWR _05773_ sky130_fd_sc_hd__xnor2_1
XFILLER_105_897 VGND VGND VPWR VPWR sky130_fd_sc_hd__decap_3
Xhold292 u_interface.fifo_data\[13\]\[9\] VGND VGND VPWR VPWR net1157 sky130_fd_sc_hd__dlygate4sd3_1
Xhold281 u_interface.fifo_data\[1\]\[2\] VGND VGND VPWR VPWR net1146 sky130_fd_sc_hd__dlygate4sd3_1
Xfanout750 net754 VGND VGND VPWR VPWR net750 sky130_fd_sc_hd__clkbuf_4
XFILLER_49_98 VPWR VGND VPWR VGND sky130_ef_sc_hd__decap_12
XTAP_TAPCELL_ROW_144_2639 VGND VPWR sky130_fd_sc_hd__tapvpwrvgnd_1
XFILLER_120_878 VGND VGND VPWR VPWR sky130_fd_sc_hd__decap_3
Xfanout783 net784 VGND VGND VPWR VPWR net783 sky130_fd_sc_hd__dlymetal6s2s_1
Xfanout761 net762 VGND VGND VPWR VPWR net761 sky130_fd_sc_hd__clkbuf_4
XFILLER_93_729 VGND VGND VPWR VPWR sky130_fd_sc_hd__decap_6
XFILLER_93_707 VGND VGND VPWR VPWR sky130_fd_sc_hd__decap_8
Xfanout772 net792 VGND VGND VPWR VPWR net772 sky130_fd_sc_hd__clkbuf_4
X_13991_ clknet_leaf_64_clk _00917_ VGND VGND VPWR VPWR u_interface.u_gelu_fp32.u_q16_to_fp32.s3_norm_mag\[18\]
+ sky130_fd_sc_hd__dfxtp_1
Xfanout794 net795 VGND VGND VPWR VPWR net794 sky130_fd_sc_hd__clkbuf_2
X_12942_ u_interface.in_flight_count\[5\] _06464_ net828 VGND VGND VPWR VPWR _06465_
+ sky130_fd_sc_hd__a21oi_1
XFILLER_58_472 VGND VGND VPWR VPWR sky130_fd_sc_hd__decap_4
XFILLER_1_39 VPWR VGND VPWR VGND sky130_ef_sc_hd__decap_12
XPHY_EDGE_ROW_37_Left_193 VGND VGND VPWR VPWR sky130_fd_sc_hd__decap_3
XFILLER_46_645 VGND VGND VPWR VPWR sky130_fd_sc_hd__decap_4
X_12873_ net1598 u_interface.u_gelu_fp32.u_fp32_to_q16.s2_norm_mag\[28\] net820 VGND
+ VGND VPWR VPWR _01017_ sky130_fd_sc_hd__mux2_1
XFILLER_45_155 VGND VGND VPWR VPWR sky130_fd_sc_hd__fill_1
XFILLER_73_497 VGND VGND VPWR VPWR sky130_fd_sc_hd__fill_2
X_11824_ net197 _05559_ VGND VGND VPWR VPWR _05560_ sky130_fd_sc_hd__xnor2_1
XFILLER_14_531 VGND VGND VPWR VPWR sky130_fd_sc_hd__fill_1
XTAP_TAPCELL_ROW_64_1365 VGND VPWR sky130_fd_sc_hd__tapvpwrvgnd_1
XTAP_TAPCELL_ROW_64_1354 VGND VPWR sky130_fd_sc_hd__tapvpwrvgnd_1
X_11755_ net179 _05489_ VGND VGND VPWR VPWR _05491_ sky130_fd_sc_hd__xor2_1
XFILLER_42_862 VGND VGND VPWR VPWR sky130_fd_sc_hd__decap_6
X_10706_ _04449_ _04450_ _04451_ VGND VGND VPWR VPWR _04452_ sky130_fd_sc_hd__a21o_1
X_13425_ clknet_leaf_11_clk _00435_ VGND VGND VPWR VPWR u_interface.u_gelu_fp32.u_fp32_to_q16.s3_frac\[5\]
+ sky130_fd_sc_hd__dfxtp_1
X_11686_ _05421_ _05422_ VGND VGND VPWR VPWR _05423_ sky130_fd_sc_hd__and2b_1
XFILLER_155_720 VGND VGND VPWR VPWR sky130_fd_sc_hd__decap_4
X_10637_ _04264_ _04266_ _04265_ VGND VGND VPWR VPWR _04384_ sky130_fd_sc_hd__a21bo_1
XFILLER_10_781 VPWR VGND VPWR VGND sky130_ef_sc_hd__decap_12
XFILLER_127_455 VGND VGND VPWR VPWR sky130_fd_sc_hd__decap_8
XFILLER_127_444 VGND VGND VPWR VPWR sky130_fd_sc_hd__decap_4
XPHY_EDGE_ROW_116_Right_116 VGND VGND VPWR VPWR sky130_fd_sc_hd__decap_3
XFILLER_115_617 VPWR VGND VPWR VGND sky130_ef_sc_hd__decap_12
X_13356_ clknet_leaf_54_clk _00366_ VGND VGND VPWR VPWR u_interface.fifo_data\[7\]\[1\]
+ sky130_fd_sc_hd__dfxtp_1
X_10568_ _04314_ _04315_ VGND VGND VPWR VPWR _04316_ sky130_fd_sc_hd__nand2b_1
XFILLER_155_797 VGND VGND VPWR VPWR sky130_fd_sc_hd__decap_4
XFILLER_114_116 VGND VGND VPWR VPWR sky130_fd_sc_hd__decap_8
X_13287_ clknet_leaf_44_clk _00297_ VGND VGND VPWR VPWR u_interface.fifo_data\[0\]\[29\]
+ sky130_fd_sc_hd__dfxtp_1
X_10499_ _04245_ _04246_ _04239_ VGND VGND VPWR VPWR _04247_ sky130_fd_sc_hd__a21o_1
XFILLER_5_273 VGND VGND VPWR VPWR sky130_fd_sc_hd__decap_6
X_12307_ _06034_ _06033_ VGND VGND VPWR VPWR _06036_ sky130_fd_sc_hd__nand2b_1
X_12238_ _05958_ _05967_ VGND VGND VPWR VPWR _05968_ sky130_fd_sc_hd__xnor2_1
XFILLER_69_737 VGND VGND VPWR VPWR sky130_fd_sc_hd__fill_2
XFILLER_110_333 VGND VGND VPWR VPWR sky130_fd_sc_hd__fill_2
X_12169_ _05898_ _05899_ VGND VGND VPWR VPWR _05900_ sky130_fd_sc_hd__and2_1
XFILLER_96_589 VPWR VGND VPWR VGND sky130_ef_sc_hd__decap_12
XFILLER_56_409 VGND VGND VPWR VPWR sky130_fd_sc_hd__decap_4
Xinput5 s_axil_araddr[11] VGND VGND VPWR VPWR net5 sky130_fd_sc_hd__clkbuf_1
X_06730_ u_interface.fifo_data\[4\]\[12\] u_interface.fifo_data\[5\]\[12\] u_interface.fifo_data\[6\]\[12\]
+ u_interface.fifo_data\[7\]\[12\] net760 net743 VGND VGND VPWR VPWR _01293_ sky130_fd_sc_hd__mux4_1
X_06661_ u_interface.fifo_data\[12\]\[4\] u_interface.fifo_data\[13\]\[4\] u_interface.fifo_data\[14\]\[4\]
+ u_interface.fifo_data\[15\]\[4\] net761 net744 VGND VGND VPWR VPWR _01232_ sky130_fd_sc_hd__mux4_1
XFILLER_36_111 VPWR VGND VPWR VGND sky130_ef_sc_hd__decap_12
X_08400_ _02190_ VGND VGND VPWR VPWR _02191_ sky130_fd_sc_hd__inv_2
XFILLER_18_881 VPWR VGND VPWR VGND sky130_ef_sc_hd__decap_12
X_09380_ _03136_ _03137_ VGND VGND VPWR VPWR _03138_ sky130_fd_sc_hd__and2b_1
X_06592_ _01154_ _01176_ VGND VGND VPWR VPWR _00019_ sky130_fd_sc_hd__and2_1
XFILLER_17_380 VGND VGND VPWR VPWR sky130_fd_sc_hd__fill_2
XFILLER_17_391 VGND VGND VPWR VPWR sky130_fd_sc_hd__fill_1
X_08331_ u_interface.u_gelu_fp32.s2_data\[22\] _02128_ VGND VGND VPWR VPWR _02131_
+ sky130_fd_sc_hd__or2_1
XFILLER_51_169 VGND VGND VPWR VPWR sky130_fd_sc_hd__decap_8
X_08262_ net1561 _02079_ net782 VGND VGND VPWR VPWR _02080_ sky130_fd_sc_hd__o21ai_1
XTAP_TAPCELL_ROW_15_570 VGND VPWR sky130_fd_sc_hd__tapvpwrvgnd_1
XFILLER_32_372 VGND VGND VPWR VPWR sky130_fd_sc_hd__fill_2
XFILLER_33_895 VGND VGND VPWR VPWR sky130_fd_sc_hd__fill_1
XTAP_TAPCELL_ROW_15_581 VGND VPWR sky130_fd_sc_hd__tapvpwrvgnd_1
X_07213_ net342 net1254 net257 VGND VGND VPWR VPWR _00253_ sky130_fd_sc_hd__mux2_1
XFILLER_118_433 VPWR VGND VPWR VGND sky130_ef_sc_hd__decap_12
X_08193_ net539 _02025_ _02026_ VGND VGND VPWR VPWR _02027_ sky130_fd_sc_hd__nand3_1
XFILLER_20_589 VPWR VGND VPWR VGND sky130_ef_sc_hd__decap_12
X_07144_ net962 net352 net220 VGND VGND VPWR VPWR _00184_ sky130_fd_sc_hd__mux2_1
XFILLER_106_606 VPWR VGND VPWR VGND sky130_ef_sc_hd__decap_12
XFILLER_145_274 VGND VGND VPWR VPWR sky130_fd_sc_hd__decap_6
XFILLER_133_425 VGND VGND VPWR VPWR sky130_fd_sc_hd__decap_6
X_07075_ net1473 net572 net209 VGND VGND VPWR VPWR _00115_ sky130_fd_sc_hd__mux2_1
XFILLER_118_477 VGND VGND VPWR VPWR sky130_fd_sc_hd__decap_6
XTAP_TAPCELL_ROW_95_1859 VGND VPWR sky130_fd_sc_hd__tapvpwrvgnd_1
XTAP_TAPCELL_ROW_95_1848 VGND VPWR sky130_fd_sc_hd__tapvpwrvgnd_1
XFILLER_10_15 VPWR VGND VPWR VGND sky130_ef_sc_hd__decap_12
XFILLER_105_149 VPWR VGND VPWR VGND sky130_ef_sc_hd__decap_12
XFILLER_87_512 VGND VGND VPWR VPWR sky130_fd_sc_hd__fill_2
XFILLER_141_491 VGND VGND VPWR VPWR sky130_fd_sc_hd__fill_1
XFILLER_59_225 VPWR VGND VPWR VGND sky130_ef_sc_hd__decap_12
X_07977_ net780 net973 _01850_ VGND VGND VPWR VPWR _00693_ sky130_fd_sc_hd__o21a_1
XFILLER_75_729 VGND VGND VPWR VPWR sky130_fd_sc_hd__decap_3
XFILLER_59_269 VGND VGND VPWR VPWR sky130_fd_sc_hd__decap_8
XTAP_TAPCELL_ROW_126_2358 VGND VPWR sky130_fd_sc_hd__tapvpwrvgnd_1
XTAP_TAPCELL_ROW_126_2347 VGND VPWR sky130_fd_sc_hd__tapvpwrvgnd_1
X_09716_ _03369_ _03372_ VGND VGND VPWR VPWR _03471_ sky130_fd_sc_hd__nor2_1
XFILLER_101_399 VGND VGND VPWR VPWR sky130_fd_sc_hd__decap_3
X_06928_ _01453_ _01462_ _01463_ VGND VGND VPWR VPWR _01464_ sky130_fd_sc_hd__and3_1
XFILLER_19_57 VPWR VGND VPWR VGND sky130_ef_sc_hd__decap_12
XFILLER_28_601 VPWR VGND VPWR VGND sky130_ef_sc_hd__decap_12
XFILLER_27_111 VGND VGND VPWR VPWR sky130_fd_sc_hd__fill_1
XFILLER_28_645 VPWR VGND VPWR VGND sky130_ef_sc_hd__decap_12
X_06859_ _01404_ _01405_ net736 VGND VGND VPWR VPWR _01406_ sky130_fd_sc_hd__mux2_1
X_09647_ _03262_ _03264_ _03400_ _03401_ VGND VGND VPWR VPWR _03403_ sky130_fd_sc_hd__a211oi_4
XFILLER_43_615 VGND VGND VPWR VPWR sky130_fd_sc_hd__fill_1
X_09578_ net472 net648 VGND VGND VPWR VPWR _03334_ sky130_fd_sc_hd__and2_1
XFILLER_70_445 VPWR VGND VPWR VGND sky130_ef_sc_hd__decap_12
XFILLER_43_659 VGND VGND VPWR VPWR sky130_fd_sc_hd__decap_3
XFILLER_42_136 VGND VGND VPWR VPWR sky130_fd_sc_hd__decap_4
X_08529_ _02296_ _02308_ _02306_ VGND VGND VPWR VPWR _02320_ sky130_fd_sc_hd__a21o_1
XTAP_TAPCELL_ROW_104_1999 VGND VPWR sky130_fd_sc_hd__tapvpwrvgnd_1
XTAP_TAPCELL_ROW_46_1073 VGND VPWR sky130_fd_sc_hd__tapvpwrvgnd_1
XFILLER_11_501 VGND VGND VPWR VPWR sky130_fd_sc_hd__decap_3
X_11540_ _05276_ _05277_ VGND VGND VPWR VPWR _05279_ sky130_fd_sc_hd__xor2_2
XFILLER_7_505 VPWR VGND VPWR VGND sky130_ef_sc_hd__decap_12
X_11471_ net195 _05210_ VGND VGND VPWR VPWR _05211_ sky130_fd_sc_hd__xnor2_1
XFILLER_51_66 VGND VGND VPWR VPWR sky130_fd_sc_hd__decap_6
X_10422_ _04169_ _04170_ _04153_ VGND VGND VPWR VPWR _04171_ sky130_fd_sc_hd__a21o_1
X_13210_ clknet_leaf_69_clk _00220_ VGND VGND VPWR VPWR u_interface.fifo_data\[12\]\[20\]
+ sky130_fd_sc_hd__dfxtp_1
XFILLER_136_274 VGND VGND VPWR VPWR sky130_fd_sc_hd__decap_3
XFILLER_124_403 VGND VGND VPWR VPWR sky130_fd_sc_hd__fill_1
X_10353_ _04100_ _04101_ _04085_ VGND VGND VPWR VPWR _04102_ sky130_fd_sc_hd__a21o_1
X_13141_ clknet_leaf_68_clk _00151_ VGND VGND VPWR VPWR u_interface.fifo_data\[2\]\[30\]
+ sky130_fd_sc_hd__dfxtp_1
X_13072_ clknet_leaf_47_clk _00082_ VGND VGND VPWR VPWR u_interface.fifo_data\[14\]\[25\]
+ sky130_fd_sc_hd__dfxtp_1
XFILLER_2_221 VPWR VGND VPWR VGND sky130_ef_sc_hd__decap_12
XFILLER_151_277 VGND VGND VPWR VPWR sky130_fd_sc_hd__decap_3
X_10284_ _03998_ _04031_ _04032_ VGND VGND VPWR VPWR _04034_ sky130_fd_sc_hd__and3_1
XFILLER_3_777 VGND VGND VPWR VPWR sky130_fd_sc_hd__decap_6
XFILLER_2_265 VPWR VGND VPWR VGND sky130_ef_sc_hd__decap_12
X_12023_ net684 net393 VGND VGND VPWR VPWR _05756_ sky130_fd_sc_hd__nand2_1
XPHY_EDGE_ROW_45_Left_201 VGND VGND VPWR VPWR sky130_fd_sc_hd__decap_3
Xfanout591 net592 VGND VGND VPWR VPWR net591 sky130_fd_sc_hd__buf_2
XFILLER_93_537 VPWR VGND VPWR VGND sky130_ef_sc_hd__decap_12
Xfanout580 net581 VGND VGND VPWR VPWR net580 sky130_fd_sc_hd__clkbuf_2
XFILLER_93_559 VGND VGND VPWR VPWR sky130_fd_sc_hd__fill_1
X_13974_ clknet_leaf_84_clk net1709 VGND VGND VPWR VPWR u_interface.u_gelu_fp32.u_q16_to_fp32.s2_mag\[19\]
+ sky130_fd_sc_hd__dfxtp_1
XFILLER_18_133 VGND VGND VPWR VPWR sky130_fd_sc_hd__decap_6
X_12925_ _06444_ _06447_ _06449_ VGND VGND VPWR VPWR _06451_ sky130_fd_sc_hd__a21oi_1
X_12856_ net1378 u_interface.u_gelu_fp32.u_fp32_to_q16.s2_norm_mag\[11\] net817 VGND
+ VGND VPWR VPWR _01000_ sky130_fd_sc_hd__mux2_1
XFILLER_34_637 VGND VGND VPWR VPWR sky130_fd_sc_hd__decap_6
X_11807_ _05540_ _05541_ VGND VGND VPWR VPWR _05543_ sky130_fd_sc_hd__xnor2_1
XFILLER_33_169 VGND VGND VPWR VPWR sky130_fd_sc_hd__fill_2
X_12787_ u_interface.u_gelu_fp32.u_q16_to_fp32.s3_norm_mag\[22\] _01784_ net295 VGND
+ VGND VPWR VPWR _06410_ sky130_fd_sc_hd__o21ai_1
XPHY_EDGE_ROW_54_Left_210 VGND VGND VPWR VPWR sky130_fd_sc_hd__decap_3
XFILLER_14_372 VPWR VGND VPWR VGND sky130_ef_sc_hd__decap_12
XFILLER_15_895 VGND VGND VPWR VPWR sky130_fd_sc_hd__fill_1
XTAP_TAPCELL_ROW_32_849 VGND VPWR sky130_fd_sc_hd__tapvpwrvgnd_1
XFILLER_42_681 VPWR VGND VPWR VGND sky130_ef_sc_hd__decap_12
X_11738_ _05472_ _05473_ VGND VGND VPWR VPWR _05475_ sky130_fd_sc_hd__xor2_1
X_11669_ net205 _05324_ _05405_ VGND VGND VPWR VPWR _05406_ sky130_fd_sc_hd__o21ai_1
XFILLER_128_742 VGND VGND VPWR VPWR sky130_fd_sc_hd__fill_1
X_13408_ clknet_leaf_83_clk _00418_ VGND VGND VPWR VPWR u_interface.fifo_data\[6\]\[21\]
+ sky130_fd_sc_hd__dfxtp_1
X_13339_ clknet_leaf_31_clk _00349_ VGND VGND VPWR VPWR u_interface.fifo_data\[10\]\[16\]
+ sky130_fd_sc_hd__dfxtp_1
XFILLER_127_285 VGND VGND VPWR VPWR sky130_fd_sc_hd__fill_1
XFILLER_115_436 VGND VGND VPWR VPWR sky130_fd_sc_hd__fill_1
XTAP_TAPCELL_ROW_77_1567 VGND VPWR sky130_fd_sc_hd__tapvpwrvgnd_1
XFILLER_51_3 VPWR VGND VPWR VGND sky130_ef_sc_hd__decap_12
XFILLER_143_778 VGND VGND VPWR VPWR sky130_fd_sc_hd__decap_6
XFILLER_103_609 VGND VGND VPWR VPWR sky130_fd_sc_hd__decap_6
XFILLER_88_309 VGND VGND VPWR VPWR sky130_fd_sc_hd__decap_8
X_07900_ net785 net906 VGND VGND VPWR VPWR _00661_ sky130_fd_sc_hd__and2_1
XFILLER_130_439 VGND VGND VPWR VPWR sky130_fd_sc_hd__fill_1
X_08880_ net476 net629 net481 net637 VGND VGND VPWR VPWR _02639_ sky130_fd_sc_hd__a22o_1
X_07831_ net1445 net565 net232 VGND VGND VPWR VPWR _00592_ sky130_fd_sc_hd__mux2_1
XTAP_TAPCELL_ROW_90_1778 VGND VPWR sky130_fd_sc_hd__tapvpwrvgnd_1
XFILLER_57_729 VPWR VGND VPWR VGND sky130_ef_sc_hd__decap_12
X_09501_ _03255_ _03256_ _03195_ _03197_ VGND VGND VPWR VPWR _03258_ sky130_fd_sc_hd__o211ai_1
XTAP_TAPCELL_ROW_108_2066 VGND VPWR sky130_fd_sc_hd__tapvpwrvgnd_1
X_07762_ net294 _01800_ _01801_ VGND VGND VPWR VPWR _00526_ sky130_fd_sc_hd__and3_1
X_06713_ u_interface.fifo_data\[0\]\[10\] u_interface.fifo_data\[1\]\[10\] u_interface.fifo_data\[2\]\[10\]
+ u_interface.fifo_data\[3\]\[10\] net771 net754 VGND VGND VPWR VPWR _01278_ sky130_fd_sc_hd__mux4_1
X_07693_ u_interface.u_gelu_fp32.u_synth_top.s1_hits\[1\] _01187_ _01753_ _01757_
+ VGND VGND VPWR VPWR _00497_ sky130_fd_sc_hd__or4_1
X_09432_ net489 net494 net664 net671 VGND VGND VPWR VPWR _03190_ sky130_fd_sc_hd__nand4_1
X_06644_ _01213_ _01214_ _01217_ net318 VGND VGND VPWR VPWR net120 sky130_fd_sc_hd__a22o_1
X_09363_ _03110_ _03111_ _03121_ VGND VGND VPWR VPWR _03122_ sky130_fd_sc_hd__a21oi_1
XTAP_TAPCELL_ROW_121_2277 VGND VPWR sky130_fd_sc_hd__tapvpwrvgnd_1
XTAP_TAPCELL_ROW_121_2266 VGND VPWR sky130_fd_sc_hd__tapvpwrvgnd_1
X_06575_ net538 _01105_ VGND VGND VPWR VPWR _01166_ sky130_fd_sc_hd__nor2_1
XFILLER_80_787 VGND VGND VPWR VPWR sky130_fd_sc_hd__fill_1
XFILLER_52_445 VGND VGND VPWR VPWR sky130_fd_sc_hd__fill_2
X_08314_ _02117_ _02118_ VGND VGND VPWR VPWR _00762_ sky130_fd_sc_hd__nor2_1
XFILLER_21_821 VPWR VGND VPWR VGND sky130_ef_sc_hd__decap_12
X_09294_ _03043_ _03052_ VGND VGND VPWR VPWR _03053_ sky130_fd_sc_hd__nor2_1
XANTENNA_10 net2 VGND VGND VPWR VPWR sky130_fd_sc_hd__diode_2
XFILLER_21_865 VPWR VGND VPWR VGND sky130_ef_sc_hd__decap_12
XFILLER_32_191 VGND VGND VPWR VPWR sky130_fd_sc_hd__decap_4
X_08245_ net146 net145 VGND VGND VPWR VPWR _02069_ sky130_fd_sc_hd__nor2_1
XFILLER_138_539 VGND VGND VPWR VPWR sky130_fd_sc_hd__fill_1
X_08176_ net166 _02012_ net162 VGND VGND VPWR VPWR _02013_ sky130_fd_sc_hd__a21oi_1
X_07127_ net1189 net325 net209 VGND VGND VPWR VPWR _00167_ sky130_fd_sc_hd__mux2_1
XFILLER_146_583 VGND VGND VPWR VPWR sky130_fd_sc_hd__decap_4
XFILLER_106_414 VGND VGND VPWR VPWR sky130_fd_sc_hd__decap_6
XFILLER_21_69 VPWR VGND VPWR VGND sky130_ef_sc_hd__decap_12
XFILLER_137_69 VPWR VGND VPWR VGND sky130_ef_sc_hd__decap_12
Xoutput150 net150 VGND VGND VPWR VPWR s_axis_tready sky130_fd_sc_hd__buf_2
X_07058_ net1258 net367 net207 VGND VGND VPWR VPWR _00098_ sky130_fd_sc_hd__mux2_1
XFILLER_0_725 VGND VGND VPWR VPWR sky130_fd_sc_hd__decap_3
XFILLER_153_57 VGND VGND VPWR VPWR sky130_fd_sc_hd__decap_4
XFILLER_102_642 VGND VGND VPWR VPWR sky130_fd_sc_hd__fill_2
XFILLER_0_769 VPWR VGND VPWR VGND sky130_ef_sc_hd__decap_12
XFILLER_101_163 VGND VGND VPWR VPWR sky130_fd_sc_hd__decap_4
XFILLER_47_206 VGND VGND VPWR VPWR sky130_fd_sc_hd__fill_2
X_10971_ _04614_ _04616_ _04713_ VGND VGND VPWR VPWR _04715_ sky130_fd_sc_hd__a21oi_1
XFILLER_56_773 VGND VGND VPWR VPWR sky130_fd_sc_hd__decap_4
XFILLER_55_261 VPWR VGND VPWR VGND sky130_ef_sc_hd__decap_12
XTAP_TAPCELL_ROW_48_1102 VGND VPWR sky130_fd_sc_hd__tapvpwrvgnd_1
XTAP_TAPCELL_ROW_39_960 VGND VPWR sky130_fd_sc_hd__tapvpwrvgnd_1
X_13690_ clknet_leaf_13_clk _00700_ VGND VGND VPWR VPWR u_interface.u_gelu_fp32.u_fp32_to_q16.s3_frac\[26\]
+ sky130_fd_sc_hd__dfxtp_1
X_12710_ _01746_ _01749_ _06365_ _01697_ VGND VGND VPWR VPWR _06366_ sky130_fd_sc_hd__o22a_1
XFILLER_43_412 VPWR VGND VPWR VGND sky130_ef_sc_hd__decap_12
XFILLER_15_125 VPWR VGND VPWR VGND sky130_ef_sc_hd__decap_12
XFILLER_16_637 VGND VGND VPWR VPWR sky130_fd_sc_hd__decap_6
XFILLER_102_61 VGND VGND VPWR VPWR sky130_fd_sc_hd__fill_1
X_12641_ net213 _06335_ VGND VGND VPWR VPWR _06340_ sky130_fd_sc_hd__nand2_1
XFILLER_70_253 VGND VGND VPWR VPWR sky130_fd_sc_hd__decap_8
XFILLER_102_83 VGND VGND VPWR VPWR sky130_fd_sc_hd__fill_1
XFILLER_70_286 VGND VGND VPWR VPWR sky130_fd_sc_hd__fill_1
XFILLER_62_54 VPWR VGND VPWR VGND sky130_ef_sc_hd__decap_12
XTAP_TAPCELL_ROW_61_1313 VGND VPWR sky130_fd_sc_hd__tapvpwrvgnd_1
XFILLER_24_681 VPWR VGND VPWR VGND sky130_ef_sc_hd__decap_12
XFILLER_31_629 VPWR VGND VPWR VGND sky130_ef_sc_hd__decap_12
X_12572_ net773 u_interface.u_gelu_fp32.u_synth_top.s2_b\[16\] VGND VGND VPWR VPWR
+ _00870_ sky130_fd_sc_hd__and2_1
XFILLER_129_528 VGND VGND VPWR VPWR sky130_fd_sc_hd__decap_4
XFILLER_11_353 VGND VGND VPWR VPWR sky130_fd_sc_hd__fill_1
XFILLER_8_825 VPWR VGND VPWR VGND sky130_ef_sc_hd__decap_12
XFILLER_7_313 VGND VGND VPWR VPWR sky130_fd_sc_hd__decap_6
XFILLER_7_27 VPWR VGND VPWR VGND sky130_ef_sc_hd__decap_12
X_11523_ _05256_ _05259_ _05260_ VGND VGND VPWR VPWR _05262_ sky130_fd_sc_hd__nand3_1
XFILLER_8_869 VPWR VGND VPWR VGND sky130_ef_sc_hd__decap_12
X_11454_ _05191_ _05192_ VGND VGND VPWR VPWR _05194_ sky130_fd_sc_hd__xnor2_2
XFILLER_109_252 VGND VGND VPWR VPWR sky130_fd_sc_hd__fill_1
X_10405_ net652 net449 VGND VGND VPWR VPWR _04154_ sky130_fd_sc_hd__nand2_1
XFILLER_7_379 VGND VGND VPWR VPWR sky130_fd_sc_hd__decap_4
XFILLER_109_296 VGND VGND VPWR VPWR sky130_fd_sc_hd__fill_2
XTAP_TAPCELL_ROW_59_1275 VGND VPWR sky130_fd_sc_hd__tapvpwrvgnd_1
X_11385_ _05041_ _05043_ net180 VGND VGND VPWR VPWR _05125_ sky130_fd_sc_hd__o21a_1
XFILLER_152_575 VGND VGND VPWR VPWR sky130_fd_sc_hd__decap_3
X_13124_ clknet_leaf_26_clk _00134_ VGND VGND VPWR VPWR u_interface.fifo_data\[2\]\[13\]
+ sky130_fd_sc_hd__dfxtp_1
X_10336_ _03998_ _04031_ _04032_ VGND VGND VPWR VPWR _04085_ sky130_fd_sc_hd__a21bo_1
XTAP_TAPCELL_ROW_59_1286 VGND VPWR sky130_fd_sc_hd__tapvpwrvgnd_1
XFILLER_3_541 VPWR VGND VPWR VGND sky130_ef_sc_hd__decap_12
XFILLER_127_91 VGND VGND VPWR VPWR sky130_fd_sc_hd__decap_4
XFILLER_79_832 VGND VGND VPWR VPWR sky130_fd_sc_hd__decap_8
X_10267_ net636 net451 _03928_ _03927_ VGND VGND VPWR VPWR _04017_ sky130_fd_sc_hd__a31o_1
XFILLER_3_585 VPWR VGND VPWR VGND sky130_ef_sc_hd__decap_12
X_13055_ clknet_leaf_72_clk _00065_ VGND VGND VPWR VPWR u_interface.fifo_data\[14\]\[8\]
+ sky130_fd_sc_hd__dfxtp_1
XFILLER_105_491 VGND VGND VPWR VPWR sky130_fd_sc_hd__fill_1
XTAP_TAPCELL_ROW_72_1486 VGND VPWR sky130_fd_sc_hd__tapvpwrvgnd_1
X_12006_ _05738_ VGND VGND VPWR VPWR _05739_ sky130_fd_sc_hd__inv_2
X_10198_ _03921_ _03922_ _03947_ VGND VGND VPWR VPWR _03949_ sky130_fd_sc_hd__nand3_2
XFILLER_39_729 VGND VGND VPWR VPWR sky130_fd_sc_hd__fill_2
X_13957_ clknet_leaf_56_clk net1689 VGND VGND VPWR VPWR u_interface.u_gelu_fp32.u_q16_to_fp32.s2_mag\[2\]
+ sky130_fd_sc_hd__dfxtp_1
XFILLER_53_209 VPWR VGND VPWR VGND sky130_ef_sc_hd__decap_12
X_12908_ u_interface.fifo_wr_ptr\[3\] _01523_ VGND VGND VPWR VPWR _06437_ sky130_fd_sc_hd__or2_1
XTAP_TAPCELL_ROW_17_610 VGND VPWR sky130_fd_sc_hd__tapvpwrvgnd_1
X_13888_ clknet_leaf_90_clk _00024_ VGND VGND VPWR VPWR u_interface.u_gelu_fp32.u_synth_top.s2_dx\[24\]
+ sky130_fd_sc_hd__dfxtp_1
X_12839_ net60 net59 net72 VGND VGND VPWR VPWR _06421_ sky130_fd_sc_hd__or3b_2
XFILLER_99_3 VPWR VGND VPWR VGND sky130_ef_sc_hd__decap_12
XFILLER_148_848 VGND VGND VPWR VPWR sky130_fd_sc_hd__fill_1
XFILLER_147_325 VGND VGND VPWR VPWR sky130_fd_sc_hd__fill_2
XTAP_TAPCELL_ROW_79_1607 VGND VPWR sky130_fd_sc_hd__tapvpwrvgnd_1
Xinput30 s_axil_araddr[5] VGND VGND VPWR VPWR net30 sky130_fd_sc_hd__clkbuf_1
X_08030_ u_interface.u_gelu_fp32.u_fp32_to_q16.s3_mag\[20\] _01886_ VGND VGND VPWR
+ VPWR _01887_ sky130_fd_sc_hd__and2_1
Xinput41 s_axil_awaddr[14] VGND VGND VPWR VPWR net41 sky130_fd_sc_hd__clkbuf_1
Xinput63 s_axil_awaddr[5] VGND VGND VPWR VPWR net63 sky130_fd_sc_hd__clkbuf_1
Xinput52 s_axil_awaddr[24] VGND VGND VPWR VPWR net52 sky130_fd_sc_hd__clkbuf_1
Xhold803 u_interface.u_gelu_fp32.u_fp32_to_q16.s3_mag\[19\] VGND VGND VPWR VPWR net1668
+ sky130_fd_sc_hd__dlygate4sd3_1
XFILLER_116_701 VGND VGND VPWR VPWR sky130_fd_sc_hd__decap_4
XFILLER_155_391 VGND VGND VPWR VPWR sky130_fd_sc_hd__fill_1
Xinput85 s_axis_tdata[1] VGND VGND VPWR VPWR net85 sky130_fd_sc_hd__clkbuf_1
Xinput74 s_axis_tdata[0] VGND VGND VPWR VPWR net74 sky130_fd_sc_hd__clkbuf_1
Xinput96 s_axis_tdata[2] VGND VGND VPWR VPWR net96 sky130_fd_sc_hd__clkbuf_1
Xhold814 u_interface.u_gelu_fp32.u_fp32_to_q16.s3_mag\[31\] VGND VGND VPWR VPWR net1679
+ sky130_fd_sc_hd__dlygate4sd3_1
XTAP_TAPCELL_ROW_92_1807 VGND VPWR sky130_fd_sc_hd__tapvpwrvgnd_1
Xhold836 u_interface.u_gelu_fp32.u_q16_to_fp32.s2_mag\[21\] VGND VGND VPWR VPWR net1701
+ sky130_fd_sc_hd__dlygate4sd3_1
Xhold825 u_interface.u_gelu_fp32.u_q16_to_fp32.s2_mag\[25\] VGND VGND VPWR VPWR net1690
+ sky130_fd_sc_hd__dlygate4sd3_1
Xhold869 u_interface.u_gelu_fp32.u_fp32_to_q16.s3_mag\[20\] VGND VGND VPWR VPWR net1734
+ sky130_fd_sc_hd__dlygate4sd3_1
X_09981_ _03731_ _03733_ _03621_ _03623_ VGND VGND VPWR VPWR _03734_ sky130_fd_sc_hd__a211o_1
Xhold847 u_interface.u_gelu_fp32.u_q16_to_fp32.s1_mag\[1\] VGND VGND VPWR VPWR net1712
+ sky130_fd_sc_hd__dlygate4sd3_1
Xhold858 _00907_ VGND VGND VPWR VPWR net1723 sky130_fd_sc_hd__dlygate4sd3_1
X_08932_ _02688_ _02689_ _02542_ _02544_ VGND VGND VPWR VPWR _02691_ sky130_fd_sc_hd__o211ai_1
X_08863_ _02618_ _02619_ _02621_ VGND VGND VPWR VPWR _02622_ sky130_fd_sc_hd__nand3_1
XFILLER_111_472 VPWR VGND VPWR VGND sky130_ef_sc_hd__decap_12
XFILLER_85_835 VGND VGND VPWR VPWR sky130_fd_sc_hd__decap_4
XFILLER_69_364 VGND VGND VPWR VPWR sky130_fd_sc_hd__decap_3
X_08794_ _02549_ _02550_ _02551_ VGND VGND VPWR VPWR _02553_ sky130_fd_sc_hd__or3_1
XFILLER_84_345 VPWR VGND VPWR VGND sky130_ef_sc_hd__decap_12
X_07814_ net1295 net360 net230 VGND VGND VPWR VPWR _00575_ sky130_fd_sc_hd__mux2_1
XFILLER_29_228 VPWR VGND VPWR VGND sky130_ef_sc_hd__decap_12
XTAP_TAPCELL_ROW_123_2306 VGND VPWR sky130_fd_sc_hd__tapvpwrvgnd_1
X_07745_ u_interface.u_gelu_fp32.u_q16_to_fp32.s3_norm_mag\[28\] _01788_ VGND VGND
+ VPWR VPWR _01789_ sky130_fd_sc_hd__and2_1
XFILLER_72_529 VGND VGND VPWR VPWR sky130_fd_sc_hd__decap_3
XFILLER_65_592 VGND VGND VPWR VPWR sky130_fd_sc_hd__fill_1
XFILLER_65_581 VGND VGND VPWR VPWR sky130_fd_sc_hd__fill_2
XFILLER_25_434 VGND VGND VPWR VPWR sky130_fd_sc_hd__decap_3
X_09415_ net714 _03171_ VGND VGND VPWR VPWR _03173_ sky130_fd_sc_hd__and2_1
X_07676_ u_interface.u_gelu_fp32.u_synth_top.s1_hits\[13\] u_interface.u_gelu_fp32.u_synth_top.s1_hits\[17\]
+ net386 u_interface.u_gelu_fp32.u_synth_top.comb_b\[18\] VGND VGND VPWR VPWR _00488_
+ sky130_fd_sc_hd__or4_1
XFILLER_52_253 VGND VGND VPWR VPWR sky130_fd_sc_hd__decap_4
X_06627_ _01201_ _01202_ net735 VGND VGND VPWR VPWR _01203_ sky130_fd_sc_hd__mux2_1
XFILLER_13_629 VPWR VGND VPWR VGND sky130_ef_sc_hd__decap_12
XFILLER_40_415 VGND VGND VPWR VPWR sky130_fd_sc_hd__decap_4
XFILLER_139_804 VGND VGND VPWR VPWR sky130_fd_sc_hd__decap_4
X_09346_ _03103_ _03104_ _03100_ VGND VGND VPWR VPWR _03105_ sky130_fd_sc_hd__a21oi_1
XTAP_TAPCELL_ROW_101_1958 VGND VPWR sky130_fd_sc_hd__tapvpwrvgnd_1
XTAP_TAPCELL_ROW_101_1947 VGND VPWR sky130_fd_sc_hd__tapvpwrvgnd_1
X_06558_ u_interface.u_gelu_fp32.s1_data\[16\] _01139_ _01147_ _01152_ VGND VGND VPWR
+ VPWR _01153_ sky130_fd_sc_hd__a31o_1
XFILLER_12_139 VGND VGND VPWR VPWR sky130_fd_sc_hd__fill_1
XTAP_TAPCELL_ROW_43_1021 VGND VPWR sky130_fd_sc_hd__tapvpwrvgnd_1
X_09277_ _03033_ _03035_ _02990_ _03010_ VGND VGND VPWR VPWR _03036_ sky130_fd_sc_hd__a211oi_1
XFILLER_139_826 VGND VGND VPWR VPWR sky130_fd_sc_hd__decap_4
XFILLER_21_673 VPWR VGND VPWR VGND sky130_ef_sc_hd__decap_12
XFILLER_138_358 VGND VGND VPWR VPWR sky130_fd_sc_hd__decap_6
X_08228_ u_interface.u_gelu_fp32.u_fp32_to_q16.s3_mag\[29\] _01892_ VGND VGND VPWR
+ VPWR _02056_ sky130_fd_sc_hd__nor2_1
XFILLER_153_317 VGND VGND VPWR VPWR sky130_fd_sc_hd__decap_8
XFILLER_119_561 VGND VGND VPWR VPWR sky130_fd_sc_hd__decap_3
XFILLER_5_839 VGND VGND VPWR VPWR sky130_fd_sc_hd__fill_1
XTAP_TAPCELL_ROW_134_2479 VGND VPWR sky130_fd_sc_hd__tapvpwrvgnd_1
X_08159_ u_interface.u_gelu_fp32.u_fp32_to_q16.s3_mag\[18\] _01885_ VGND VGND VPWR
+ VPWR _01998_ sky130_fd_sc_hd__xnor2_1
XFILLER_107_756 VGND VGND VPWR VPWR sky130_fd_sc_hd__fill_1
X_11170_ _04906_ _04912_ net800 VGND VGND VPWR VPWR _04913_ sky130_fd_sc_hd__a21oi_1
X_10121_ net277 _03869_ _03870_ VGND VGND VPWR VPWR _03872_ sky130_fd_sc_hd__nand3_1
X_10052_ _03802_ _03803_ VGND VGND VPWR VPWR _03804_ sky130_fd_sc_hd__and2_1
XFILLER_0_533 VPWR VGND VPWR VGND sky130_ef_sc_hd__decap_12
XFILLER_76_813 VGND VGND VPWR VPWR sky130_fd_sc_hd__decap_3
XTAP_TAPCELL_ROW_54_1194 VGND VPWR sky130_fd_sc_hd__tapvpwrvgnd_1
XFILLER_57_54 VGND VGND VPWR VPWR sky130_fd_sc_hd__fill_2
X_13811_ clknet_leaf_87_clk _00821_ VGND VGND VPWR VPWR u_interface.u_gelu_fp32.u_synth_top.s3_mult\[29\]
+ sky130_fd_sc_hd__dfxtp_1
XFILLER_57_98 VGND VGND VPWR VPWR sky130_fd_sc_hd__fill_1
X_13742_ clknet_leaf_58_clk _00752_ VGND VGND VPWR VPWR u_interface.u_gelu_fp32.u_q16_to_fp32.s1_mag\[8\]
+ sky130_fd_sc_hd__dfxtp_1
XFILLER_75_389 VGND VGND VPWR VPWR sky130_fd_sc_hd__decap_3
XTAP_TAPCELL_ROW_3_382 VGND VPWR sky130_fd_sc_hd__tapvpwrvgnd_1
X_10954_ _04685_ _04697_ VGND VGND VPWR VPWR _04698_ sky130_fd_sc_hd__and2b_1
XFILLER_32_905 VPWR VGND VPWR VGND sky130_ef_sc_hd__decap_12
X_13673_ clknet_leaf_11_clk _00683_ VGND VGND VPWR VPWR u_interface.u_gelu_fp32.u_fp32_to_q16.s3_frac\[9\]
+ sky130_fd_sc_hd__dfxtp_1
X_10885_ net602 net404 u_interface.u_gelu_fp32.u_synth_top.s2_dx\[28\] net595 VGND
+ VGND VPWR VPWR _04630_ sky130_fd_sc_hd__a22oi_1
XFILLER_31_426 VGND VGND VPWR VPWR sky130_fd_sc_hd__fill_1
X_12624_ _06309_ _06320_ _06326_ VGND VGND VPWR VPWR _06327_ sky130_fd_sc_hd__and3b_1
XFILLER_31_459 VGND VGND VPWR VPWR sky130_fd_sc_hd__decap_4
X_12555_ net170 net165 net161 net160 net151 VGND VGND VPWR VPWR _00843_ sky130_fd_sc_hd__o2111a_1
XFILLER_11_161 VGND VGND VPWR VPWR sky130_fd_sc_hd__decap_6
X_11506_ _05241_ _05242_ _05243_ VGND VGND VPWR VPWR _05245_ sky130_fd_sc_hd__o21ai_1
XFILLER_144_328 VGND VGND VPWR VPWR sky130_fd_sc_hd__fill_1
XFILLER_144_317 VGND VGND VPWR VPWR sky130_fd_sc_hd__fill_1
X_12486_ _06210_ _06211_ VGND VGND VPWR VPWR _06212_ sky130_fd_sc_hd__nor2_1
XTAP_TAPCELL_ROW_22_690 VGND VPWR sky130_fd_sc_hd__tapvpwrvgnd_1
XFILLER_144_339 VGND VGND VPWR VPWR sky130_fd_sc_hd__decap_6
XFILLER_8_699 VGND VGND VPWR VPWR sky130_fd_sc_hd__fill_1
X_11437_ net625 net393 VGND VGND VPWR VPWR _05177_ sky130_fd_sc_hd__nand2_1
X_14156_ clknet_leaf_35_clk _01082_ VGND VGND VPWR VPWR u_interface.fifo_data\[1\]\[16\]
+ sky130_fd_sc_hd__dfxtp_1
XTAP_TAPCELL_ROW_74_1526 VGND VPWR sky130_fd_sc_hd__tapvpwrvgnd_1
XTAP_TAPCELL_ROW_74_1515 VGND VPWR sky130_fd_sc_hd__tapvpwrvgnd_1
X_11368_ _05106_ _05107_ VGND VGND VPWR VPWR _05109_ sky130_fd_sc_hd__xnor2_1
XFILLER_4_861 VGND VGND VPWR VPWR sky130_fd_sc_hd__decap_6
X_13107_ clknet_leaf_39_clk _00117_ VGND VGND VPWR VPWR u_interface.fifo_data\[15\]\[28\]
+ sky130_fd_sc_hd__dfxtp_1
XFILLER_125_597 VGND VGND VPWR VPWR sky130_fd_sc_hd__fill_1
XFILLER_113_726 VGND VGND VPWR VPWR sky130_fd_sc_hd__fill_2
XFILLER_112_214 VPWR VGND VPWR VGND sky130_ef_sc_hd__decap_12
XFILLER_98_426 VPWR VGND VPWR VGND sky130_ef_sc_hd__decap_12
XFILLER_98_83 VGND VGND VPWR VPWR sky130_fd_sc_hd__fill_1
X_10319_ _04067_ _04068_ _03952_ _03954_ VGND VGND VPWR VPWR _04069_ sky130_fd_sc_hd__a211oi_1
X_14087_ clknet_leaf_16_clk net1610 VGND VGND VPWR VPWR u_interface.u_gelu_fp32.u_fp32_to_q16.s2_norm_mag\[24\]
+ sky130_fd_sc_hd__dfxtp_1
X_11299_ net206 _05038_ VGND VGND VPWR VPWR _05040_ sky130_fd_sc_hd__xnor2_1
XFILLER_3_393 VPWR VGND VPWR VGND sky130_ef_sc_hd__decap_12
X_13038_ clknet_leaf_37_clk _00048_ VGND VGND VPWR VPWR u_interface.fifo_tuser\[7\]
+ sky130_fd_sc_hd__dfxtp_1
XFILLER_140_589 VGND VGND VPWR VPWR sky130_fd_sc_hd__decap_3
XFILLER_100_409 VGND VGND VPWR VPWR sky130_fd_sc_hd__decap_6
XFILLER_14_3 VPWR VGND VPWR VGND sky130_ef_sc_hd__decap_12
XFILLER_39_559 VGND VGND VPWR VPWR sky130_fd_sc_hd__fill_1
XTAP_TAPCELL_ROW_105_2014 VGND VPWR sky130_fd_sc_hd__tapvpwrvgnd_1
X_07530_ net548 _01558_ VGND VGND VPWR VPWR _01658_ sky130_fd_sc_hd__nor2_1
XFILLER_81_337 VGND VGND VPWR VPWR sky130_fd_sc_hd__fill_2
XFILLER_90_860 VGND VGND VPWR VPWR sky130_fd_sc_hd__decap_8
XFILLER_81_348 VPWR VGND VPWR VGND sky130_ef_sc_hd__decap_12
XFILLER_34_220 VPWR VGND VPWR VGND sky130_ef_sc_hd__decap_12
X_07461_ u_interface.u_gelu_fp32.u_fp32_to_q16.s2_norm_mag\[8\] net560 VGND VGND VPWR
+ VPWR _01596_ sky130_fd_sc_hd__and2_1
XTAP_TAPCELL_ROW_85_1699 VGND VPWR sky130_fd_sc_hd__tapvpwrvgnd_1
XTAP_TAPCELL_ROW_85_1688 VGND VPWR sky130_fd_sc_hd__tapvpwrvgnd_1
XFILLER_34_253 VGND VGND VPWR VPWR sky130_fd_sc_hd__fill_2
X_09200_ _02956_ _02957_ _02955_ VGND VGND VPWR VPWR _02959_ sky130_fd_sc_hd__a21bo_1
XFILLER_148_601 VGND VGND VPWR VPWR sky130_fd_sc_hd__decap_6
X_07392_ net1492 net573 net240 VGND VGND VPWR VPWR _00422_ sky130_fd_sc_hd__mux2_1
XFILLER_50_757 VGND VGND VPWR VPWR sky130_fd_sc_hd__fill_2
X_09131_ _02887_ _02888_ _02886_ VGND VGND VPWR VPWR _02890_ sky130_fd_sc_hd__o21bai_1
XFILLER_148_645 VGND VGND VPWR VPWR sky130_fd_sc_hd__decap_4
X_09062_ _02804_ _02820_ VGND VGND VPWR VPWR _02821_ sky130_fd_sc_hd__nor2_1
XTAP_TAPCELL_ROW_20_649 VGND VPWR sky130_fd_sc_hd__tapvpwrvgnd_1
XFILLER_135_306 VGND VGND VPWR VPWR sky130_fd_sc_hd__decap_6
X_08013_ net1312 net541 net819 VGND VGND VPWR VPWR _00708_ sky130_fd_sc_hd__mux2_1
XFILLER_116_531 VGND VGND VPWR VPWR sky130_fd_sc_hd__fill_1
XTAP_TAPCELL_ROW_116_2187 VGND VPWR sky130_fd_sc_hd__tapvpwrvgnd_1
Xhold611 u_interface.fifo_data\[4\]\[30\] VGND VGND VPWR VPWR net1476 sky130_fd_sc_hd__dlygate4sd3_1
Xhold600 u_interface.fifo_data\[3\]\[2\] VGND VGND VPWR VPWR net1465 sky130_fd_sc_hd__dlygate4sd3_1
XFILLER_150_309 VGND VGND VPWR VPWR sky130_fd_sc_hd__decap_3
Xhold622 u_interface.fifo_data\[3\]\[10\] VGND VGND VPWR VPWR net1487 sky130_fd_sc_hd__dlygate4sd3_1
Xhold633 u_interface.fifo_data\[7\]\[14\] VGND VGND VPWR VPWR net1498 sky130_fd_sc_hd__dlygate4sd3_1
XTAP_TAPCELL_ROW_116_2198 VGND VPWR sky130_fd_sc_hd__tapvpwrvgnd_1
XFILLER_116_553 VGND VGND VPWR VPWR sky130_fd_sc_hd__fill_1
Xhold644 u_interface.fifo_data\[3\]\[29\] VGND VGND VPWR VPWR net1509 sky130_fd_sc_hd__dlygate4sd3_1
Xhold655 u_interface.fifo_data\[3\]\[28\] VGND VGND VPWR VPWR net1520 sky130_fd_sc_hd__dlygate4sd3_1
XFILLER_131_523 VGND VGND VPWR VPWR sky130_fd_sc_hd__decap_8
Xhold666 u_interface.fifo_data\[3\]\[7\] VGND VGND VPWR VPWR net1531 sky130_fd_sc_hd__dlygate4sd3_1
XFILLER_103_225 VGND VGND VPWR VPWR sky130_fd_sc_hd__decap_6
Xhold688 u_interface.u_gelu_fp32.u_q16_to_fp32.s1_mag\[12\] VGND VGND VPWR VPWR net1553
+ sky130_fd_sc_hd__dlygate4sd3_1
Xhold677 u_interface.u_gelu_fp32.u_q16_to_fp32.s3_sign VGND VGND VPWR VPWR net1542
+ sky130_fd_sc_hd__dlygate4sd3_1
XFILLER_131_567 VGND VGND VPWR VPWR sky130_fd_sc_hd__decap_4
Xhold699 u_interface.fifo_data\[4\]\[19\] VGND VGND VPWR VPWR net1564 sky130_fd_sc_hd__dlygate4sd3_1
XFILLER_103_247 VGND VGND VPWR VPWR sky130_fd_sc_hd__fill_2
X_09964_ _03715_ _03716_ _03703_ VGND VGND VPWR VPWR _03717_ sky130_fd_sc_hd__o21ai_1
X_08915_ _02671_ _02672_ VGND VGND VPWR VPWR _02674_ sky130_fd_sc_hd__xnor2_1
X_09895_ _03647_ VGND VGND VPWR VPWR _03648_ sky130_fd_sc_hd__inv_2
X_08846_ net623 net476 net630 net480 VGND VGND VPWR VPWR _02605_ sky130_fd_sc_hd__a22o_1
XFILLER_94_19 VGND VGND VPWR VPWR sky130_fd_sc_hd__fill_1
XFILLER_85_687 VGND VGND VPWR VPWR sky130_fd_sc_hd__decap_4
X_08777_ net629 net484 _02529_ _02528_ VGND VGND VPWR VPWR _02536_ sky130_fd_sc_hd__a31o_1
XFILLER_73_838 VGND VGND VPWR VPWR sky130_fd_sc_hd__fill_2
XTAP_TAPCELL_ROW_0_330 VGND VPWR sky130_fd_sc_hd__tapvpwrvgnd_1
XFILLER_27_57 VPWR VGND VPWR VGND sky130_ef_sc_hd__decap_12
XFILLER_38_570 VGND VGND VPWR VPWR sky130_fd_sc_hd__fill_1
XFILLER_38_581 VGND VGND VPWR VPWR sky130_fd_sc_hd__decap_6
X_07728_ net1753 _01435_ _01441_ _01766_ VGND VGND VPWR VPWR _00520_ sky130_fd_sc_hd__or4_1
XTAP_TAPCELL_ROW_0_341 VGND VPWR sky130_fd_sc_hd__tapvpwrvgnd_1
XFILLER_14_905 VPWR VGND VPWR VGND sky130_ef_sc_hd__decap_12
XFILLER_25_220 VGND VGND VPWR VPWR sky130_fd_sc_hd__decap_4
X_07659_ u_interface.u_gelu_fp32.u_q16_to_fp32.s2_mag\[13\] u_interface.u_gelu_fp32.u_q16_to_fp32.s2_mag\[12\]
+ u_interface.u_gelu_fp32.u_q16_to_fp32.s2_mag\[11\] u_interface.u_gelu_fp32.u_q16_to_fp32.s2_mag\[10\]
+ net337 net333 VGND VGND VPWR VPWR _01742_ sky130_fd_sc_hd__mux4_1
X_10670_ _04371_ _04372_ _04414_ _04415_ VGND VGND VPWR VPWR _04417_ sky130_fd_sc_hd__or4bb_4
X_09329_ _02919_ _03087_ VGND VGND VPWR VPWR _03088_ sky130_fd_sc_hd__or2_1
XFILLER_138_100 VGND VGND VPWR VPWR sky130_fd_sc_hd__fill_1
XTAP_TAPCELL_ROW_136_2519 VGND VPWR sky130_fd_sc_hd__tapvpwrvgnd_1
XTAP_TAPCELL_ROW_136_2508 VGND VPWR sky130_fd_sc_hd__tapvpwrvgnd_1
XFILLER_21_470 VPWR VGND VPWR VGND sky130_ef_sc_hd__decap_12
XFILLER_126_306 VGND VGND VPWR VPWR sky130_fd_sc_hd__fill_2
X_12340_ net177 _06006_ _06009_ VGND VGND VPWR VPWR _06068_ sky130_fd_sc_hd__nor3_1
X_12271_ net183 _05941_ _05940_ VGND VGND VPWR VPWR _06000_ sky130_fd_sc_hd__a21o_1
X_14010_ clknet_leaf_50_clk net1551 VGND VGND VPWR VPWR u_interface.u_gelu_fp32.u_q16_to_fp32.s3_exp\[7\]
+ sky130_fd_sc_hd__dfxtp_1
X_11222_ _04962_ _04963_ VGND VGND VPWR VPWR _04964_ sky130_fd_sc_hd__or2_1
XFILLER_135_895 VGND VGND VPWR VPWR sky130_fd_sc_hd__fill_1
XTAP_TAPCELL_ROW_56_1234 VGND VPWR sky130_fd_sc_hd__tapvpwrvgnd_1
XFILLER_122_545 VGND VGND VPWR VPWR sky130_fd_sc_hd__decap_4
XFILLER_68_53 VGND VGND VPWR VPWR sky130_fd_sc_hd__decap_4
X_11153_ _04893_ _04894_ VGND VGND VPWR VPWR _04896_ sky130_fd_sc_hd__xor2_1
XTAP_TAPCELL_ROW_8_463 VGND VPWR sky130_fd_sc_hd__tapvpwrvgnd_1
XFILLER_1_853 VPWR VGND VPWR VGND sky130_ef_sc_hd__decap_12
XFILLER_122_589 VPWR VGND VPWR VGND sky130_ef_sc_hd__decap_12
X_10104_ net196 _03853_ _03854_ VGND VGND VPWR VPWR _03856_ sky130_fd_sc_hd__or3_1
X_11084_ _04737_ _04739_ _04825_ VGND VGND VPWR VPWR _04827_ sky130_fd_sc_hd__a21o_1
XFILLER_1_897 VPWR VGND VPWR VGND sky130_ef_sc_hd__decap_12
XFILLER_88_481 VGND VGND VPWR VPWR sky130_fd_sc_hd__fill_2
X_10035_ net610 net619 net446 net441 VGND VGND VPWR VPWR _03787_ sky130_fd_sc_hd__and4_1
XFILLER_76_632 VGND VGND VPWR VPWR sky130_fd_sc_hd__decap_3
XFILLER_91_646 VGND VGND VPWR VPWR sky130_fd_sc_hd__decap_8
XFILLER_57_890 VGND VGND VPWR VPWR sky130_fd_sc_hd__decap_6
XFILLER_48_389 VGND VGND VPWR VPWR sky130_fd_sc_hd__decap_8
XFILLER_17_721 VGND VGND VPWR VPWR sky130_fd_sc_hd__decap_6
XFILLER_17_765 VPWR VGND VPWR VGND sky130_ef_sc_hd__decap_12
X_11986_ _05718_ _05649_ VGND VGND VPWR VPWR _05720_ sky130_fd_sc_hd__and2b_1
X_13725_ clknet_leaf_7_clk _00735_ VGND VGND VPWR VPWR u_interface.u_gelu_fp32.s1_data\[25\]
+ sky130_fd_sc_hd__dfxtp_1
X_10937_ _03172_ _04680_ VGND VGND VPWR VPWR _04681_ sky130_fd_sc_hd__nand2_1
XTAP_TAPCELL_ROW_27_760 VGND VPWR sky130_fd_sc_hd__tapvpwrvgnd_1
XTAP_TAPCELL_ROW_27_771 VGND VPWR sky130_fd_sc_hd__tapvpwrvgnd_1
XFILLER_32_713 VPWR VGND VPWR VGND sky130_ef_sc_hd__decap_12
X_13656_ clknet_leaf_15_clk _00666_ VGND VGND VPWR VPWR u_interface.u_gelu_fp32.u_fp32_to_q16.s1_exp\[2\]
+ sky130_fd_sc_hd__dfxtp_1
XFILLER_16_297 VGND VGND VPWR VPWR sky130_fd_sc_hd__decap_4
XFILLER_32_757 VPWR VGND VPWR VGND sky130_ef_sc_hd__decap_12
X_12607_ u_interface.u_gelu_fp32.u_q16_to_fp32.s1_mag\[4\] net212 u_interface.u_gelu_fp32.u_q16_to_fp32.s1_mag\[20\]
+ VGND VGND VPWR VPWR _06310_ sky130_fd_sc_hd__a21o_1
X_10868_ _04525_ _04527_ _04612_ VGND VGND VPWR VPWR _04613_ sky130_fd_sc_hd__nand3_1
X_10799_ _04543_ _04544_ _04419_ _04422_ VGND VGND VPWR VPWR _04545_ sky130_fd_sc_hd__o211a_1
X_13587_ clknet_leaf_73_clk _00597_ VGND VGND VPWR VPWR u_interface.fifo_data\[3\]\[2\]
+ sky130_fd_sc_hd__dfxtp_1
X_12538_ _06222_ _06261_ _06259_ VGND VGND VPWR VPWR _06262_ sky130_fd_sc_hd__a21oi_1
XFILLER_144_114 VGND VGND VPWR VPWR sky130_fd_sc_hd__decap_3
XFILLER_117_328 VGND VGND VPWR VPWR sky130_fd_sc_hd__decap_8
X_12469_ _06146_ _06148_ _06194_ VGND VGND VPWR VPWR _06195_ sky130_fd_sc_hd__and3_1
X_14208_ net145 VGND VGND VPWR VPWR net149 sky130_fd_sc_hd__clkbuf_1
XFILLER_132_309 VPWR VGND VPWR VGND sky130_ef_sc_hd__decap_12
XFILLER_126_851 VGND VGND VPWR VPWR sky130_fd_sc_hd__fill_1
XFILLER_153_670 VGND VGND VPWR VPWR sky130_fd_sc_hd__fill_2
XFILLER_113_512 VGND VGND VPWR VPWR sky130_fd_sc_hd__decap_8
XFILLER_113_501 VGND VGND VPWR VPWR sky130_fd_sc_hd__decap_3
XFILLER_99_724 VGND VGND VPWR VPWR sky130_fd_sc_hd__fill_1
XFILLER_98_212 VGND VGND VPWR VPWR sky130_fd_sc_hd__decap_3
X_14139_ clknet_leaf_37_clk _01065_ VGND VGND VPWR VPWR u_interface.fifo_tuser\[9\]
+ sky130_fd_sc_hd__dfxtp_1
XFILLER_140_331 VPWR VGND VPWR VGND sky130_ef_sc_hd__decap_12
XFILLER_101_707 VGND VGND VPWR VPWR sky130_fd_sc_hd__decap_4
Xfanout409 u_interface.u_gelu_fp32.u_synth_top.s2_dx\[26\] VGND VGND VPWR VPWR net409
+ sky130_fd_sc_hd__buf_2
XFILLER_98_289 VGND VGND VPWR VPWR sky130_fd_sc_hd__fill_1
X_06961_ _01488_ _01489_ VGND VGND VPWR VPWR _00029_ sky130_fd_sc_hd__xnor2_1
X_08700_ _02456_ _02458_ VGND VGND VPWR VPWR _02459_ sky130_fd_sc_hd__and2b_1
X_09680_ net472 net656 VGND VGND VPWR VPWR _03435_ sky130_fd_sc_hd__and2_1
X_06892_ _01130_ _01434_ VGND VGND VPWR VPWR _00032_ sky130_fd_sc_hd__xnor2_1
XFILLER_104_29 VGND VGND VPWR VPWR sky130_fd_sc_hd__decap_8
XTAP_TAPCELL_ROW_87_1728 VGND VPWR sky130_fd_sc_hd__tapvpwrvgnd_1
X_08631_ net153 _02403_ net793 VGND VGND VPWR VPWR _00794_ sky130_fd_sc_hd__a21oi_1
XFILLER_82_624 VPWR VGND VPWR VGND sky130_ef_sc_hd__decap_12
XFILLER_54_304 VGND VGND VPWR VPWR sky130_fd_sc_hd__decap_4
XFILLER_81_123 VGND VGND VPWR VPWR sky130_fd_sc_hd__fill_2
XFILLER_54_348 VGND VGND VPWR VPWR sky130_fd_sc_hd__decap_8
X_08562_ _02319_ _02323_ _02350_ _02352_ VGND VGND VPWR VPWR _02353_ sky130_fd_sc_hd__nand4_1
X_07513_ _01640_ _01643_ net310 VGND VGND VPWR VPWR _01644_ sky130_fd_sc_hd__mux2_1
X_08493_ u_interface.u_gelu_fp32.u_synth_top.s3_mult\[41\] u_interface.u_gelu_fp32.u_synth_top.s3_mult\[40\]
+ net526 VGND VGND VPWR VPWR _02284_ sky130_fd_sc_hd__o21a_1
X_07444_ u_interface.u_gelu_fp32.u_fp32_to_q16.s2_norm_mag\[27\] u_interface.u_gelu_fp32.u_fp32_to_q16.s2_norm_mag\[28\]
+ net559 VGND VGND VPWR VPWR _01579_ sky130_fd_sc_hd__mux2_1
XFILLER_13_15 VPWR VGND VPWR VGND sky130_ef_sc_hd__decap_12
XTAP_TAPCELL_ROW_118_2227 VGND VPWR sky130_fd_sc_hd__tapvpwrvgnd_1
XTAP_TAPCELL_ROW_118_2216 VGND VPWR sky130_fd_sc_hd__tapvpwrvgnd_1
X_07375_ net1260 net369 net237 VGND VGND VPWR VPWR _00405_ sky130_fd_sc_hd__mux2_1
X_09114_ _02849_ _02850_ _02851_ _02832_ VGND VGND VPWR VPWR _02873_ sky130_fd_sc_hd__a2bb2o_1
X_09045_ _02765_ _02802_ _02803_ VGND VGND VPWR VPWR _02804_ sky130_fd_sc_hd__and3_1
XFILLER_135_169 VGND VGND VPWR VPWR sky130_fd_sc_hd__decap_8
XTAP_TAPCELL_ROW_131_2438 VGND VPWR sky130_fd_sc_hd__tapvpwrvgnd_1
XTAP_TAPCELL_ROW_131_2427 VGND VPWR sky130_fd_sc_hd__tapvpwrvgnd_1
Xhold441 u_interface.fifo_data\[12\]\[28\] VGND VGND VPWR VPWR net1306 sky130_fd_sc_hd__dlygate4sd3_1
Xhold463 u_interface.fifo_data\[8\]\[24\] VGND VGND VPWR VPWR net1328 sky130_fd_sc_hd__dlygate4sd3_1
Xmax_cap171 _04182_ VGND VGND VPWR VPWR net171 sky130_fd_sc_hd__clkbuf_1
Xhold430 u_interface.fifo_data\[4\]\[12\] VGND VGND VPWR VPWR net1295 sky130_fd_sc_hd__dlygate4sd3_1
Xhold452 u_interface.fifo_data\[4\]\[0\] VGND VGND VPWR VPWR net1317 sky130_fd_sc_hd__dlygate4sd3_1
XFILLER_1_105 VGND VGND VPWR VPWR sky130_fd_sc_hd__decap_6
XFILLER_143_191 VPWR VGND VPWR VGND sky130_ef_sc_hd__decap_12
Xhold474 u_interface.fifo_data\[0\]\[28\] VGND VGND VPWR VPWR net1339 sky130_fd_sc_hd__dlygate4sd3_1
XFILLER_131_320 VPWR VGND VPWR VGND sky130_ef_sc_hd__decap_12
Xhold496 u_interface.fifo_data\[0\]\[26\] VGND VGND VPWR VPWR net1361 sky130_fd_sc_hd__dlygate4sd3_1
XFILLER_89_223 VGND VGND VPWR VPWR sky130_fd_sc_hd__fill_1
Xhold485 u_interface.fifo_data\[5\]\[15\] VGND VGND VPWR VPWR net1350 sky130_fd_sc_hd__dlygate4sd3_1
XFILLER_1_149 VPWR VGND VPWR VGND sky130_ef_sc_hd__decap_12
X_09947_ _03696_ _03697_ _03698_ VGND VGND VPWR VPWR _03700_ sky130_fd_sc_hd__a21o_1
XTAP_TAPCELL_ROW_5_422 VGND VPWR sky130_fd_sc_hd__tapvpwrvgnd_1
XTAP_TAPCELL_ROW_5_411 VGND VPWR sky130_fd_sc_hd__tapvpwrvgnd_1
XFILLER_131_386 VGND VGND VPWR VPWR sky130_fd_sc_hd__decap_6
XTAP_TAPCELL_ROW_51_1153 VGND VPWR sky130_fd_sc_hd__tapvpwrvgnd_1
XTAP_TAPCELL_ROW_146_2670 VGND VPWR sky130_fd_sc_hd__tapvpwrvgnd_1
X_09878_ net782 _03630_ _03631_ VGND VGND VPWR VPWR _00813_ sky130_fd_sc_hd__and3_1
XFILLER_73_602 VGND VGND VPWR VPWR sky130_fd_sc_hd__decap_4
XFILLER_46_805 VGND VGND VPWR VPWR sky130_fd_sc_hd__decap_6
X_08829_ _02457_ _02459_ VGND VGND VPWR VPWR _02588_ sky130_fd_sc_hd__xnor2_1
XFILLER_72_101 VGND VGND VPWR VPWR sky130_fd_sc_hd__fill_1
XFILLER_57_175 VPWR VGND VPWR VGND sky130_ef_sc_hd__decap_12
XFILLER_73_668 VGND VGND VPWR VPWR sky130_fd_sc_hd__decap_4
XFILLER_45_337 VPWR VGND VPWR VGND sky130_ef_sc_hd__decap_12
XFILLER_26_540 VPWR VGND VPWR VGND sky130_ef_sc_hd__decap_12
X_11840_ net199 _05573_ VGND VGND VPWR VPWR _05575_ sky130_fd_sc_hd__nor2_1
XFILLER_54_33 VGND VGND VPWR VPWR sky130_fd_sc_hd__fill_1
XFILLER_14_713 VPWR VGND VPWR VGND sky130_ef_sc_hd__decap_12
X_11771_ _05501_ _05506_ VGND VGND VPWR VPWR _05507_ sky130_fd_sc_hd__xor2_1
X_13510_ clknet_leaf_3_clk _00520_ VGND VGND VPWR VPWR u_interface.u_gelu_fp32.u_synth_top.s2_m\[1\]
+ sky130_fd_sc_hd__dfxtp_1
X_10722_ _04226_ _04467_ VGND VGND VPWR VPWR _04468_ sky130_fd_sc_hd__xnor2_1
XFILLER_54_99 VGND VGND VPWR VPWR sky130_fd_sc_hd__decap_8
XFILLER_53_381 VGND VGND VPWR VPWR sky130_fd_sc_hd__fill_2
XFILLER_13_223 VGND VGND VPWR VPWR sky130_fd_sc_hd__fill_1
XFILLER_14_757 VPWR VGND VPWR VGND sky130_ef_sc_hd__decap_12
XFILLER_110_61 VGND VGND VPWR VPWR sky130_fd_sc_hd__decap_6
XFILLER_9_216 VGND VGND VPWR VPWR sky130_fd_sc_hd__decap_8
XFILLER_13_245 VGND VGND VPWR VPWR sky130_fd_sc_hd__decap_3
XFILLER_41_554 VGND VGND VPWR VPWR sky130_fd_sc_hd__fill_1
XFILLER_139_442 VGND VGND VPWR VPWR sky130_fd_sc_hd__fill_2
X_13441_ clknet_leaf_10_clk _00451_ VGND VGND VPWR VPWR u_interface.u_gelu_fp32.u_fp32_to_q16.s3_mag\[12\]
+ sky130_fd_sc_hd__dfxtp_1
X_10653_ net609 net417 net414 net603 VGND VGND VPWR VPWR _04400_ sky130_fd_sc_hd__a22o_1
XFILLER_13_289 VGND VGND VPWR VPWR sky130_fd_sc_hd__fill_2
XFILLER_139_464 VGND VGND VPWR VPWR sky130_fd_sc_hd__decap_4
X_13372_ clknet_leaf_26_clk _00382_ VGND VGND VPWR VPWR u_interface.fifo_data\[7\]\[17\]
+ sky130_fd_sc_hd__dfxtp_1
X_10584_ _04329_ _04330_ _04321_ VGND VGND VPWR VPWR _04331_ sky130_fd_sc_hd__a21o_1
XFILLER_154_412 VGND VGND VPWR VPWR sky130_fd_sc_hd__fill_1
Xclkload19 clknet_leaf_89_clk VGND VGND VPWR VPWR clkload19/Y sky130_fd_sc_hd__inv_16
X_12323_ _06050_ _06051_ VGND VGND VPWR VPWR _06052_ sky130_fd_sc_hd__nand2b_1
XFILLER_119_81 VGND VGND VPWR VPWR sky130_fd_sc_hd__decap_4
XFILLER_5_444 VGND VGND VPWR VPWR sky130_fd_sc_hd__decap_4
XFILLER_123_832 VGND VGND VPWR VPWR sky130_fd_sc_hd__decap_8
XFILLER_107_361 VGND VGND VPWR VPWR sky130_fd_sc_hd__decap_4
X_12254_ _05942_ _05983_ VGND VGND VPWR VPWR _05984_ sky130_fd_sc_hd__xor2_1
X_11205_ net711 net448 VGND VGND VPWR VPWR _04947_ sky130_fd_sc_hd__nand2_1
X_12185_ _05914_ _05915_ VGND VGND VPWR VPWR _05916_ sky130_fd_sc_hd__or2_1
XFILLER_110_504 VGND VGND VPWR VPWR sky130_fd_sc_hd__decap_8
XFILLER_96_738 VGND VGND VPWR VPWR sky130_fd_sc_hd__decap_3
XFILLER_95_204 VGND VGND VPWR VPWR sky130_fd_sc_hd__fill_2
X_11136_ _04756_ _04763_ _04762_ VGND VGND VPWR VPWR _04879_ sky130_fd_sc_hd__a21boi_1
XFILLER_150_695 VGND VGND VPWR VPWR sky130_fd_sc_hd__decap_4
XFILLER_49_610 VGND VGND VPWR VPWR sky130_fd_sc_hd__decap_6
X_11067_ _04795_ _04809_ VGND VGND VPWR VPWR _04810_ sky130_fd_sc_hd__xnor2_1
XFILLER_0_193 VGND VGND VPWR VPWR sky130_fd_sc_hd__decap_3
XFILLER_95_95 VGND VGND VPWR VPWR sky130_fd_sc_hd__fill_1
X_10018_ _03760_ _03767_ _03768_ VGND VGND VPWR VPWR _03770_ sky130_fd_sc_hd__nand3_1
XTAP_TAPCELL_ROW_69_1436 VGND VPWR sky130_fd_sc_hd__tapvpwrvgnd_1
XFILLER_49_687 VGND VGND VPWR VPWR sky130_fd_sc_hd__fill_2
XFILLER_37_838 VGND VGND VPWR VPWR sky130_fd_sc_hd__fill_2
XTAP_TAPCELL_ROW_69_1447 VGND VPWR sky130_fd_sc_hd__tapvpwrvgnd_1
XFILLER_64_657 VGND VGND VPWR VPWR sky130_fd_sc_hd__decap_4
XFILLER_52_808 VGND VGND VPWR VPWR sky130_fd_sc_hd__decap_4
XFILLER_36_359 VGND VGND VPWR VPWR sky130_fd_sc_hd__fill_1
XFILLER_63_167 VGND VGND VPWR VPWR sky130_fd_sc_hd__fill_1
XFILLER_17_573 VPWR VGND VPWR VGND sky130_ef_sc_hd__decap_12
X_13708_ clknet_leaf_2_clk _00718_ VGND VGND VPWR VPWR u_interface.u_gelu_fp32.s1_data\[8\]
+ sky130_fd_sc_hd__dfxtp_1
XTAP_TAPCELL_ROW_82_1647 VGND VPWR sky130_fd_sc_hd__tapvpwrvgnd_1
XFILLER_60_830 VGND VGND VPWR VPWR sky130_fd_sc_hd__decap_8
X_11969_ _05702_ _05701_ VGND VGND VPWR VPWR _05703_ sky130_fd_sc_hd__and2b_1
X_13639_ clknet_leaf_37_clk _00649_ VGND VGND VPWR VPWR u_interface.fifo_data\[13\]\[22\]
+ sky130_fd_sc_hd__dfxtp_1
XFILLER_81_3 VPWR VGND VPWR VGND sky130_ef_sc_hd__decap_12
XFILLER_20_749 VGND VGND VPWR VPWR sky130_fd_sc_hd__decap_6
XFILLER_32_587 VGND VGND VPWR VPWR sky130_fd_sc_hd__fill_1
X_07160_ net1470 net384 net262 VGND VGND VPWR VPWR _00200_ sky130_fd_sc_hd__mux2_1
X_07091_ net1432 net364 net227 VGND VGND VPWR VPWR _00131_ sky130_fd_sc_hd__mux2_1
XFILLER_9_783 VGND VGND VPWR VPWR sky130_fd_sc_hd__fill_1
XFILLER_8_271 VGND VGND VPWR VPWR sky130_fd_sc_hd__fill_2
XFILLER_117_169 VGND VGND VPWR VPWR sky130_fd_sc_hd__fill_1
XTAP_TAPCELL_ROW_113_2146 VGND VPWR sky130_fd_sc_hd__tapvpwrvgnd_1
XTAP_TAPCELL_ROW_97_1890 VGND VPWR sky130_fd_sc_hd__tapvpwrvgnd_1
XTAP_TAPCELL_ROW_10_490 VGND VPWR sky130_fd_sc_hd__tapvpwrvgnd_1
XFILLER_141_673 VGND VGND VPWR VPWR sky130_fd_sc_hd__decap_3
Xfanout228 _01521_ VGND VGND VPWR VPWR net228 sky130_fd_sc_hd__clkbuf_8
XFILLER_115_28 VPWR VGND VPWR VGND sky130_ef_sc_hd__decap_12
X_09801_ _03552_ _03553_ _03491_ _03493_ VGND VGND VPWR VPWR _03555_ sky130_fd_sc_hd__o211ai_1
XFILLER_87_727 VGND VGND VPWR VPWR sky130_fd_sc_hd__fill_1
Xfanout217 net218 VGND VGND VPWR VPWR net217 sky130_fd_sc_hd__buf_4
Xfanout206 _04699_ VGND VGND VPWR VPWR net206 sky130_fd_sc_hd__clkbuf_2
XFILLER_5_93 VPWR VGND VPWR VGND sky130_ef_sc_hd__decap_12
Xfanout239 net240 VGND VGND VPWR VPWR net239 sky130_fd_sc_hd__buf_4
X_07993_ net308 net301 _01665_ net1739 net813 VGND VGND VPWR VPWR _01860_ sky130_fd_sc_hd__a32o_1
X_09732_ net490 net689 net696 net495 VGND VGND VPWR VPWR _03487_ sky130_fd_sc_hd__a22o_1
XFILLER_86_248 VGND VGND VPWR VPWR sky130_fd_sc_hd__decap_4
XFILLER_101_559 VGND VGND VPWR VPWR sky130_fd_sc_hd__fill_1
X_06944_ _01468_ _01469_ _01473_ VGND VGND VPWR VPWR _01476_ sky130_fd_sc_hd__or3_1
XFILLER_28_805 VGND VGND VPWR VPWR sky130_fd_sc_hd__decap_6
X_09663_ _03320_ _03322_ _03318_ VGND VGND VPWR VPWR _03419_ sky130_fd_sc_hd__o21bai_1
X_06875_ _01418_ _01419_ net729 VGND VGND VPWR VPWR _01420_ sky130_fd_sc_hd__mux2_1
XFILLER_55_613 VGND VGND VPWR VPWR sky130_fd_sc_hd__decap_3
XFILLER_28_849 VPWR VGND VPWR VGND sky130_ef_sc_hd__decap_12
XFILLER_39_186 VPWR VGND VPWR VGND sky130_ef_sc_hd__decap_12
X_09594_ _03346_ _03349_ VGND VGND VPWR VPWR _03350_ sky130_fd_sc_hd__xnor2_1
X_08614_ _02181_ _02236_ VGND VGND VPWR VPWR _02391_ sky130_fd_sc_hd__xnor2_1
XFILLER_54_134 VGND VGND VPWR VPWR sky130_fd_sc_hd__fill_1
XFILLER_27_337 VGND VGND VPWR VPWR sky130_fd_sc_hd__decap_8
XFILLER_27_359 VGND VGND VPWR VPWR sky130_fd_sc_hd__fill_2
X_08545_ net523 u_interface.u_gelu_fp32.u_synth_top.s3_mult\[46\] _02335_ VGND VGND
+ VPWR VPWR _02336_ sky130_fd_sc_hd__a21oi_1
XFILLER_42_307 VGND VGND VPWR VPWR sky130_fd_sc_hd__fill_1
XFILLER_23_532 VGND VGND VPWR VPWR sky130_fd_sc_hd__decap_3
X_08476_ net522 u_interface.u_gelu_fp32.u_synth_top.s3_mult\[43\] VGND VGND VPWR VPWR
+ _02267_ sky130_fd_sc_hd__xnor2_1
X_07427_ _01561_ _01562_ net557 VGND VGND VPWR VPWR _01563_ sky130_fd_sc_hd__mux2_1
XFILLER_11_727 VGND VGND VPWR VPWR sky130_fd_sc_hd__fill_1
XFILLER_10_204 VPWR VGND VPWR VGND sky130_ef_sc_hd__decap_12
XFILLER_155_209 VGND VGND VPWR VPWR sky130_fd_sc_hd__decap_4
X_07358_ net577 net1570 net244 VGND VGND VPWR VPWR _00388_ sky130_fd_sc_hd__mux2_1
XFILLER_7_709 VPWR VGND VPWR VGND sky130_ef_sc_hd__decap_12
XFILLER_148_294 VGND VGND VPWR VPWR sky130_fd_sc_hd__fill_1
X_07289_ net1160 net349 net246 VGND VGND VPWR VPWR _00319_ sky130_fd_sc_hd__mux2_1
X_09028_ net632 net502 net508 net638 VGND VGND VPWR VPWR _02787_ sky130_fd_sc_hd__a22oi_2
XFILLER_117_681 VGND VGND VPWR VPWR sky130_fd_sc_hd__fill_2
Xhold271 u_interface.fifo_data\[13\]\[22\] VGND VGND VPWR VPWR net1136 sky130_fd_sc_hd__dlygate4sd3_1
Xhold260 u_interface.fifo_data\[15\]\[19\] VGND VGND VPWR VPWR net1125 sky130_fd_sc_hd__dlygate4sd3_1
XTAP_TAPCELL_ROW_148_2710 VGND VPWR sky130_fd_sc_hd__tapvpwrvgnd_1
Xhold282 u_interface.fifo_data\[12\]\[10\] VGND VGND VPWR VPWR net1147 sky130_fd_sc_hd__dlygate4sd3_1
XFILLER_120_802 VGND VGND VPWR VPWR sky130_fd_sc_hd__decap_4
Xhold293 u_interface.fifo_data\[6\]\[18\] VGND VGND VPWR VPWR net1158 sky130_fd_sc_hd__dlygate4sd3_1
XFILLER_77_204 VGND VGND VPWR VPWR sky130_fd_sc_hd__decap_6
XFILLER_49_55 VGND VGND VPWR VPWR sky130_fd_sc_hd__fill_1
XFILLER_2_469 VGND VGND VPWR VPWR sky130_fd_sc_hd__decap_6
Xfanout751 net754 VGND VGND VPWR VPWR net751 sky130_fd_sc_hd__buf_2
Xfanout740 net742 VGND VGND VPWR VPWR net740 sky130_fd_sc_hd__clkbuf_4
Xfanout784 net792 VGND VGND VPWR VPWR net784 sky130_fd_sc_hd__buf_2
Xfanout762 _00000_ VGND VGND VPWR VPWR net762 sky130_fd_sc_hd__buf_2
Xfanout773 net792 VGND VGND VPWR VPWR net773 sky130_fd_sc_hd__buf_2
X_13990_ clknet_leaf_60_clk _00916_ VGND VGND VPWR VPWR u_interface.u_gelu_fp32.u_q16_to_fp32.s3_norm_mag\[17\]
+ sky130_fd_sc_hd__dfxtp_1
X_12941_ u_interface.in_flight_count\[4\] _01100_ _01535_ _06459_ _06463_ VGND VGND
+ VPWR VPWR _06464_ sky130_fd_sc_hd__a41o_1
Xfanout795 net2 VGND VGND VPWR VPWR net795 sky130_fd_sc_hd__buf_2
XFILLER_45_101 VGND VGND VPWR VPWR sky130_fd_sc_hd__decap_3
XFILLER_18_326 VGND VGND VPWR VPWR sky130_fd_sc_hd__decap_8
XTAP_TAPCELL_ROW_29_800 VGND VPWR sky130_fd_sc_hd__tapvpwrvgnd_1
X_12872_ net1245 u_interface.u_gelu_fp32.u_fp32_to_q16.s2_norm_mag\[27\] net818 VGND
+ VGND VPWR VPWR _01016_ sky130_fd_sc_hd__mux2_1
XFILLER_85_281 VGND VGND VPWR VPWR sky130_fd_sc_hd__decap_3
XFILLER_73_443 VGND VGND VPWR VPWR sky130_fd_sc_hd__decap_4
X_11823_ _05556_ _05557_ VGND VGND VPWR VPWR _05559_ sky130_fd_sc_hd__xor2_1
XFILLER_33_318 VPWR VGND VPWR VGND sky130_ef_sc_hd__decap_12
XFILLER_26_381 VGND VGND VPWR VPWR sky130_fd_sc_hd__decap_8
XTAP_TAPCELL_ROW_64_1366 VGND VPWR sky130_fd_sc_hd__tapvpwrvgnd_1
XTAP_TAPCELL_ROW_64_1355 VGND VPWR sky130_fd_sc_hd__tapvpwrvgnd_1
X_11754_ net179 _05489_ VGND VGND VPWR VPWR _05490_ sky130_fd_sc_hd__nand2_1
X_10705_ _04321_ _04329_ _04330_ VGND VGND VPWR VPWR _04451_ sky130_fd_sc_hd__a21bo_1
XFILLER_14_587 VGND VGND VPWR VPWR sky130_fd_sc_hd__fill_1
X_11685_ _05419_ _05420_ _05415_ VGND VGND VPWR VPWR _05422_ sky130_fd_sc_hd__a21o_1
X_13424_ clknet_leaf_11_clk _00434_ VGND VGND VPWR VPWR u_interface.u_gelu_fp32.u_fp32_to_q16.s3_frac\[4\]
+ sky130_fd_sc_hd__dfxtp_1
X_10636_ _04379_ _04380_ _04381_ VGND VGND VPWR VPWR _04383_ sky130_fd_sc_hd__nand3_1
XFILLER_155_776 VGND VGND VPWR VPWR sky130_fd_sc_hd__decap_4
XFILLER_143_905 VGND VGND VPWR VPWR sky130_fd_sc_hd__fill_1
X_10567_ _04200_ _04313_ VGND VGND VPWR VPWR _04315_ sky130_fd_sc_hd__nand2_1
X_13355_ clknet_leaf_62_clk _00365_ VGND VGND VPWR VPWR u_interface.fifo_data\[7\]\[0\]
+ sky130_fd_sc_hd__dfxtp_1
XFILLER_10_793 VPWR VGND VPWR VGND sky130_ef_sc_hd__decap_12
XFILLER_142_404 VGND VGND VPWR VPWR sky130_fd_sc_hd__decap_8
X_13286_ clknet_leaf_40_clk _00296_ VGND VGND VPWR VPWR u_interface.fifo_data\[0\]\[28\]
+ sky130_fd_sc_hd__dfxtp_1
XFILLER_115_629 VGND VGND VPWR VPWR sky130_fd_sc_hd__decap_4
X_10498_ _04240_ _04243_ _04244_ VGND VGND VPWR VPWR _04246_ sky130_fd_sc_hd__nand3_1
X_12306_ _06033_ _06034_ VGND VGND VPWR VPWR _06035_ sky130_fd_sc_hd__and2b_1
XFILLER_114_128 VGND VGND VPWR VPWR sky130_fd_sc_hd__fill_1
X_12237_ _05964_ _05965_ VGND VGND VPWR VPWR _05967_ sky130_fd_sc_hd__xor2_1
XFILLER_122_150 VGND VGND VPWR VPWR sky130_fd_sc_hd__decap_3
XFILLER_96_513 VGND VGND VPWR VPWR sky130_fd_sc_hd__fill_1
XFILLER_150_481 VPWR VGND VPWR VGND sky130_ef_sc_hd__decap_12
X_12168_ net692 net395 _05832_ _05831_ VGND VGND VPWR VPWR _05899_ sky130_fd_sc_hd__a31o_1
X_11119_ _04851_ _04859_ VGND VGND VPWR VPWR _04862_ sky130_fd_sc_hd__nand2_1
X_12099_ net684 net390 _05829_ VGND VGND VPWR VPWR _05831_ sky130_fd_sc_hd__and3_1
Xinput6 s_axil_araddr[12] VGND VGND VPWR VPWR net6 sky130_fd_sc_hd__clkbuf_1
XFILLER_64_432 VPWR VGND VPWR VGND sky130_ef_sc_hd__decap_12
XFILLER_64_421 VGND VGND VPWR VPWR sky130_fd_sc_hd__fill_1
X_06660_ _01226_ _01228_ _01231_ net316 VGND VGND VPWR VPWR net134 sky130_fd_sc_hd__a22o_1
XFILLER_36_123 VPWR VGND VPWR VGND sky130_ef_sc_hd__decap_12
XFILLER_80_914 VGND VGND VPWR VPWR sky130_fd_sc_hd__fill_1
X_06591_ u_interface.u_gelu_fp32.s1_data\[14\] _01166_ _01176_ VGND VGND VPWR VPWR
+ _00020_ sky130_fd_sc_hd__and3_1
XFILLER_51_126 VGND VGND VPWR VPWR sky130_fd_sc_hd__decap_3
XFILLER_18_893 VPWR VGND VPWR VGND sky130_ef_sc_hd__decap_12
XFILLER_33_841 VPWR VGND VPWR VGND sky130_ef_sc_hd__decap_12
X_08330_ _02129_ _02130_ VGND VGND VPWR VPWR _00766_ sky130_fd_sc_hd__nor2_1
X_08261_ u_interface.u_gelu_fp32.s2_data\[4\] _02076_ net534 VGND VGND VPWR VPWR _02079_
+ sky130_fd_sc_hd__o21a_1
XTAP_TAPCELL_ROW_15_571 VGND VPWR sky130_fd_sc_hd__tapvpwrvgnd_1
X_07212_ net345 net1469 net257 VGND VGND VPWR VPWR _00252_ sky130_fd_sc_hd__mux2_1
XTAP_TAPCELL_ROW_15_582 VGND VPWR sky130_fd_sc_hd__tapvpwrvgnd_1
XFILLER_118_412 VGND VGND VPWR VPWR sky130_fd_sc_hd__fill_1
X_08192_ _02019_ _02020_ VGND VGND VPWR VPWR _02026_ sky130_fd_sc_hd__nand2_1
XFILLER_145_220 VGND VGND VPWR VPWR sky130_fd_sc_hd__decap_4
XFILLER_134_916 VGND VGND VPWR VPWR sky130_fd_sc_hd__fill_1
XFILLER_118_445 VPWR VGND VPWR VGND sky130_ef_sc_hd__decap_12
X_07143_ net1110 net354 net218 VGND VGND VPWR VPWR _00183_ sky130_fd_sc_hd__mux2_1
XFILLER_106_618 VPWR VGND VPWR VGND sky130_ef_sc_hd__decap_12
X_07074_ net1466 net573 net210 VGND VGND VPWR VPWR _00114_ sky130_fd_sc_hd__mux2_1
XTAP_TAPCELL_ROW_95_1849 VGND VPWR sky130_fd_sc_hd__tapvpwrvgnd_1
XFILLER_10_27 VGND VGND VPWR VPWR sky130_fd_sc_hd__fill_1
XFILLER_102_813 VPWR VGND VPWR VGND sky130_ef_sc_hd__decap_12
XFILLER_102_802 VGND VGND VPWR VPWR sky130_fd_sc_hd__fill_1
XFILLER_59_237 VPWR VGND VPWR VGND sky130_ef_sc_hd__decap_12
X_07976_ net543 _01686_ net279 _01626_ net811 VGND VGND VPWR VPWR _01850_ sky130_fd_sc_hd__a221o_1
XFILLER_142_37 VGND VGND VPWR VPWR sky130_fd_sc_hd__fill_1
XTAP_TAPCELL_ROW_126_2348 VGND VPWR sky130_fd_sc_hd__tapvpwrvgnd_1
X_09715_ net216 _03373_ _03374_ VGND VGND VPWR VPWR _03470_ sky130_fd_sc_hd__a21bo_1
X_06927_ u_interface.u_gelu_fp32.u_synth_top.s1_x\[20\] u_interface.u_gelu_fp32.u_synth_top.s1_x\[21\]
+ net274 VGND VGND VPWR VPWR _01463_ sky130_fd_sc_hd__o21ai_1
XFILLER_19_69 VPWR VGND VPWR VGND sky130_ef_sc_hd__decap_12
XFILLER_28_613 VPWR VGND VPWR VGND sky130_ef_sc_hd__decap_12
XTAP_TAPCELL_ROW_126_2359 VGND VPWR sky130_fd_sc_hd__tapvpwrvgnd_1
X_09646_ _03400_ _03401_ _03262_ _03264_ VGND VGND VPWR VPWR _03402_ sky130_fd_sc_hd__o211a_1
XFILLER_28_657 VPWR VGND VPWR VGND sky130_ef_sc_hd__decap_12
X_06858_ u_interface.fifo_data\[4\]\[28\] u_interface.fifo_data\[5\]\[28\] u_interface.fifo_data\[6\]\[28\]
+ u_interface.fifo_data\[7\]\[28\] net769 net752 VGND VGND VPWR VPWR _01405_ sky130_fd_sc_hd__mux4_1
XFILLER_82_251 VGND VGND VPWR VPWR sky130_fd_sc_hd__fill_1
XFILLER_27_167 VGND VGND VPWR VPWR sky130_fd_sc_hd__fill_1
X_09577_ _03329_ _03332_ VGND VGND VPWR VPWR _03333_ sky130_fd_sc_hd__xnor2_1
XFILLER_82_273 VGND VGND VPWR VPWR sky130_fd_sc_hd__fill_2
XFILLER_70_413 VGND VGND VPWR VPWR sky130_fd_sc_hd__decap_6
X_06789_ u_interface.fifo_data\[8\]\[20\] u_interface.fifo_data\[9\]\[20\] u_interface.fifo_data\[10\]\[20\]
+ u_interface.fifo_data\[11\]\[20\] net758 net741 VGND VGND VPWR VPWR _01344_ sky130_fd_sc_hd__mux4_1
XFILLER_15_318 VGND VGND VPWR VPWR sky130_fd_sc_hd__fill_2
XFILLER_35_57 VPWR VGND VPWR VGND sky130_ef_sc_hd__decap_12
XFILLER_70_457 VPWR VGND VPWR VGND sky130_ef_sc_hd__decap_12
X_08528_ _02314_ _02317_ VGND VGND VPWR VPWR _02319_ sky130_fd_sc_hd__xor2_1
X_08459_ _02238_ _02240_ _02249_ _02176_ _02173_ VGND VGND VPWR VPWR _02250_ sky130_fd_sc_hd__a2111o_1
XFILLER_51_660 VGND VGND VPWR VPWR sky130_fd_sc_hd__decap_3
XTAP_TAPCELL_ROW_46_1074 VGND VPWR sky130_fd_sc_hd__tapvpwrvgnd_1
XFILLER_23_362 VGND VGND VPWR VPWR sky130_fd_sc_hd__fill_1
XTAP_TAPCELL_ROW_34_880 VGND VPWR sky130_fd_sc_hd__tapvpwrvgnd_1
Xclkbuf_3_3__f_clk clknet_0_clk VGND VGND VPWR VPWR clknet_3_3__leaf_clk sky130_fd_sc_hd__clkbuf_16
XPHY_EDGE_ROW_14_Right_14 VGND VGND VPWR VPWR sky130_fd_sc_hd__decap_3
XFILLER_129_3 VGND VGND VPWR VPWR sky130_fd_sc_hd__decap_4
XFILLER_109_412 VPWR VGND VPWR VGND sky130_ef_sc_hd__decap_12
X_11470_ _05207_ _05208_ VGND VGND VPWR VPWR _05210_ sky130_fd_sc_hd__xor2_1
XFILLER_7_517 VPWR VGND VPWR VGND sky130_ef_sc_hd__decap_12
XFILLER_109_445 VGND VGND VPWR VPWR sky130_fd_sc_hd__decap_3
X_10421_ _04040_ _04167_ _04168_ VGND VGND VPWR VPWR _04170_ sky130_fd_sc_hd__nand3_2
XFILLER_151_201 VGND VGND VPWR VPWR sky130_fd_sc_hd__fill_1
XFILLER_136_253 VGND VGND VPWR VPWR sky130_fd_sc_hd__decap_3
XFILLER_124_415 VGND VGND VPWR VPWR sky130_fd_sc_hd__decap_4
X_13140_ clknet_leaf_44_clk _00150_ VGND VGND VPWR VPWR u_interface.fifo_data\[2\]\[29\]
+ sky130_fd_sc_hd__dfxtp_1
X_10352_ net190 _04098_ _04099_ VGND VGND VPWR VPWR _04101_ sky130_fd_sc_hd__nand3_1
XFILLER_152_735 VGND VGND VPWR VPWR sky130_fd_sc_hd__decap_8
X_13071_ clknet_leaf_46_clk _00081_ VGND VGND VPWR VPWR u_interface.fifo_data\[14\]\[24\]
+ sky130_fd_sc_hd__dfxtp_1
X_10283_ _04031_ _04032_ _03998_ VGND VGND VPWR VPWR _04033_ sky130_fd_sc_hd__a21oi_1
XFILLER_2_233 VPWR VGND VPWR VGND sky130_ef_sc_hd__decap_12
X_12022_ _05753_ _05754_ VGND VGND VPWR VPWR _05755_ sky130_fd_sc_hd__xnor2_1
XFILLER_104_172 VGND VGND VPWR VPWR sky130_fd_sc_hd__fill_1
XFILLER_2_277 VPWR VGND VPWR VGND sky130_ef_sc_hd__decap_12
XPHY_EDGE_ROW_23_Right_23 VGND VGND VPWR VPWR sky130_fd_sc_hd__decap_3
Xfanout592 net593 VGND VGND VPWR VPWR net592 sky130_fd_sc_hd__clkbuf_2
XFILLER_120_698 VGND VGND VPWR VPWR sky130_fd_sc_hd__fill_2
XFILLER_120_676 VGND VGND VPWR VPWR sky130_fd_sc_hd__decap_8
Xfanout581 u_interface.u_gelu_fp32.u_synth_top.s2_m\[0\] VGND VGND VPWR VPWR net581
+ sky130_fd_sc_hd__dlymetal6s2s_1
Xfanout570 u_interface.core_data_out\[27\] VGND VGND VPWR VPWR net570 sky130_fd_sc_hd__buf_1
X_13973_ clknet_leaf_84_clk net1678 VGND VGND VPWR VPWR u_interface.u_gelu_fp32.u_q16_to_fp32.s2_mag\[18\]
+ sky130_fd_sc_hd__dfxtp_1
XFILLER_19_613 VGND VGND VPWR VPWR sky130_fd_sc_hd__decap_3
X_12924_ _06444_ _06447_ _06449_ VGND VGND VPWR VPWR _06450_ sky130_fd_sc_hd__and3_1
XFILLER_93_549 VGND VGND VPWR VPWR sky130_fd_sc_hd__decap_3
XFILLER_74_741 VPWR VGND VPWR VGND sky130_ef_sc_hd__decap_12
XFILLER_18_156 VPWR VGND VPWR VGND sky130_ef_sc_hd__decap_12
X_12855_ net1134 u_interface.u_gelu_fp32.u_fp32_to_q16.s2_norm_mag\[10\] net817 VGND
+ VGND VPWR VPWR _00999_ sky130_fd_sc_hd__mux2_1
XFILLER_61_413 VGND VGND VPWR VPWR sky130_fd_sc_hd__fill_1
XFILLER_33_104 VGND VGND VPWR VPWR sky130_fd_sc_hd__decap_8
X_12786_ _01784_ net295 _06409_ VGND VGND VPWR VPWR _00953_ sky130_fd_sc_hd__and3b_1
XFILLER_92_85 VPWR VGND VPWR VGND sky130_ef_sc_hd__decap_12
XFILLER_61_446 VGND VGND VPWR VPWR sky130_fd_sc_hd__fill_2
XFILLER_15_841 VPWR VGND VPWR VGND sky130_ef_sc_hd__decap_12
X_11806_ _05541_ _05540_ VGND VGND VPWR VPWR _05542_ sky130_fd_sc_hd__nand2b_1
XPHY_EDGE_ROW_32_Right_32 VGND VGND VPWR VPWR sky130_fd_sc_hd__decap_3
X_11737_ _05472_ _05473_ VGND VGND VPWR VPWR _05474_ sky130_fd_sc_hd__nor2_1
XPHY_EDGE_ROW_1_Left_157 VGND VGND VPWR VPWR sky130_fd_sc_hd__decap_3
XFILLER_30_811 VGND VGND VPWR VPWR sky130_fd_sc_hd__fill_1
XTAP_TAPCELL_ROW_12_530 VGND VPWR sky130_fd_sc_hd__tapvpwrvgnd_1
XFILLER_14_384 VGND VGND VPWR VPWR sky130_fd_sc_hd__decap_4
XFILLER_14_395 VGND VGND VPWR VPWR sky130_fd_sc_hd__fill_1
XFILLER_42_693 VGND VGND VPWR VPWR sky130_fd_sc_hd__decap_6
X_11668_ _05226_ _05322_ VGND VGND VPWR VPWR _05405_ sky130_fd_sc_hd__nand2_1
XFILLER_128_765 VPWR VGND VPWR VGND sky130_ef_sc_hd__decap_12
X_10619_ _04363_ _04364_ _04351_ VGND VGND VPWR VPWR _04366_ sky130_fd_sc_hd__o21a_1
X_13407_ clknet_leaf_70_clk _00417_ VGND VGND VPWR VPWR u_interface.fifo_data\[6\]\[20\]
+ sky130_fd_sc_hd__dfxtp_1
X_11599_ _05334_ _05335_ _05336_ VGND VGND VPWR VPWR _05337_ sky130_fd_sc_hd__and3_1
XFILLER_128_787 VGND VGND VPWR VPWR sky130_fd_sc_hd__decap_3
X_13338_ clknet_leaf_64_clk _00348_ VGND VGND VPWR VPWR u_interface.fifo_data\[10\]\[15\]
+ sky130_fd_sc_hd__dfxtp_1
XFILLER_155_595 VGND VGND VPWR VPWR sky130_fd_sc_hd__decap_3
XFILLER_143_768 VGND VGND VPWR VPWR sky130_fd_sc_hd__fill_1
XFILLER_115_459 VGND VGND VPWR VPWR sky130_fd_sc_hd__fill_1
XTAP_TAPCELL_ROW_77_1568 VGND VPWR sky130_fd_sc_hd__tapvpwrvgnd_1
XFILLER_130_418 VGND VGND VPWR VPWR sky130_fd_sc_hd__fill_2
XFILLER_102_109 VGND VGND VPWR VPWR sky130_fd_sc_hd__fill_1
X_13269_ clknet_leaf_51_clk _00279_ VGND VGND VPWR VPWR u_interface.fifo_data\[0\]\[11\]
+ sky130_fd_sc_hd__dfxtp_1
XFILLER_69_502 VGND VGND VPWR VPWR sky130_fd_sc_hd__fill_2
XFILLER_44_3 VPWR VGND VPWR VGND sky130_ef_sc_hd__decap_12
XPHY_EDGE_ROW_41_Right_41 VGND VGND VPWR VPWR sky130_fd_sc_hd__decap_3
XFILLER_142_289 VGND VGND VPWR VPWR sky130_fd_sc_hd__decap_6
XFILLER_142_278 VGND VGND VPWR VPWR sky130_fd_sc_hd__decap_3
XFILLER_97_833 VGND VGND VPWR VPWR sky130_fd_sc_hd__decap_6
XFILLER_96_321 VPWR VGND VPWR VGND sky130_ef_sc_hd__decap_12
XTAP_TAPCELL_ROW_90_1768 VGND VPWR sky130_fd_sc_hd__tapvpwrvgnd_1
X_07830_ net1113 net567 net232 VGND VGND VPWR VPWR _00591_ sky130_fd_sc_hd__mux2_1
XFILLER_110_131 VGND VGND VPWR VPWR sky130_fd_sc_hd__decap_3
XTAP_TAPCELL_ROW_90_1779 VGND VPWR sky130_fd_sc_hd__tapvpwrvgnd_1
XFILLER_111_698 VPWR VGND VPWR VGND sky130_ef_sc_hd__decap_12
X_07761_ u_interface.u_gelu_fp32.u_q16_to_fp32.s3_exp\[4\] _01798_ VGND VGND VPWR
+ VPWR _01801_ sky130_fd_sc_hd__nand2_1
XFILLER_96_376 VGND VGND VPWR VPWR sky130_fd_sc_hd__fill_2
XFILLER_56_207 VPWR VGND VPWR VGND sky130_ef_sc_hd__decap_12
X_06712_ net323 _01274_ net727 VGND VGND VPWR VPWR _01277_ sky130_fd_sc_hd__o21a_1
X_09500_ _03244_ _03253_ _03254_ VGND VGND VPWR VPWR _03257_ sky130_fd_sc_hd__nand3_1
XFILLER_110_197 VGND VGND VPWR VPWR sky130_fd_sc_hd__decap_3
XTAP_TAPCELL_ROW_108_2067 VGND VPWR sky130_fd_sc_hd__tapvpwrvgnd_1
XTAP_TAPCELL_ROW_108_2056 VGND VPWR sky130_fd_sc_hd__tapvpwrvgnd_1
XFILLER_2_83 VGND VGND VPWR VPWR sky130_fd_sc_hd__fill_1
X_07692_ _01188_ _01435_ _01755_ VGND VGND VPWR VPWR _00496_ sky130_fd_sc_hd__or3_1
XFILLER_65_785 VGND VGND VPWR VPWR sky130_fd_sc_hd__decap_3
XFILLER_64_240 VGND VGND VPWR VPWR sky130_fd_sc_hd__fill_1
X_09431_ net484 net647 _02639_ _02638_ VGND VGND VPWR VPWR _03189_ sky130_fd_sc_hd__a31o_1
X_06643_ _01215_ _01216_ net733 VGND VGND VPWR VPWR _01217_ sky130_fd_sc_hd__mux2_1
XFILLER_92_571 VGND VGND VPWR VPWR sky130_fd_sc_hd__decap_3
XFILLER_64_262 VPWR VGND VPWR VGND sky130_ef_sc_hd__decap_12
XPHY_EDGE_ROW_50_Right_50 VGND VGND VPWR VPWR sky130_fd_sc_hd__decap_3
X_09362_ _03110_ _03111_ _03116_ _03068_ VGND VGND VPWR VPWR _03121_ sky130_fd_sc_hd__o22a_1
XTAP_TAPCELL_ROW_121_2278 VGND VPWR sky130_fd_sc_hd__tapvpwrvgnd_1
XTAP_TAPCELL_ROW_121_2267 VGND VPWR sky130_fd_sc_hd__tapvpwrvgnd_1
X_06574_ _01159_ _01165_ VGND VGND VPWR VPWR _00008_ sky130_fd_sc_hd__nor2_1
XFILLER_80_755 VGND VGND VPWR VPWR sky130_fd_sc_hd__fill_1
XFILLER_24_137 VGND VGND VPWR VPWR sky130_fd_sc_hd__decap_3
X_08313_ net530 net1637 _02116_ net799 VGND VGND VPWR VPWR _02118_ sky130_fd_sc_hd__a31o_1
XFILLER_33_671 VGND VGND VPWR VPWR sky130_fd_sc_hd__fill_1
X_09293_ net615 net513 net517 net623 VGND VGND VPWR VPWR _03052_ sky130_fd_sc_hd__a22oi_1
XFILLER_138_518 VPWR VGND VPWR VGND sky130_ef_sc_hd__decap_12
XANTENNA_11 net2 VGND VGND VPWR VPWR sky130_fd_sc_hd__diode_2
XFILLER_20_321 VGND VGND VPWR VPWR sky130_fd_sc_hd__decap_3
XFILLER_21_833 VGND VGND VPWR VPWR sky130_fd_sc_hd__decap_6
X_08244_ net788 net946 VGND VGND VPWR VPWR _00742_ sky130_fd_sc_hd__and2_1
XFILLER_20_365 VGND VGND VPWR VPWR sky130_fd_sc_hd__decap_4
XFILLER_21_877 VPWR VGND VPWR VGND sky130_ef_sc_hd__decap_12
X_08175_ _02009_ _02011_ VGND VGND VPWR VPWR _02012_ sky130_fd_sc_hd__xnor2_1
XFILLER_21_15 VPWR VGND VPWR VGND sky130_ef_sc_hd__decap_12
X_07126_ net1315 net324 net223 VGND VGND VPWR VPWR _00166_ sky130_fd_sc_hd__mux2_1
XFILLER_118_275 VGND VGND VPWR VPWR sky130_fd_sc_hd__decap_4
XFILLER_118_253 VGND VGND VPWR VPWR sky130_fd_sc_hd__decap_3
XFILLER_106_459 VGND VGND VPWR VPWR sky130_fd_sc_hd__fill_1
Xoutput140 net140 VGND VGND VPWR VPWR m_axis_tdata[9] sky130_fd_sc_hd__buf_2
X_07057_ net1087 net368 net207 VGND VGND VPWR VPWR _00097_ sky130_fd_sc_hd__mux2_1
XFILLER_99_181 VGND VGND VPWR VPWR sky130_fd_sc_hd__fill_1
XFILLER_87_310 VGND VGND VPWR VPWR sky130_fd_sc_hd__fill_1
XFILLER_87_332 VGND VGND VPWR VPWR sky130_fd_sc_hd__fill_1
XFILLER_87_376 VGND VGND VPWR VPWR sky130_fd_sc_hd__decap_3
XFILLER_87_365 VGND VGND VPWR VPWR sky130_fd_sc_hd__decap_3
XFILLER_75_505 VGND VGND VPWR VPWR sky130_fd_sc_hd__decap_8
X_07959_ net545 _01612_ net278 _01841_ VGND VGND VPWR VPWR _00684_ sky130_fd_sc_hd__a31o_1
X_10970_ _04614_ _04616_ _04713_ VGND VGND VPWR VPWR _04714_ sky130_fd_sc_hd__and3_1
XTAP_TAPCELL_ROW_48_1103 VGND VPWR sky130_fd_sc_hd__tapvpwrvgnd_1
XFILLER_28_454 VPWR VGND VPWR VGND sky130_ef_sc_hd__decap_12
XTAP_TAPCELL_ROW_39_961 VGND VPWR sky130_fd_sc_hd__tapvpwrvgnd_1
X_09629_ net490 net680 net689 net491 VGND VGND VPWR VPWR _03385_ sky130_fd_sc_hd__a22o_1
XFILLER_71_722 VGND VGND VPWR VPWR sky130_fd_sc_hd__decap_6
XFILLER_46_89 VGND VGND VPWR VPWR sky130_fd_sc_hd__fill_2
XFILLER_43_424 VPWR VGND VPWR VGND sky130_ef_sc_hd__decap_12
X_12640_ net213 _06335_ _06329_ VGND VGND VPWR VPWR _06339_ sky130_fd_sc_hd__o21a_1
XFILLER_15_137 VPWR VGND VPWR VGND sky130_ef_sc_hd__decap_12
XTAP_TAPCELL_ROW_61_1314 VGND VPWR sky130_fd_sc_hd__tapvpwrvgnd_1
XFILLER_12_811 VGND VGND VPWR VPWR sky130_fd_sc_hd__fill_1
Xclkbuf_leaf_50_clk clknet_3_7__leaf_clk VGND VGND VPWR VPWR clknet_leaf_50_clk sky130_fd_sc_hd__clkbuf_8
X_12571_ net784 net1763 VGND VGND VPWR VPWR _00869_ sky130_fd_sc_hd__and2_1
XFILLER_62_66 VPWR VGND VPWR VGND sky130_ef_sc_hd__decap_12
XFILLER_23_181 VPWR VGND VPWR VGND sky130_ef_sc_hd__decap_12
XFILLER_24_693 VGND VGND VPWR VPWR sky130_fd_sc_hd__decap_6
XFILLER_8_837 VPWR VGND VPWR VGND sky130_ef_sc_hd__decap_12
X_11522_ _05259_ _05260_ _05256_ VGND VGND VPWR VPWR _05261_ sky130_fd_sc_hd__a21o_1
XFILLER_7_39 VPWR VGND VPWR VGND sky130_ef_sc_hd__decap_12
X_11453_ _05192_ _05191_ VGND VGND VPWR VPWR _05193_ sky130_fd_sc_hd__and2b_1
XFILLER_125_724 VGND VGND VPWR VPWR sky130_fd_sc_hd__decap_4
X_10404_ _04047_ _04055_ _04054_ VGND VGND VPWR VPWR _04153_ sky130_fd_sc_hd__a21o_1
X_14172_ clknet_leaf_82_clk _01098_ VGND VGND VPWR VPWR u_interface.u_gelu_fp32.u_q16_to_fp32.s1_mag\[31\]
+ sky130_fd_sc_hd__dfxtp_1
X_13123_ clknet_leaf_63_clk _00133_ VGND VGND VPWR VPWR u_interface.fifo_data\[2\]\[12\]
+ sky130_fd_sc_hd__dfxtp_1
XTAP_TAPCELL_ROW_59_1276 VGND VPWR sky130_fd_sc_hd__tapvpwrvgnd_1
X_11384_ net180 _05041_ _05043_ VGND VGND VPWR VPWR _05124_ sky130_fd_sc_hd__nor3_1
XFILLER_127_70 VGND VGND VPWR VPWR sky130_fd_sc_hd__fill_2
X_10335_ _03991_ _03993_ VGND VGND VPWR VPWR _04084_ sky130_fd_sc_hd__nand2_1
XTAP_TAPCELL_ROW_59_1287 VGND VPWR sky130_fd_sc_hd__tapvpwrvgnd_1
XFILLER_11_81 VPWR VGND VPWR VGND sky130_ef_sc_hd__decap_12
XFILLER_3_553 VGND VGND VPWR VPWR sky130_fd_sc_hd__decap_6
XFILLER_140_738 VGND VGND VPWR VPWR sky130_fd_sc_hd__fill_1
X_13054_ clknet_leaf_41_clk _00064_ VGND VGND VPWR VPWR u_interface.fifo_data\[14\]\[7\]
+ sky130_fd_sc_hd__dfxtp_1
X_10266_ _03906_ _03909_ VGND VGND VPWR VPWR _04016_ sky130_fd_sc_hd__nand2_1
XFILLER_3_597 VPWR VGND VPWR VGND sky130_ef_sc_hd__decap_12
XFILLER_79_866 VGND VGND VPWR VPWR sky130_fd_sc_hd__fill_2
XFILLER_78_321 VPWR VGND VPWR VGND sky130_ef_sc_hd__decap_12
XTAP_TAPCELL_ROW_72_1487 VGND VPWR sky130_fd_sc_hd__tapvpwrvgnd_1
X_12005_ net202 _05737_ VGND VGND VPWR VPWR _05738_ sky130_fd_sc_hd__xnor2_1
XFILLER_94_836 VGND VGND VPWR VPWR sky130_fd_sc_hd__decap_4
X_10197_ _03921_ _03922_ _03947_ VGND VGND VPWR VPWR _03948_ sky130_fd_sc_hd__a21o_1
XFILLER_38_218 VPWR VGND VPWR VGND sky130_ef_sc_hd__decap_12
X_13956_ clknet_leaf_56_clk net1713 VGND VGND VPWR VPWR u_interface.u_gelu_fp32.u_q16_to_fp32.s2_mag\[1\]
+ sky130_fd_sc_hd__dfxtp_1
XFILLER_74_560 VGND VGND VPWR VPWR sky130_fd_sc_hd__fill_1
X_12907_ _01523_ _06436_ VGND VGND VPWR VPWR _01051_ sky130_fd_sc_hd__nor2_1
X_13887_ clknet_leaf_0_clk _00040_ VGND VGND VPWR VPWR u_interface.u_gelu_fp32.u_synth_top.s2_dx\[23\]
+ sky130_fd_sc_hd__dfxtp_1
XFILLER_61_210 VPWR VGND VPWR VGND sky130_ef_sc_hd__decap_12
XFILLER_47_785 VGND VGND VPWR VPWR sky130_fd_sc_hd__decap_4
XTAP_TAPCELL_ROW_17_600 VGND VPWR sky130_fd_sc_hd__tapvpwrvgnd_1
XTAP_TAPCELL_ROW_17_611 VGND VPWR sky130_fd_sc_hd__tapvpwrvgnd_1
X_12838_ net51 net50 net53 net52 VGND VGND VPWR VPWR _06420_ sky130_fd_sc_hd__or4_1
XFILLER_15_671 VGND VGND VPWR VPWR sky130_fd_sc_hd__fill_1
Xclkbuf_leaf_41_clk clknet_3_7__leaf_clk VGND VGND VPWR VPWR clknet_leaf_41_clk sky130_fd_sc_hd__clkbuf_8
X_12769_ net1647 _01778_ net296 VGND VGND VPWR VPWR _06401_ sky130_fd_sc_hd__o21ai_1
XFILLER_14_181 VPWR VGND VPWR VGND sky130_ef_sc_hd__decap_12
Xinput31 s_axil_araddr[6] VGND VGND VPWR VPWR net31 sky130_fd_sc_hd__clkbuf_1
Xinput20 s_axil_araddr[25] VGND VGND VPWR VPWR net20 sky130_fd_sc_hd__dlymetal6s2s_1
XFILLER_147_359 VGND VGND VPWR VPWR sky130_fd_sc_hd__decap_4
XFILLER_147_337 VGND VGND VPWR VPWR sky130_fd_sc_hd__fill_1
Xinput64 s_axil_awaddr[6] VGND VGND VPWR VPWR net64 sky130_fd_sc_hd__clkbuf_1
Xinput42 s_axil_awaddr[15] VGND VGND VPWR VPWR net42 sky130_fd_sc_hd__clkbuf_1
Xinput53 s_axil_awaddr[25] VGND VGND VPWR VPWR net53 sky130_fd_sc_hd__clkbuf_1
XFILLER_128_562 VGND VGND VPWR VPWR sky130_fd_sc_hd__decap_8
Xinput86 s_axis_tdata[20] VGND VGND VPWR VPWR net86 sky130_fd_sc_hd__clkbuf_1
Xinput75 s_axis_tdata[10] VGND VGND VPWR VPWR net75 sky130_fd_sc_hd__clkbuf_1
Xhold815 net148 VGND VGND VPWR VPWR net1680 sky130_fd_sc_hd__dlygate4sd3_1
Xinput97 s_axis_tdata[30] VGND VGND VPWR VPWR net97 sky130_fd_sc_hd__clkbuf_1
Xhold804 u_interface.u_gelu_fp32.u_fp32_to_q16.s3_mag\[16\] VGND VGND VPWR VPWR net1669
+ sky130_fd_sc_hd__dlygate4sd3_1
XFILLER_115_223 VGND VGND VPWR VPWR sky130_fd_sc_hd__fill_1
XTAP_TAPCELL_ROW_92_1808 VGND VPWR sky130_fd_sc_hd__tapvpwrvgnd_1
Xhold837 _00902_ VGND VGND VPWR VPWR net1702 sky130_fd_sc_hd__dlygate4sd3_1
Xhold826 _00906_ VGND VGND VPWR VPWR net1691 sky130_fd_sc_hd__dlygate4sd3_1
XFILLER_143_576 VGND VGND VPWR VPWR sky130_fd_sc_hd__decap_8
Xhold859 u_interface.fifo_wr_ptr\[1\] VGND VGND VPWR VPWR net1724 sky130_fd_sc_hd__dlygate4sd3_1
XFILLER_115_245 VGND VGND VPWR VPWR sky130_fd_sc_hd__fill_2
X_09980_ _03633_ _03729_ _03730_ VGND VGND VPWR VPWR _03733_ sky130_fd_sc_hd__or3_1
Xhold848 _00882_ VGND VGND VPWR VPWR net1713 sky130_fd_sc_hd__dlygate4sd3_1
X_08931_ _02677_ _02686_ _02687_ VGND VGND VPWR VPWR _02690_ sky130_fd_sc_hd__nand3_1
X_08862_ _02600_ _02620_ VGND VGND VPWR VPWR _02621_ sky130_fd_sc_hd__or2_1
XFILLER_69_332 VGND VGND VPWR VPWR sky130_fd_sc_hd__decap_4
X_07813_ net1256 net362 net232 VGND VGND VPWR VPWR _00574_ sky130_fd_sc_hd__mux2_1
XFILLER_57_516 VGND VGND VPWR VPWR sky130_fd_sc_hd__fill_1
X_08793_ _02549_ _02550_ _02551_ VGND VGND VPWR VPWR _02552_ sky130_fd_sc_hd__o21ai_1
XFILLER_111_484 VPWR VGND VPWR VGND sky130_ef_sc_hd__decap_12
XTAP_TAPCELL_ROW_123_2307 VGND VPWR sky130_fd_sc_hd__tapvpwrvgnd_1
X_07744_ u_interface.u_gelu_fp32.u_q16_to_fp32.s3_norm_mag\[27\] u_interface.u_gelu_fp32.u_q16_to_fp32.s3_norm_mag\[26\]
+ _01787_ VGND VGND VPWR VPWR _01788_ sky130_fd_sc_hd__and3_1
XFILLER_84_357 VGND VGND VPWR VPWR sky130_fd_sc_hd__decap_3
X_07675_ u_interface.u_gelu_fp32.u_synth_top.s1_hits\[17\] u_interface.u_gelu_fp32.u_synth_top.comb_b\[18\]
+ _01435_ VGND VGND VPWR VPWR _00487_ sky130_fd_sc_hd__or3_1
XFILLER_16_15 VPWR VGND VPWR VGND sky130_ef_sc_hd__decap_12
X_06626_ u_interface.fifo_tlast\[4\] u_interface.fifo_tlast\[5\] u_interface.fifo_tlast\[6\]
+ u_interface.fifo_tlast\[7\] net767 net750 VGND VGND VPWR VPWR _01202_ sky130_fd_sc_hd__mux4_1
X_09414_ _03171_ VGND VGND VPWR VPWR _03172_ sky130_fd_sc_hd__inv_2
XFILLER_53_799 VGND VGND VPWR VPWR sky130_fd_sc_hd__fill_1
XFILLER_52_265 VGND VGND VPWR VPWR sky130_fd_sc_hd__decap_6
XFILLER_40_405 VGND VGND VPWR VPWR sky130_fd_sc_hd__decap_3
Xclkbuf_leaf_32_clk clknet_3_6__leaf_clk VGND VGND VPWR VPWR clknet_leaf_32_clk sky130_fd_sc_hd__clkbuf_8
X_09345_ _03095_ _03097_ VGND VGND VPWR VPWR _03104_ sky130_fd_sc_hd__xnor2_1
XTAP_TAPCELL_ROW_101_1959 VGND VPWR sky130_fd_sc_hd__tapvpwrvgnd_1
XTAP_TAPCELL_ROW_101_1948 VGND VPWR sky130_fd_sc_hd__tapvpwrvgnd_1
X_06557_ _01140_ _01151_ _01150_ VGND VGND VPWR VPWR _01152_ sky130_fd_sc_hd__o21ba_1
XTAP_TAPCELL_ROW_43_1022 VGND VPWR sky130_fd_sc_hd__tapvpwrvgnd_1
XFILLER_40_438 VPWR VGND VPWR VGND sky130_ef_sc_hd__decap_12
X_09276_ net584 net485 _03033_ _03034_ VGND VGND VPWR VPWR _03035_ sky130_fd_sc_hd__nand4_2
XTAP_TAPCELL_ROW_138_2550 VGND VPWR sky130_fd_sc_hd__tapvpwrvgnd_1
XFILLER_21_641 VPWR VGND VPWR VGND sky130_ef_sc_hd__decap_12
X_08227_ net289 _02055_ VGND VGND VPWR VPWR _00738_ sky130_fd_sc_hd__nor2_1
XFILLER_21_685 VPWR VGND VPWR VGND sky130_ef_sc_hd__decap_12
XTAP_TAPCELL_ROW_151_2750 VGND VPWR sky130_fd_sc_hd__tapvpwrvgnd_1
XFILLER_147_893 VGND VGND VPWR VPWR sky130_fd_sc_hd__decap_3
XFILLER_107_735 VGND VGND VPWR VPWR sky130_fd_sc_hd__fill_1
XFILLER_107_724 VGND VGND VPWR VPWR sky130_fd_sc_hd__decap_4
X_08158_ net293 _01997_ VGND VGND VPWR VPWR _00727_ sky130_fd_sc_hd__nor2_1
XPHY_EDGE_ROW_73_Left_229 VGND VGND VPWR VPWR sky130_fd_sc_hd__decap_3
X_07109_ net1145 net567 net227 VGND VGND VPWR VPWR _00149_ sky130_fd_sc_hd__mux2_1
X_08089_ net169 _01938_ _01939_ net164 VGND VGND VPWR VPWR _01940_ sky130_fd_sc_hd__a31oi_1
XFILLER_106_278 VGND VGND VPWR VPWR sky130_fd_sc_hd__fill_2
X_10120_ net277 _03869_ _03870_ VGND VGND VPWR VPWR _03871_ sky130_fd_sc_hd__a21o_1
XFILLER_0_501 VGND VGND VPWR VPWR sky130_fd_sc_hd__decap_3
X_10051_ _03800_ _03801_ _03785_ VGND VGND VPWR VPWR _03803_ sky130_fd_sc_hd__o21ai_1
XFILLER_0_545 VPWR VGND VPWR VGND sky130_ef_sc_hd__decap_12
XTAP_TAPCELL_ROW_54_1195 VGND VPWR sky130_fd_sc_hd__tapvpwrvgnd_1
XFILLER_48_527 VGND VGND VPWR VPWR sky130_fd_sc_hd__decap_4
XFILLER_0_589 VPWR VGND VPWR VGND sky130_ef_sc_hd__decap_12
XFILLER_76_869 VGND VGND VPWR VPWR sky130_fd_sc_hd__fill_2
XFILLER_75_335 VGND VGND VPWR VPWR sky130_fd_sc_hd__fill_1
XPHY_EDGE_ROW_82_Left_238 VGND VGND VPWR VPWR sky130_fd_sc_hd__decap_3
X_13810_ clknet_leaf_88_clk _00820_ VGND VGND VPWR VPWR u_interface.u_gelu_fp32.u_synth_top.s3_mult\[28\]
+ sky130_fd_sc_hd__dfxtp_1
XFILLER_29_741 VPWR VGND VPWR VGND sky130_ef_sc_hd__decap_12
XFILLER_90_316 VGND VGND VPWR VPWR sky130_fd_sc_hd__fill_1
X_13741_ clknet_leaf_58_clk net1667 VGND VGND VPWR VPWR u_interface.u_gelu_fp32.u_q16_to_fp32.s1_mag\[7\]
+ sky130_fd_sc_hd__dfxtp_1
X_10953_ _04343_ _04572_ VGND VGND VPWR VPWR _04697_ sky130_fd_sc_hd__nand2_1
XFILLER_56_582 VGND VGND VPWR VPWR sky130_fd_sc_hd__fill_1
XFILLER_44_733 VPWR VGND VPWR VGND sky130_ef_sc_hd__decap_12
XTAP_TAPCELL_ROW_3_383 VGND VPWR sky130_fd_sc_hd__tapvpwrvgnd_1
XFILLER_29_785 VPWR VGND VPWR VGND sky130_ef_sc_hd__decap_12
XFILLER_71_552 VGND VGND VPWR VPWR sky130_fd_sc_hd__decap_8
XFILLER_44_766 VPWR VGND VPWR VGND sky130_ef_sc_hd__decap_12
X_13672_ clknet_leaf_29_clk _00682_ VGND VGND VPWR VPWR u_interface.u_gelu_fp32.u_fp32_to_q16.s2_valid
+ sky130_fd_sc_hd__dfxtp_1
XFILLER_71_574 VGND VGND VPWR VPWR sky130_fd_sc_hd__decap_8
X_10884_ net595 net602 net404 u_interface.u_gelu_fp32.u_synth_top.s2_dx\[28\] VGND
+ VGND VPWR VPWR _04629_ sky130_fd_sc_hd__and4_1
XFILLER_32_917 VGND VGND VPWR VPWR sky130_fd_sc_hd__fill_1
XFILLER_43_276 VGND VGND VPWR VPWR sky130_fd_sc_hd__decap_4
Xclkbuf_leaf_23_clk clknet_3_1__leaf_clk VGND VGND VPWR VPWR clknet_leaf_23_clk sky130_fd_sc_hd__clkbuf_8
X_12623_ _06316_ _06325_ VGND VGND VPWR VPWR _06326_ sky130_fd_sc_hd__nand2_1
XFILLER_31_449 VGND VGND VPWR VPWR sky130_fd_sc_hd__decap_4
XFILLER_8_601 VPWR VGND VPWR VGND sky130_ef_sc_hd__decap_12
X_12554_ net170 net165 _06276_ _06277_ VGND VGND VPWR VPWR _06278_ sky130_fd_sc_hd__o2bb2a_1
XFILLER_129_337 VGND VGND VPWR VPWR sky130_fd_sc_hd__fill_1
XFILLER_8_645 VPWR VGND VPWR VGND sky130_ef_sc_hd__decap_12
XFILLER_7_111 VGND VGND VPWR VPWR sky130_fd_sc_hd__fill_1
XTAP_TAPCELL_ROW_22_680 VGND VPWR sky130_fd_sc_hd__tapvpwrvgnd_1
X_11505_ _05241_ _05242_ _05243_ VGND VGND VPWR VPWR _05244_ sky130_fd_sc_hd__or3_1
XFILLER_144_307 VGND VGND VPWR VPWR sky130_fd_sc_hd__fill_1
XPHY_EDGE_ROW_91_Left_247 VGND VGND VPWR VPWR sky130_fd_sc_hd__decap_3
X_12485_ _06208_ _06209_ VGND VGND VPWR VPWR _06211_ sky130_fd_sc_hd__nor2_1
XTAP_TAPCELL_ROW_22_691 VGND VPWR sky130_fd_sc_hd__tapvpwrvgnd_1
X_11436_ _05172_ _05175_ VGND VGND VPWR VPWR _05176_ sky130_fd_sc_hd__xnor2_1
XFILLER_153_863 VPWR VGND VPWR VGND sky130_ef_sc_hd__decap_12
XFILLER_125_565 VPWR VGND VPWR VGND sky130_ef_sc_hd__decap_12
X_14155_ clknet_leaf_65_clk _01081_ VGND VGND VPWR VPWR u_interface.fifo_data\[1\]\[15\]
+ sky130_fd_sc_hd__dfxtp_1
XTAP_TAPCELL_ROW_74_1527 VGND VPWR sky130_fd_sc_hd__tapvpwrvgnd_1
XTAP_TAPCELL_ROW_74_1516 VGND VPWR sky130_fd_sc_hd__tapvpwrvgnd_1
X_11367_ _05107_ _05106_ VGND VGND VPWR VPWR _05108_ sky130_fd_sc_hd__and2b_1
XFILLER_152_362 VGND VGND VPWR VPWR sky130_fd_sc_hd__fill_2
X_14086_ clknet_leaf_16_clk net1624 VGND VGND VPWR VPWR u_interface.u_gelu_fp32.u_fp32_to_q16.s2_norm_mag\[23\]
+ sky130_fd_sc_hd__dfxtp_1
XFILLER_140_524 VGND VGND VPWR VPWR sky130_fd_sc_hd__decap_8
XFILLER_98_438 VPWR VGND VPWR VGND sky130_ef_sc_hd__decap_12
X_10318_ _03996_ _03997_ _04065_ _04066_ VGND VGND VPWR VPWR _04068_ sky130_fd_sc_hd__nand4_2
X_13106_ clknet_leaf_67_clk _00116_ VGND VGND VPWR VPWR u_interface.fifo_data\[15\]\[27\]
+ sky130_fd_sc_hd__dfxtp_1
XFILLER_3_361 VPWR VGND VPWR VGND sky130_ef_sc_hd__decap_12
X_13037_ clknet_leaf_38_clk _00047_ VGND VGND VPWR VPWR u_interface.fifo_tuser\[8\]
+ sky130_fd_sc_hd__dfxtp_1
XFILLER_112_226 VGND VGND VPWR VPWR sky130_fd_sc_hd__decap_4
X_11298_ net206 _05038_ VGND VGND VPWR VPWR _05039_ sky130_fd_sc_hd__and2b_1
X_10249_ net482 net722 VGND VGND VPWR VPWR _03999_ sky130_fd_sc_hd__and2_1
XTAP_TAPCELL_ROW_105_2015 VGND VPWR sky130_fd_sc_hd__tapvpwrvgnd_1
XFILLER_94_666 VGND VGND VPWR VPWR sky130_fd_sc_hd__fill_1
XFILLER_93_132 VGND VGND VPWR VPWR sky130_fd_sc_hd__decap_3
XFILLER_94_699 VGND VGND VPWR VPWR sky130_fd_sc_hd__fill_1
XFILLER_47_571 VGND VGND VPWR VPWR sky130_fd_sc_hd__decap_6
X_13939_ clknet_leaf_3_clk _00006_ VGND VGND VPWR VPWR u_interface.u_gelu_fp32.u_synth_top.s1_hits\[11\]
+ sky130_fd_sc_hd__dfxtp_1
XFILLER_62_541 VGND VGND VPWR VPWR sky130_fd_sc_hd__fill_2
XFILLER_34_232 VGND VGND VPWR VPWR sky130_fd_sc_hd__decap_8
X_07460_ _01594_ VGND VGND VPWR VPWR _01595_ sky130_fd_sc_hd__inv_2
XTAP_TAPCELL_ROW_85_1689 VGND VPWR sky130_fd_sc_hd__tapvpwrvgnd_1
X_07391_ net1121 net575 net240 VGND VGND VPWR VPWR _00421_ sky130_fd_sc_hd__mux2_1
X_09130_ _02886_ _02887_ _02888_ VGND VGND VPWR VPWR _02889_ sky130_fd_sc_hd__or3_1
Xclkbuf_leaf_14_clk clknet_3_2__leaf_clk VGND VGND VPWR VPWR clknet_leaf_14_clk sky130_fd_sc_hd__clkbuf_8
XFILLER_147_134 VGND VGND VPWR VPWR sky130_fd_sc_hd__fill_2
X_09061_ _02802_ _02803_ _02765_ VGND VGND VPWR VPWR _02820_ sky130_fd_sc_hd__a21oi_1
XFILLER_148_679 VGND VGND VPWR VPWR sky130_fd_sc_hd__fill_1
XFILLER_147_156 VPWR VGND VPWR VGND sky130_ef_sc_hd__decap_12
X_08012_ u_interface.u_gelu_fp32.u_fp32_to_q16.s2_is_zero net1217 net816 VGND VGND
+ VPWR VPWR _00707_ sky130_fd_sc_hd__mux2_1
XFILLER_135_329 VGND VGND VPWR VPWR sky130_fd_sc_hd__decap_6
Xhold612 u_interface.fifo_data\[3\]\[11\] VGND VGND VPWR VPWR net1477 sky130_fd_sc_hd__dlygate4sd3_1
Xhold601 u_interface.fifo_data\[15\]\[25\] VGND VGND VPWR VPWR net1466 sky130_fd_sc_hd__dlygate4sd3_1
Xhold623 u_interface.fifo_data\[8\]\[29\] VGND VGND VPWR VPWR net1488 sky130_fd_sc_hd__dlygate4sd3_1
XTAP_TAPCELL_ROW_116_2199 VGND VPWR sky130_fd_sc_hd__tapvpwrvgnd_1
XTAP_TAPCELL_ROW_116_2188 VGND VPWR sky130_fd_sc_hd__tapvpwrvgnd_1
Xhold645 u_interface.u_gelu_fp32.u_q16_to_fp32.s2_exp\[2\] VGND VGND VPWR VPWR net1510
+ sky130_fd_sc_hd__dlygate4sd3_1
XFILLER_89_405 VGND VGND VPWR VPWR sky130_fd_sc_hd__decap_4
Xhold634 u_interface.fifo_data\[7\]\[31\] VGND VGND VPWR VPWR net1499 sky130_fd_sc_hd__dlygate4sd3_1
X_09963_ _03712_ _03713_ _03714_ VGND VGND VPWR VPWR _03716_ sky130_fd_sc_hd__and3_1
Xhold656 u_interface.fifo_data\[3\]\[5\] VGND VGND VPWR VPWR net1521 sky130_fd_sc_hd__dlygate4sd3_1
Xhold667 u_interface.fifo_data\[0\]\[20\] VGND VGND VPWR VPWR net1532 sky130_fd_sc_hd__dlygate4sd3_1
Xhold678 u_interface.fifo_data\[1\]\[5\] VGND VGND VPWR VPWR net1543 sky130_fd_sc_hd__dlygate4sd3_1
XPHY_EDGE_ROW_4_Right_4 VGND VGND VPWR VPWR sky130_fd_sc_hd__decap_3
X_08914_ _02672_ _02671_ VGND VGND VPWR VPWR _02673_ sky130_fd_sc_hd__nand2b_1
Xhold689 _00893_ VGND VGND VPWR VPWR net1554 sky130_fd_sc_hd__dlygate4sd3_1
XPHY_EDGE_ROW_139_Left_295 VGND VGND VPWR VPWR sky130_fd_sc_hd__decap_3
X_09894_ _03634_ _03644_ _03645_ VGND VGND VPWR VPWR _03647_ sky130_fd_sc_hd__and3_1
XFILLER_69_140 VGND VGND VPWR VPWR sky130_fd_sc_hd__decap_3
X_08845_ net623 net476 net630 net480 VGND VGND VPWR VPWR _02604_ sky130_fd_sc_hd__and4_1
XFILLER_57_335 VGND VGND VPWR VPWR sky130_fd_sc_hd__fill_1
X_08776_ _02493_ _02496_ VGND VGND VPWR VPWR _02535_ sky130_fd_sc_hd__nand2_1
XFILLER_85_677 VGND VGND VPWR VPWR sky130_fd_sc_hd__fill_1
XFILLER_58_869 VGND VGND VPWR VPWR sky130_fd_sc_hd__decap_6
XFILLER_57_357 VPWR VGND VPWR VGND sky130_ef_sc_hd__decap_12
XFILLER_150_15 VPWR VGND VPWR VGND sky130_ef_sc_hd__decap_12
X_07727_ net1398 u_interface.u_gelu_fp32.u_synth_top.s1_hits\[9\] u_interface.u_gelu_fp32.u_synth_top.s1_hits\[3\]
+ _01766_ VGND VGND VPWR VPWR _00519_ sky130_fd_sc_hd__or4_1
XTAP_TAPCELL_ROW_0_320 VGND VPWR sky130_fd_sc_hd__tapvpwrvgnd_1
XFILLER_27_69 VPWR VGND VPWR VGND sky130_ef_sc_hd__decap_12
XTAP_TAPCELL_ROW_0_331 VGND VPWR sky130_fd_sc_hd__tapvpwrvgnd_1
XTAP_TAPCELL_ROW_0_342 VGND VPWR sky130_fd_sc_hd__tapvpwrvgnd_1
XFILLER_26_755 VGND VGND VPWR VPWR sky130_fd_sc_hd__fill_1
X_07658_ net807 net1706 net299 _01741_ VGND VGND VPWR VPWR _00482_ sky130_fd_sc_hd__a22o_1
XFILLER_81_894 VGND VGND VPWR VPWR sky130_fd_sc_hd__fill_2
XFILLER_14_917 VGND VGND VPWR VPWR sky130_fd_sc_hd__decap_4
XFILLER_25_276 VGND VGND VPWR VPWR sky130_fd_sc_hd__decap_4
X_07589_ u_interface.u_gelu_fp32.u_fp32_to_q16.s2_shift\[4\] _01661_ VGND VGND VPWR
+ VPWR _01691_ sky130_fd_sc_hd__nor2_1
X_06609_ u_interface.u_gelu_fp32.u_synth_top.s1_hits\[4\] u_interface.u_gelu_fp32.u_synth_top.s1_hits\[3\]
+ VGND VGND VPWR VPWR _01187_ sky130_fd_sc_hd__or2_1
XFILLER_13_449 VGND VGND VPWR VPWR sky130_fd_sc_hd__fill_2
X_09328_ _03074_ _03086_ VGND VGND VPWR VPWR _03087_ sky130_fd_sc_hd__xor2_1
XTAP_TAPCELL_ROW_136_2509 VGND VPWR sky130_fd_sc_hd__tapvpwrvgnd_1
XFILLER_21_482 VGND VGND VPWR VPWR sky130_fd_sc_hd__decap_4
X_09259_ _03015_ _03016_ _03014_ VGND VGND VPWR VPWR _03018_ sky130_fd_sc_hd__o21bai_1
XFILLER_154_649 VGND VGND VPWR VPWR sky130_fd_sc_hd__fill_1
XFILLER_119_370 VGND VGND VPWR VPWR sky130_fd_sc_hd__fill_1
XFILLER_111_3 VPWR VGND VPWR VGND sky130_ef_sc_hd__decap_12
XFILLER_5_615 VGND VGND VPWR VPWR sky130_fd_sc_hd__fill_1
X_12270_ _05997_ _05998_ _05999_ VGND VGND VPWR VPWR _00837_ sky130_fd_sc_hd__o21a_1
XFILLER_107_543 VGND VGND VPWR VPWR sky130_fd_sc_hd__fill_1
X_11221_ _04858_ _04862_ _04961_ VGND VGND VPWR VPWR _04963_ sky130_fd_sc_hd__a21oi_1
X_11152_ _04893_ _04894_ VGND VGND VPWR VPWR _04895_ sky130_fd_sc_hd__nor2_1
XTAP_TAPCELL_ROW_56_1235 VGND VPWR sky130_fd_sc_hd__tapvpwrvgnd_1
XTAP_TAPCELL_ROW_56_1224 VGND VPWR sky130_fd_sc_hd__tapvpwrvgnd_1
XFILLER_4_29 VPWR VGND VPWR VGND sky130_ef_sc_hd__decap_12
XFILLER_150_866 VGND VGND VPWR VPWR sky130_fd_sc_hd__fill_2
X_10103_ _03853_ _03854_ net196 VGND VGND VPWR VPWR _03855_ sky130_fd_sc_hd__o21ai_1
XTAP_TAPCELL_ROW_8_464 VGND VPWR sky130_fd_sc_hd__tapvpwrvgnd_1
XFILLER_1_821 VPWR VGND VPWR VGND sky130_ef_sc_hd__decap_12
XFILLER_88_460 VGND VGND VPWR VPWR sky130_fd_sc_hd__fill_2
XFILLER_68_76 VGND VGND VPWR VPWR sky130_fd_sc_hd__decap_8
X_11083_ _04737_ _04739_ _04825_ VGND VGND VPWR VPWR _04826_ sky130_fd_sc_hd__nand3_1
XFILLER_48_302 VGND VGND VPWR VPWR sky130_fd_sc_hd__decap_6
XFILLER_1_865 VPWR VGND VPWR VGND sky130_ef_sc_hd__decap_12
XFILLER_103_782 VGND VGND VPWR VPWR sky130_fd_sc_hd__fill_2
X_10034_ net627 net450 VGND VGND VPWR VPWR _03786_ sky130_fd_sc_hd__nand2_1
XFILLER_49_836 VGND VGND VPWR VPWR sky130_fd_sc_hd__decap_4
XFILLER_76_666 VGND VGND VPWR VPWR sky130_fd_sc_hd__fill_1
XFILLER_84_42 VGND VGND VPWR VPWR sky130_fd_sc_hd__fill_1
XFILLER_76_688 VGND VGND VPWR VPWR sky130_fd_sc_hd__fill_1
XFILLER_75_187 VPWR VGND VPWR VGND sky130_ef_sc_hd__decap_12
XFILLER_72_850 VGND VGND VPWR VPWR sky130_fd_sc_hd__fill_2
X_11985_ _05649_ _05718_ VGND VGND VPWR VPWR _05719_ sky130_fd_sc_hd__nand2b_1
X_13724_ clknet_leaf_7_clk _00734_ VGND VGND VPWR VPWR u_interface.u_gelu_fp32.s1_data\[24\]
+ sky130_fd_sc_hd__dfxtp_1
X_10936_ _04677_ _04679_ VGND VGND VPWR VPWR _04680_ sky130_fd_sc_hd__xnor2_1
XFILLER_17_777 VGND VGND VPWR VPWR sky130_fd_sc_hd__decap_6
XTAP_TAPCELL_ROW_27_761 VGND VPWR sky130_fd_sc_hd__tapvpwrvgnd_1
XTAP_TAPCELL_ROW_27_772 VGND VPWR sky130_fd_sc_hd__tapvpwrvgnd_1
XFILLER_32_725 VPWR VGND VPWR VGND sky130_ef_sc_hd__decap_12
X_13655_ clknet_leaf_15_clk _00665_ VGND VGND VPWR VPWR u_interface.u_gelu_fp32.u_fp32_to_q16.s1_exp\[1\]
+ sky130_fd_sc_hd__dfxtp_1
XFILLER_71_393 VGND VGND VPWR VPWR sky130_fd_sc_hd__decap_4
X_10867_ _04603_ _04611_ VGND VGND VPWR VPWR _04612_ sky130_fd_sc_hd__xnor2_1
X_12606_ _06307_ _06308_ u_interface.u_gelu_fp32.u_q16_to_fp32.s1_mag\[30\] _06300_
+ VGND VGND VPWR VPWR _06309_ sky130_fd_sc_hd__a211o_1
XFILLER_32_769 VPWR VGND VPWR VGND sky130_ef_sc_hd__decap_12
X_13586_ clknet_leaf_54_clk _00596_ VGND VGND VPWR VPWR u_interface.fifo_data\[3\]\[1\]
+ sky130_fd_sc_hd__dfxtp_1
X_10798_ _04459_ _04460_ _04540_ _04541_ VGND VGND VPWR VPWR _04544_ sky130_fd_sc_hd__and4_1
XFILLER_129_167 VGND VGND VPWR VPWR sky130_fd_sc_hd__fill_1
X_12537_ _06259_ _06260_ VGND VGND VPWR VPWR _06261_ sky130_fd_sc_hd__nor2_1
XFILLER_8_453 VGND VGND VPWR VPWR sky130_fd_sc_hd__fill_1
XFILLER_145_638 VGND VGND VPWR VPWR sky130_fd_sc_hd__decap_4
XFILLER_8_475 VGND VGND VPWR VPWR sky130_fd_sc_hd__fill_1
X_12468_ _06192_ _06193_ VGND VGND VPWR VPWR _06194_ sky130_fd_sc_hd__or2_1
X_11419_ _05071_ _05075_ _05157_ VGND VGND VPWR VPWR _05159_ sky130_fd_sc_hd__a21oi_1
X_14138_ clknet_leaf_30_clk _01064_ VGND VGND VPWR VPWR u_interface.fifo_count\[5\]
+ sky130_fd_sc_hd__dfxtp_1
X_12399_ net177 _06073_ _06076_ VGND VGND VPWR VPWR _06126_ sky130_fd_sc_hd__nor3_1
XFILLER_140_343 VGND VGND VPWR VPWR sky130_fd_sc_hd__fill_2
XFILLER_113_557 VGND VGND VPWR VPWR sky130_fd_sc_hd__decap_3
XFILLER_4_681 VPWR VGND VPWR VGND sky130_ef_sc_hd__decap_12
X_14069_ clknet_leaf_31_clk _00995_ VGND VGND VPWR VPWR u_interface.pipeline_enable
+ sky130_fd_sc_hd__dfxtp_1
XFILLER_140_365 VPWR VGND VPWR VGND sky130_ef_sc_hd__decap_12
Xclkbuf_leaf_3_clk clknet_3_2__leaf_clk VGND VGND VPWR VPWR clknet_leaf_3_clk sky130_fd_sc_hd__clkbuf_8
X_06960_ u_interface.u_gelu_fp32.u_synth_top.s1_x\[28\] net275 _01487_ VGND VGND VPWR
+ VPWR _01489_ sky130_fd_sc_hd__a21o_1
X_06891_ _01432_ _01433_ VGND VGND VPWR VPWR _01434_ sky130_fd_sc_hd__nand2_1
XFILLER_66_110 VPWR VGND VPWR VGND sky130_ef_sc_hd__decap_12
XFILLER_39_335 VGND VGND VPWR VPWR sky130_fd_sc_hd__fill_1
X_08630_ net157 _02402_ VGND VGND VPWR VPWR _02403_ sky130_fd_sc_hd__nand2_1
XTAP_TAPCELL_ROW_87_1729 VGND VPWR sky130_fd_sc_hd__tapvpwrvgnd_1
XFILLER_82_636 VGND VGND VPWR VPWR sky130_fd_sc_hd__decap_3
XFILLER_54_338 VGND VGND VPWR VPWR sky130_fd_sc_hd__decap_3
X_08561_ _02325_ _02347_ _02351_ VGND VGND VPWR VPWR _02352_ sky130_fd_sc_hd__nor3_1
XFILLER_35_541 VGND VGND VPWR VPWR sky130_fd_sc_hd__fill_1
X_07512_ _01642_ _01641_ net544 VGND VGND VPWR VPWR _01643_ sky130_fd_sc_hd__mux2_1
X_08492_ _02266_ _02274_ _02282_ VGND VGND VPWR VPWR _02283_ sky130_fd_sc_hd__or3_1
X_07443_ u_interface.u_gelu_fp32.u_fp32_to_q16.s2_norm_mag\[25\] u_interface.u_gelu_fp32.u_fp32_to_q16.s2_norm_mag\[26\]
+ net559 VGND VGND VPWR VPWR _01578_ sky130_fd_sc_hd__mux2_1
XFILLER_11_909 VGND VGND VPWR VPWR sky130_fd_sc_hd__decap_8
XFILLER_22_268 VPWR VGND VPWR VGND sky130_ef_sc_hd__decap_12
X_09113_ _02713_ _02871_ VGND VGND VPWR VPWR _02872_ sky130_fd_sc_hd__or2_1
X_07374_ net1402 net370 net239 VGND VGND VPWR VPWR _00404_ sky130_fd_sc_hd__mux2_1
XTAP_TAPCELL_ROW_118_2228 VGND VPWR sky130_fd_sc_hd__tapvpwrvgnd_1
XTAP_TAPCELL_ROW_118_2217 VGND VPWR sky130_fd_sc_hd__tapvpwrvgnd_1
XFILLER_10_419 VGND VGND VPWR VPWR sky130_fd_sc_hd__fill_1
XFILLER_13_27 VPWR VGND VPWR VGND sky130_ef_sc_hd__decap_12
XFILLER_136_605 VGND VGND VPWR VPWR sky130_fd_sc_hd__decap_4
XFILLER_129_27 VGND VGND VPWR VPWR sky130_fd_sc_hd__decap_6
X_09044_ _02753_ _02766_ _02781_ _02800_ VGND VGND VPWR VPWR _02803_ sky130_fd_sc_hd__a211o_1
XFILLER_117_830 VGND VGND VPWR VPWR sky130_fd_sc_hd__fill_2
XTAP_TAPCELL_ROW_131_2439 VGND VPWR sky130_fd_sc_hd__tapvpwrvgnd_1
XTAP_TAPCELL_ROW_131_2428 VGND VPWR sky130_fd_sc_hd__tapvpwrvgnd_1
Xhold420 u_interface.fifo_data\[14\]\[14\] VGND VGND VPWR VPWR net1285 sky130_fd_sc_hd__dlygate4sd3_1
XPHY_EDGE_ROW_147_Left_303 VGND VGND VPWR VPWR sky130_fd_sc_hd__decap_3
XFILLER_144_682 VGND VGND VPWR VPWR sky130_fd_sc_hd__fill_2
Xhold431 u_interface.fifo_data\[10\]\[26\] VGND VGND VPWR VPWR net1296 sky130_fd_sc_hd__dlygate4sd3_1
Xhold442 u_interface.fifo_data\[1\]\[10\] VGND VGND VPWR VPWR net1307 sky130_fd_sc_hd__dlygate4sd3_1
XFILLER_132_822 VGND VGND VPWR VPWR sky130_fd_sc_hd__decap_3
XFILLER_132_811 VGND VGND VPWR VPWR sky130_fd_sc_hd__fill_1
Xhold453 u_interface.fifo_data\[8\]\[17\] VGND VGND VPWR VPWR net1318 sky130_fd_sc_hd__dlygate4sd3_1
XFILLER_104_502 VGND VGND VPWR VPWR sky130_fd_sc_hd__decap_8
XFILLER_143_181 VGND VGND VPWR VPWR sky130_fd_sc_hd__fill_1
XFILLER_132_866 VGND VGND VPWR VPWR sky130_fd_sc_hd__fill_2
XFILLER_131_332 VGND VGND VPWR VPWR sky130_fd_sc_hd__decap_4
Xmax_cap172 _03619_ VGND VGND VPWR VPWR net172 sky130_fd_sc_hd__buf_1
Xhold475 u_interface.fifo_data\[2\]\[18\] VGND VGND VPWR VPWR net1340 sky130_fd_sc_hd__dlygate4sd3_1
Xhold464 u_interface.fifo_data\[6\]\[3\] VGND VGND VPWR VPWR net1329 sky130_fd_sc_hd__dlygate4sd3_1
Xhold486 u_interface.fifo_data\[11\]\[31\] VGND VGND VPWR VPWR net1351 sky130_fd_sc_hd__dlygate4sd3_1
X_09946_ _03696_ _03697_ _03698_ VGND VGND VPWR VPWR _03699_ sky130_fd_sc_hd__a21oi_1
Xhold497 u_interface.u_gelu_fp32.u_q16_to_fp32.s2_mag\[30\] VGND VGND VPWR VPWR net1362
+ sky130_fd_sc_hd__dlygate4sd3_1
XTAP_TAPCELL_ROW_5_412 VGND VPWR sky130_fd_sc_hd__tapvpwrvgnd_1
XFILLER_86_920 VGND VGND VPWR VPWR sky130_fd_sc_hd__fill_1
XFILLER_58_633 VGND VGND VPWR VPWR sky130_fd_sc_hd__decap_8
XTAP_TAPCELL_ROW_5_423 VGND VPWR sky130_fd_sc_hd__tapvpwrvgnd_1
XTAP_TAPCELL_ROW_146_2671 VGND VPWR sky130_fd_sc_hd__tapvpwrvgnd_1
X_09877_ _03521_ _03528_ _03629_ VGND VGND VPWR VPWR _03631_ sky130_fd_sc_hd__o21ai_1
XTAP_TAPCELL_ROW_51_1154 VGND VPWR sky130_fd_sc_hd__tapvpwrvgnd_1
XFILLER_46_817 VGND VGND VPWR VPWR sky130_fd_sc_hd__fill_1
X_08828_ net663 net511 _02585_ _02583_ VGND VGND VPWR VPWR _02587_ sky130_fd_sc_hd__a31o_1
XPHY_EDGE_ROW_79_Right_79 VGND VGND VPWR VPWR sky130_fd_sc_hd__decap_3
XFILLER_57_187 VGND VGND VPWR VPWR sky130_fd_sc_hd__decap_8
X_08759_ _02509_ _02516_ _02517_ _02501_ VGND VGND VPWR VPWR _02518_ sky130_fd_sc_hd__a211oi_1
XFILLER_45_349 VPWR VGND VPWR VGND sky130_ef_sc_hd__decap_12
XFILLER_26_552 VGND VGND VPWR VPWR sky130_fd_sc_hd__decap_6
X_11770_ net214 _05505_ VGND VGND VPWR VPWR _05506_ sky130_fd_sc_hd__xnor2_1
XFILLER_41_500 VGND VGND VPWR VPWR sky130_fd_sc_hd__decap_4
X_10721_ _04461_ _04465_ VGND VGND VPWR VPWR _04467_ sky130_fd_sc_hd__xor2_1
XFILLER_53_393 VGND VGND VPWR VPWR sky130_fd_sc_hd__decap_3
XFILLER_14_725 VPWR VGND VPWR VGND sky130_ef_sc_hd__decap_12
XTAP_TAPCELL_ROW_24_720 VGND VPWR sky130_fd_sc_hd__tapvpwrvgnd_1
XFILLER_41_522 VGND VGND VPWR VPWR sky130_fd_sc_hd__decap_8
X_13440_ clknet_leaf_10_clk _00450_ VGND VGND VPWR VPWR u_interface.u_gelu_fp32.u_fp32_to_q16.s3_mag\[11\]
+ sky130_fd_sc_hd__dfxtp_1
XFILLER_14_769 VPWR VGND VPWR VGND sky130_ef_sc_hd__decap_12
X_10652_ net603 net609 net417 net414 VGND VGND VPWR VPWR _04399_ sky130_fd_sc_hd__nand4_1
X_13371_ clknet_leaf_32_clk _00381_ VGND VGND VPWR VPWR u_interface.fifo_data\[7\]\[16\]
+ sky130_fd_sc_hd__dfxtp_1
X_10583_ _04322_ _04326_ _04327_ VGND VGND VPWR VPWR _04330_ sky130_fd_sc_hd__nand3_1
XPHY_EDGE_ROW_88_Right_88 VGND VGND VPWR VPWR sky130_fd_sc_hd__decap_3
XFILLER_5_412 VGND VGND VPWR VPWR sky130_fd_sc_hd__decap_4
XFILLER_5_401 VGND VGND VPWR VPWR sky130_fd_sc_hd__fill_1
X_12322_ _05938_ _05987_ _05986_ VGND VGND VPWR VPWR _06051_ sky130_fd_sc_hd__a21o_1
XFILLER_126_148 VGND VGND VPWR VPWR sky130_fd_sc_hd__decap_4
XFILLER_108_852 VGND VGND VPWR VPWR sky130_fd_sc_hd__decap_4
X_12253_ _05980_ _05981_ VGND VGND VPWR VPWR _05983_ sky130_fd_sc_hd__xnor2_1
XFILLER_107_373 VPWR VGND VPWR VGND sky130_ef_sc_hd__decap_12
XFILLER_79_31 VGND VGND VPWR VPWR sky130_fd_sc_hd__fill_1
X_11204_ _04835_ _04843_ _04842_ VGND VGND VPWR VPWR _04946_ sky130_fd_sc_hd__a21oi_2
XFILLER_122_321 VGND VGND VPWR VPWR sky130_fd_sc_hd__decap_8
X_12184_ _05810_ _05848_ _05847_ VGND VGND VPWR VPWR _05915_ sky130_fd_sc_hd__a21oi_1
XFILLER_122_365 VGND VGND VPWR VPWR sky130_fd_sc_hd__decap_3
XFILLER_68_419 VGND VGND VPWR VPWR sky130_fd_sc_hd__fill_1
X_11135_ _04868_ _04877_ VGND VGND VPWR VPWR _04878_ sky130_fd_sc_hd__xnor2_1
X_11066_ _04807_ _04808_ VGND VGND VPWR VPWR _04809_ sky130_fd_sc_hd__nor2_1
XFILLER_1_673 VPWR VGND VPWR VGND sky130_ef_sc_hd__decap_12
XPHY_EDGE_ROW_97_Right_97 VGND VGND VPWR VPWR sky130_fd_sc_hd__decap_3
X_10017_ _03767_ _03768_ _03760_ VGND VGND VPWR VPWR _03769_ sky130_fd_sc_hd__a21o_1
XFILLER_49_644 VGND VGND VPWR VPWR sky130_fd_sc_hd__fill_1
XTAP_TAPCELL_ROW_69_1437 VGND VPWR sky130_fd_sc_hd__tapvpwrvgnd_1
XFILLER_63_102 VGND VGND VPWR VPWR sky130_fd_sc_hd__decap_8
XFILLER_36_327 VPWR VGND VPWR VGND sky130_ef_sc_hd__decap_12
XFILLER_63_113 VPWR VGND VPWR VGND sky130_ef_sc_hd__decap_12
X_13707_ clknet_leaf_22_clk _00717_ VGND VGND VPWR VPWR u_interface.u_gelu_fp32.s1_data\[7\]
+ sky130_fd_sc_hd__dfxtp_1
XTAP_TAPCELL_ROW_82_1648 VGND VPWR sky130_fd_sc_hd__tapvpwrvgnd_1
XFILLER_17_585 VPWR VGND VPWR VGND sky130_ef_sc_hd__decap_12
X_11968_ _05586_ _05620_ _05619_ VGND VGND VPWR VPWR _05702_ sky130_fd_sc_hd__a21oi_1
XFILLER_32_533 VGND VGND VPWR VPWR sky130_fd_sc_hd__decap_4
X_10919_ net196 _04663_ VGND VGND VPWR VPWR _04664_ sky130_fd_sc_hd__xnor2_2
X_11899_ _05488_ _05555_ _05554_ VGND VGND VPWR VPWR _05634_ sky130_fd_sc_hd__a21oi_1
X_13638_ clknet_leaf_76_clk _00648_ VGND VGND VPWR VPWR u_interface.fifo_data\[13\]\[21\]
+ sky130_fd_sc_hd__dfxtp_1
XFILLER_146_914 VGND VGND VPWR VPWR sky130_fd_sc_hd__decap_6
X_13569_ clknet_leaf_32_clk _00579_ VGND VGND VPWR VPWR u_interface.fifo_data\[4\]\[16\]
+ sky130_fd_sc_hd__dfxtp_1
XFILLER_74_3 VPWR VGND VPWR VGND sky130_ef_sc_hd__decap_12
X_07090_ net1078 net366 net225 VGND VGND VPWR VPWR _00130_ sky130_fd_sc_hd__mux2_1
XFILLER_8_261 VGND VGND VPWR VPWR sky130_fd_sc_hd__fill_2
XFILLER_8_250 VGND VGND VPWR VPWR sky130_fd_sc_hd__fill_2
XTAP_TAPCELL_ROW_113_2147 VGND VPWR sky130_fd_sc_hd__tapvpwrvgnd_1
XTAP_TAPCELL_ROW_113_2136 VGND VPWR sky130_fd_sc_hd__tapvpwrvgnd_1
XTAP_TAPCELL_ROW_97_1891 VGND VPWR sky130_fd_sc_hd__tapvpwrvgnd_1
XTAP_TAPCELL_ROW_97_1880 VGND VPWR sky130_fd_sc_hd__tapvpwrvgnd_1
XTAP_TAPCELL_ROW_10_491 VGND VPWR sky130_fd_sc_hd__tapvpwrvgnd_1
X_07992_ net310 _01666_ _01858_ VGND VGND VPWR VPWR _01859_ sky130_fd_sc_hd__o21a_1
XFILLER_114_888 VGND VGND VPWR VPWR sky130_fd_sc_hd__fill_1
XFILLER_101_505 VPWR VGND VPWR VGND sky130_ef_sc_hd__decap_12
X_09800_ _03541_ _03550_ _03551_ VGND VGND VPWR VPWR _03554_ sky130_fd_sc_hd__nand3_1
Xfanout218 _01526_ VGND VGND VPWR VPWR net218 sky130_fd_sc_hd__clkbuf_4
Xfanout207 _01525_ VGND VGND VPWR VPWR net207 sky130_fd_sc_hd__buf_4
Xfanout229 net230 VGND VGND VPWR VPWR net229 sky130_fd_sc_hd__buf_4
XFILLER_113_376 VPWR VGND VPWR VGND sky130_ef_sc_hd__decap_12
X_09731_ net490 net495 net689 net696 VGND VGND VPWR VPWR _03486_ sky130_fd_sc_hd__nand4_1
X_06943_ u_interface.u_gelu_fp32.u_synth_top.s1_x\[26\] net275 VGND VGND VPWR VPWR
+ _01475_ sky130_fd_sc_hd__xnor2_1
XFILLER_68_920 VGND VGND VPWR VPWR sky130_fd_sc_hd__fill_1
XTAP_TAPCELL_ROW_128_2390 VGND VPWR sky130_fd_sc_hd__tapvpwrvgnd_1
X_09662_ _03415_ _03416_ VGND VGND VPWR VPWR _03418_ sky130_fd_sc_hd__nor2_1
X_06874_ u_interface.fifo_data\[4\]\[30\] u_interface.fifo_data\[5\]\[30\] u_interface.fifo_data\[6\]\[30\]
+ u_interface.fifo_data\[7\]\[30\] net760 net743 VGND VGND VPWR VPWR _01419_ sky130_fd_sc_hd__mux4_1
X_09593_ _03347_ _03348_ VGND VGND VPWR VPWR _03349_ sky130_fd_sc_hd__nor2_1
X_08613_ net154 _02390_ net800 VGND VGND VPWR VPWR _00789_ sky130_fd_sc_hd__a21oi_1
XFILLER_27_327 VGND VGND VPWR VPWR sky130_fd_sc_hd__fill_1
XFILLER_39_198 VGND VGND VPWR VPWR sky130_fd_sc_hd__decap_4
XFILLER_82_477 VGND VGND VPWR VPWR sky130_fd_sc_hd__fill_1
X_08544_ _02286_ _02334_ _02281_ VGND VGND VPWR VPWR _02335_ sky130_fd_sc_hd__a21oi_1
XTAP_TAPCELL_ROW_141_2590 VGND VPWR sky130_fd_sc_hd__tapvpwrvgnd_1
XFILLER_24_15 VPWR VGND VPWR VGND sky130_ef_sc_hd__decap_12
XFILLER_145_9 VGND VGND VPWR VPWR sky130_fd_sc_hd__decap_3
X_08475_ _02258_ _02262_ _02263_ _02265_ VGND VGND VPWR VPWR _02266_ sky130_fd_sc_hd__o211a_1
XFILLER_35_393 VGND VGND VPWR VPWR sky130_fd_sc_hd__decap_6
X_07426_ u_interface.u_gelu_fp32.u_fp32_to_q16.s2_norm_mag\[10\] u_interface.u_gelu_fp32.u_fp32_to_q16.s2_norm_mag\[11\]
+ net560 VGND VGND VPWR VPWR _01562_ sky130_fd_sc_hd__mux2_1
XFILLER_50_385 VPWR VGND VPWR VGND sky130_ef_sc_hd__decap_12
XFILLER_10_216 VGND VGND VPWR VPWR sky130_fd_sc_hd__decap_8
XFILLER_23_588 VPWR VGND VPWR VGND sky130_ef_sc_hd__decap_12
XFILLER_149_774 VGND VGND VPWR VPWR sky130_fd_sc_hd__decap_8
X_07357_ net340 net1523 net243 VGND VGND VPWR VPWR _00387_ sky130_fd_sc_hd__mux2_1
XFILLER_137_914 VGND VGND VPWR VPWR sky130_fd_sc_hd__decap_6
XFILLER_149_785 VGND VGND VPWR VPWR sky130_fd_sc_hd__decap_3
XFILLER_136_413 VGND VGND VPWR VPWR sky130_fd_sc_hd__fill_1
XFILLER_108_104 VGND VGND VPWR VPWR sky130_fd_sc_hd__fill_1
XFILLER_6_209 VPWR VGND VPWR VGND sky130_ef_sc_hd__decap_12
X_09027_ net646 net510 VGND VGND VPWR VPWR _02786_ sky130_fd_sc_hd__nand2_1
X_07288_ net1318 net351 net247 VGND VGND VPWR VPWR _00318_ sky130_fd_sc_hd__mux2_1
XFILLER_151_416 VGND VGND VPWR VPWR sky130_fd_sc_hd__decap_6
XFILLER_123_107 VGND VGND VPWR VPWR sky130_fd_sc_hd__decap_4
XFILLER_151_449 VPWR VGND VPWR VGND sky130_ef_sc_hd__decap_12
Xhold261 u_interface.fifo_tuser\[13\] VGND VGND VPWR VPWR net1126 sky130_fd_sc_hd__dlygate4sd3_1
Xhold250 u_interface.fifo_data\[1\]\[12\] VGND VGND VPWR VPWR net1115 sky130_fd_sc_hd__dlygate4sd3_1
XTAP_TAPCELL_ROW_148_2711 VGND VPWR sky130_fd_sc_hd__tapvpwrvgnd_1
XTAP_TAPCELL_ROW_148_2700 VGND VPWR sky130_fd_sc_hd__tapvpwrvgnd_1
XFILLER_131_140 VGND VGND VPWR VPWR sky130_fd_sc_hd__fill_2
Xhold272 u_interface.fifo_data\[1\]\[27\] VGND VGND VPWR VPWR net1137 sky130_fd_sc_hd__dlygate4sd3_1
Xhold294 u_interface.fifo_data\[10\]\[12\] VGND VGND VPWR VPWR net1159 sky130_fd_sc_hd__dlygate4sd3_1
Xhold283 u_interface.fifo_data\[6\]\[12\] VGND VGND VPWR VPWR net1148 sky130_fd_sc_hd__dlygate4sd3_1
XFILLER_131_173 VGND VGND VPWR VPWR sky130_fd_sc_hd__fill_1
XFILLER_77_216 VGND VGND VPWR VPWR sky130_fd_sc_hd__decap_3
Xfanout730 net732 VGND VGND VPWR VPWR net730 sky130_fd_sc_hd__clkbuf_4
Xfanout741 net742 VGND VGND VPWR VPWR net741 sky130_fd_sc_hd__buf_2
Xfanout752 net753 VGND VGND VPWR VPWR net752 sky130_fd_sc_hd__clkbuf_4
Xfanout785 net786 VGND VGND VPWR VPWR net785 sky130_fd_sc_hd__clkbuf_2
XPHY_EDGE_ROW_130_Right_130 VGND VGND VPWR VPWR sky130_fd_sc_hd__decap_3
Xfanout774 net779 VGND VGND VPWR VPWR net774 sky130_fd_sc_hd__clkbuf_4
Xfanout763 net771 VGND VGND VPWR VPWR net763 sky130_fd_sc_hd__buf_4
X_09929_ _03674_ _03681_ VGND VGND VPWR VPWR _03682_ sky130_fd_sc_hd__or2_1
X_12940_ u_interface.in_flight_count\[4\] _06439_ _06458_ VGND VGND VPWR VPWR _06463_
+ sky130_fd_sc_hd__nor3_1
XFILLER_85_271 VGND VGND VPWR VPWR sky130_fd_sc_hd__fill_1
Xfanout796 net797 VGND VGND VPWR VPWR net796 sky130_fd_sc_hd__clkbuf_4
XFILLER_19_839 VGND VGND VPWR VPWR sky130_fd_sc_hd__fill_1
XTAP_TAPCELL_ROW_29_801 VGND VPWR sky130_fd_sc_hd__tapvpwrvgnd_1
X_12871_ net1302 u_interface.u_gelu_fp32.u_fp32_to_q16.s2_norm_mag\[26\] net818 VGND
+ VGND VPWR VPWR _01015_ sky130_fd_sc_hd__mux2_1
XFILLER_73_422 VPWR VGND VPWR VGND sky130_ef_sc_hd__decap_12
XFILLER_45_113 VPWR VGND VPWR VGND sky130_ef_sc_hd__decap_12
XFILLER_34_809 VGND VGND VPWR VPWR sky130_fd_sc_hd__decap_3
XFILLER_61_617 VGND VGND VPWR VPWR sky130_fd_sc_hd__decap_3
X_11822_ _05556_ _05557_ VGND VGND VPWR VPWR _05558_ sky130_fd_sc_hd__nor2_1
XFILLER_121_50 VGND VGND VPWR VPWR sky130_fd_sc_hd__decap_6
XFILLER_14_511 VPWR VGND VPWR VGND sky130_ef_sc_hd__decap_12
XTAP_TAPCELL_ROW_64_1367 VGND VPWR sky130_fd_sc_hd__tapvpwrvgnd_1
XTAP_TAPCELL_ROW_64_1356 VGND VPWR sky130_fd_sc_hd__tapvpwrvgnd_1
XFILLER_60_138 VGND VGND VPWR VPWR sky130_fd_sc_hd__fill_2
XFILLER_14_533 VPWR VGND VPWR VGND sky130_ef_sc_hd__decap_12
X_11753_ _05406_ _05409_ _05410_ VGND VGND VPWR VPWR _05489_ sky130_fd_sc_hd__a21bo_1
XFILLER_41_330 VGND VGND VPWR VPWR sky130_fd_sc_hd__decap_6
X_10704_ _04445_ _04447_ _04448_ VGND VGND VPWR VPWR _04450_ sky130_fd_sc_hd__nand3_1
X_11684_ _05415_ _05419_ _05420_ VGND VGND VPWR VPWR _05421_ sky130_fd_sc_hd__and3_1
X_13423_ clknet_leaf_18_clk _00433_ VGND VGND VPWR VPWR u_interface.u_gelu_fp32.u_fp32_to_q16.s3_frac\[3\]
+ sky130_fd_sc_hd__dfxtp_1
X_10635_ _04380_ _04381_ _04379_ VGND VGND VPWR VPWR _04382_ sky130_fd_sc_hd__a21o_1
X_13354_ clknet_leaf_75_clk _00364_ VGND VGND VPWR VPWR u_interface.fifo_data\[10\]\[31\]
+ sky130_fd_sc_hd__dfxtp_1
XFILLER_154_232 VGND VGND VPWR VPWR sky130_fd_sc_hd__fill_2
X_10566_ _04200_ _04313_ VGND VGND VPWR VPWR _04314_ sky130_fd_sc_hd__nor2_1
X_12305_ _05955_ _05971_ _05970_ VGND VGND VPWR VPWR _06034_ sky130_fd_sc_hd__o21ba_1
X_13285_ clknet_leaf_68_clk _00295_ VGND VGND VPWR VPWR u_interface.fifo_data\[0\]\[27\]
+ sky130_fd_sc_hd__dfxtp_1
X_10497_ _04243_ _04244_ _04240_ VGND VGND VPWR VPWR _04245_ sky130_fd_sc_hd__a21o_1
X_12236_ _05964_ _05965_ VGND VGND VPWR VPWR _05966_ sky130_fd_sc_hd__and2_1
XFILLER_123_641 VGND VGND VPWR VPWR sky130_fd_sc_hd__decap_4
X_12167_ _05893_ _05897_ VGND VGND VPWR VPWR _05898_ sky130_fd_sc_hd__xnor2_1
XFILLER_150_493 VGND VGND VPWR VPWR sky130_fd_sc_hd__decap_3
X_11118_ _04851_ _04859_ VGND VGND VPWR VPWR _04861_ sky130_fd_sc_hd__and2_1
XFILLER_110_346 VPWR VGND VPWR VGND sky130_ef_sc_hd__decap_12
X_12098_ net684 net390 VGND VGND VPWR VPWR _05830_ sky130_fd_sc_hd__nand2_1
Xinput7 s_axil_araddr[13] VGND VGND VPWR VPWR net7 sky130_fd_sc_hd__buf_1
XFILLER_77_794 VGND VGND VPWR VPWR sky130_fd_sc_hd__fill_1
X_11049_ _04791_ _04792_ VGND VGND VPWR VPWR _00823_ sky130_fd_sc_hd__nor2_1
XFILLER_92_731 VGND VGND VPWR VPWR sky130_fd_sc_hd__fill_1
XFILLER_64_444 VPWR VGND VPWR VGND sky130_ef_sc_hd__decap_12
XFILLER_64_411 VGND VGND VPWR VPWR sky130_fd_sc_hd__decap_8
XFILLER_36_135 VGND VGND VPWR VPWR sky130_fd_sc_hd__decap_4
XFILLER_64_477 VPWR VGND VPWR VGND sky130_ef_sc_hd__decap_12
XFILLER_18_861 VGND VGND VPWR VPWR sky130_fd_sc_hd__decap_6
XFILLER_25_809 VPWR VGND VPWR VGND sky130_ef_sc_hd__decap_12
X_06590_ net537 net535 _01162_ _01176_ VGND VGND VPWR VPWR _00021_ sky130_fd_sc_hd__and4_1
XFILLER_33_853 VPWR VGND VPWR VGND sky130_ef_sc_hd__decap_12
X_08260_ _02077_ _02078_ VGND VGND VPWR VPWR _00748_ sky130_fd_sc_hd__nor2_1
XFILLER_32_363 VGND VGND VPWR VPWR sky130_fd_sc_hd__fill_1
XFILLER_33_897 VPWR VGND VPWR VGND sky130_ef_sc_hd__decap_12
X_07211_ net346 net1446 net260 VGND VGND VPWR VPWR _00251_ sky130_fd_sc_hd__mux2_1
X_08191_ _01889_ _02024_ VGND VGND VPWR VPWR _02025_ sky130_fd_sc_hd__nor2_1
XTAP_TAPCELL_ROW_99_1920 VGND VPWR sky130_fd_sc_hd__tapvpwrvgnd_1
XTAP_TAPCELL_ROW_15_572 VGND VPWR sky130_fd_sc_hd__tapvpwrvgnd_1
XTAP_TAPCELL_ROW_15_583 VGND VPWR sky130_fd_sc_hd__tapvpwrvgnd_1
XFILLER_20_547 VGND VGND VPWR VPWR sky130_fd_sc_hd__fill_2
XFILLER_20_558 VGND VGND VPWR VPWR sky130_fd_sc_hd__decap_6
X_07142_ net1017 net356 net219 VGND VGND VPWR VPWR _00182_ sky130_fd_sc_hd__mux2_1
XFILLER_118_457 VPWR VGND VPWR VGND sky130_ef_sc_hd__decap_12
X_07073_ net1174 net576 net210 VGND VGND VPWR VPWR _00113_ sky130_fd_sc_hd__mux2_1
XFILLER_133_449 VPWR VGND VPWR VGND sky130_ef_sc_hd__decap_12
XFILLER_105_129 VGND VGND VPWR VPWR sky130_fd_sc_hd__decap_4
XFILLER_114_641 VGND VGND VPWR VPWR sky130_fd_sc_hd__decap_3
XFILLER_113_151 VGND VGND VPWR VPWR sky130_fd_sc_hd__decap_8
XFILLER_102_847 VGND VGND VPWR VPWR sky130_fd_sc_hd__fill_1
XFILLER_102_825 VGND VGND VPWR VPWR sky130_fd_sc_hd__decap_6
XFILLER_87_536 VGND VGND VPWR VPWR sky130_fd_sc_hd__decap_3
X_07975_ net780 net948 _01849_ VGND VGND VPWR VPWR _00692_ sky130_fd_sc_hd__o21a_1
XFILLER_102_869 VGND VGND VPWR VPWR sky130_fd_sc_hd__decap_4
XFILLER_59_249 VGND VGND VPWR VPWR sky130_fd_sc_hd__fill_2
XFILLER_19_15 VPWR VGND VPWR VGND sky130_ef_sc_hd__decap_12
XFILLER_142_27 VGND VGND VPWR VPWR sky130_fd_sc_hd__fill_1
XTAP_TAPCELL_ROW_126_2349 VGND VPWR sky130_fd_sc_hd__tapvpwrvgnd_1
X_09714_ _03397_ _03399_ VGND VGND VPWR VPWR _03469_ sky130_fd_sc_hd__nand2b_1
XFILLER_101_379 VGND VGND VPWR VPWR sky130_fd_sc_hd__decap_4
XFILLER_101_368 VGND VGND VPWR VPWR sky130_fd_sc_hd__decap_4
X_06926_ _01452_ _01454_ _01457_ VGND VGND VPWR VPWR _01462_ sky130_fd_sc_hd__or3_1
XFILLER_74_208 VGND VGND VPWR VPWR sky130_fd_sc_hd__decap_4
XFILLER_28_625 VPWR VGND VPWR VGND sky130_ef_sc_hd__decap_12
XTAP_TAPCELL_ROW_143_2630 VGND VPWR sky130_fd_sc_hd__tapvpwrvgnd_1
X_06857_ u_interface.fifo_data\[0\]\[28\] u_interface.fifo_data\[1\]\[28\] u_interface.fifo_data\[2\]\[28\]
+ u_interface.fifo_data\[3\]\[28\] net769 net752 VGND VGND VPWR VPWR _01404_ sky130_fd_sc_hd__mux4_1
XFILLER_110_891 VGND VGND VPWR VPWR sky130_fd_sc_hd__fill_2
X_09645_ _03300_ _03398_ _03399_ VGND VGND VPWR VPWR _03401_ sky130_fd_sc_hd__and3_2
XFILLER_83_753 VGND VGND VPWR VPWR sky130_fd_sc_hd__fill_1
XFILLER_83_742 VGND VGND VPWR VPWR sky130_fd_sc_hd__decap_3
XFILLER_43_617 VPWR VGND VPWR VGND sky130_ef_sc_hd__decap_12
XFILLER_28_669 VPWR VGND VPWR VGND sky130_ef_sc_hd__decap_12
X_06788_ _01339_ _01340_ _01343_ net319 VGND VGND VPWR VPWR net119 sky130_fd_sc_hd__a22o_1
X_09576_ _03330_ _03331_ VGND VGND VPWR VPWR _03332_ sky130_fd_sc_hd__and2b_1
XFILLER_70_469 VGND VGND VPWR VPWR sky130_fd_sc_hd__decap_6
X_08527_ _02314_ _02317_ _02155_ VGND VGND VPWR VPWR _02318_ sky130_fd_sc_hd__a21o_1
XFILLER_35_69 VGND VGND VPWR VPWR sky130_fd_sc_hd__decap_6
X_08458_ _02244_ _02245_ _02247_ VGND VGND VPWR VPWR _02249_ sky130_fd_sc_hd__or3_1
XTAP_TAPCELL_ROW_46_1075 VGND VPWR sky130_fd_sc_hd__tapvpwrvgnd_1
XTAP_TAPCELL_ROW_46_1064 VGND VPWR sky130_fd_sc_hd__tapvpwrvgnd_1
X_07409_ _01543_ _01544_ net555 VGND VGND VPWR VPWR _01545_ sky130_fd_sc_hd__mux2_1
XFILLER_50_171 VGND VGND VPWR VPWR sky130_fd_sc_hd__fill_1
XTAP_TAPCELL_ROW_34_881 VGND VPWR sky130_fd_sc_hd__tapvpwrvgnd_1
XFILLER_149_571 VPWR VGND VPWR VGND sky130_ef_sc_hd__decap_12
XFILLER_109_424 VGND VGND VPWR VPWR sky130_fd_sc_hd__decap_3
X_10420_ _04167_ _04168_ _04040_ VGND VGND VPWR VPWR _04169_ sky130_fd_sc_hd__a21o_1
X_08389_ u_interface.u_gelu_fp32.u_synth_top.s3_mult\[30\] u_interface.u_gelu_fp32.u_synth_top.s3_b\[14\]
+ VGND VGND VPWR VPWR _02180_ sky130_fd_sc_hd__or2_1
XFILLER_51_57 VGND VGND VPWR VPWR sky130_fd_sc_hd__fill_2
XFILLER_7_529 VPWR VGND VPWR VGND sky130_ef_sc_hd__decap_12
XTAP_TAPCELL_ROW_154_2792 VGND VPWR sky130_fd_sc_hd__tapvpwrvgnd_1
XFILLER_109_479 VGND VGND VPWR VPWR sky130_fd_sc_hd__decap_4
X_10351_ _04098_ _04099_ net190 VGND VGND VPWR VPWR _04100_ sky130_fd_sc_hd__a21o_1
X_13070_ clknet_leaf_52_clk _00080_ VGND VGND VPWR VPWR u_interface.fifo_data\[14\]\[23\]
+ sky130_fd_sc_hd__dfxtp_1
X_10282_ _03942_ _04029_ _04030_ VGND VGND VPWR VPWR _04032_ sky130_fd_sc_hd__or3_1
XFILLER_4_3 VPWR VGND VPWR VGND sky130_ef_sc_hd__decap_12
XFILLER_2_245 VGND VGND VPWR VPWR sky130_fd_sc_hd__decap_6
X_12021_ net709 net407 VGND VGND VPWR VPWR _05754_ sky130_fd_sc_hd__nand2_1
XFILLER_2_289 VPWR VGND VPWR VGND sky130_ef_sc_hd__decap_12
Xfanout560 u_interface.u_gelu_fp32.u_fp32_to_q16.s2_shift\[0\] VGND VGND VPWR VPWR
+ net560 sky130_fd_sc_hd__buf_2
Xfanout582 net583 VGND VGND VPWR VPWR net582 sky130_fd_sc_hd__clkbuf_2
Xfanout571 u_interface.core_data_out\[26\] VGND VGND VPWR VPWR net571 sky130_fd_sc_hd__clkbuf_2
Xfanout593 u_interface.u_gelu_fp32.u_synth_top.s2_m\[1\] VGND VGND VPWR VPWR net593
+ sky130_fd_sc_hd__buf_2
X_13972_ clknet_leaf_84_clk net1700 VGND VGND VPWR VPWR u_interface.u_gelu_fp32.u_q16_to_fp32.s2_mag\[17\]
+ sky130_fd_sc_hd__dfxtp_1
XFILLER_59_783 VGND VGND VPWR VPWR sky130_fd_sc_hd__fill_1
X_12923_ u_interface.in_flight_count\[2\] _06438_ VGND VGND VPWR VPWR _06449_ sky130_fd_sc_hd__xnor2_1
XFILLER_132_60 VGND VGND VPWR VPWR sky130_fd_sc_hd__decap_4
XFILLER_74_753 VGND VGND VPWR VPWR sky130_fd_sc_hd__decap_3
XFILLER_73_230 VGND VGND VPWR VPWR sky130_fd_sc_hd__decap_3
XFILLER_46_477 VPWR VGND VPWR VGND sky130_ef_sc_hd__decap_12
XFILLER_18_168 VGND VGND VPWR VPWR sky130_fd_sc_hd__decap_8
X_12854_ net1462 u_interface.u_gelu_fp32.u_fp32_to_q16.s2_norm_mag\[9\] net817 VGND
+ VGND VPWR VPWR _00998_ sky130_fd_sc_hd__mux2_1
XFILLER_132_93 VGND VGND VPWR VPWR sky130_fd_sc_hd__fill_1
XFILLER_92_97 VGND VGND VPWR VPWR sky130_fd_sc_hd__fill_2
X_12785_ u_interface.u_gelu_fp32.u_q16_to_fp32.s3_norm_mag\[20\] u_interface.u_gelu_fp32.u_q16_to_fp32.s3_norm_mag\[19\]
+ _01782_ u_interface.u_gelu_fp32.u_q16_to_fp32.s3_norm_mag\[21\] VGND VGND VPWR VPWR
+ _06409_ sky130_fd_sc_hd__a31o_1
XFILLER_15_853 VPWR VGND VPWR VGND sky130_ef_sc_hd__decap_12
X_11805_ _05436_ _05437_ _05455_ _05454_ _05453_ VGND VGND VPWR VPWR _05541_ sky130_fd_sc_hd__o32a_1
X_11736_ _05315_ _05391_ _05390_ VGND VGND VPWR VPWR _05473_ sky130_fd_sc_hd__a21oi_1
XFILLER_14_341 VGND VGND VPWR VPWR sky130_fd_sc_hd__fill_1
XFILLER_15_897 VPWR VGND VPWR VGND sky130_ef_sc_hd__decap_12
XTAP_TAPCELL_ROW_12_520 VGND VPWR sky130_fd_sc_hd__tapvpwrvgnd_1
XTAP_TAPCELL_ROW_12_531 VGND VPWR sky130_fd_sc_hd__tapvpwrvgnd_1
XFILLER_30_867 VGND VGND VPWR VPWR sky130_fd_sc_hd__fill_1
X_11667_ net184 _05403_ VGND VGND VPWR VPWR _05404_ sky130_fd_sc_hd__xor2_1
X_13406_ clknet_leaf_34_clk _00416_ VGND VGND VPWR VPWR u_interface.fifo_data\[6\]\[19\]
+ sky130_fd_sc_hd__dfxtp_1
X_10618_ _04364_ VGND VGND VPWR VPWR _04365_ sky130_fd_sc_hd__inv_2
X_11598_ _05241_ _05244_ VGND VGND VPWR VPWR _05336_ sky130_fd_sc_hd__nand2b_1
XFILLER_128_777 VGND VGND VPWR VPWR sky130_fd_sc_hd__fill_2
XFILLER_127_243 VGND VGND VPWR VPWR sky130_fd_sc_hd__fill_1
X_13337_ clknet_leaf_43_clk _00347_ VGND VGND VPWR VPWR u_interface.fifo_data\[10\]\[14\]
+ sky130_fd_sc_hd__dfxtp_1
X_10549_ _04173_ _04294_ _04295_ VGND VGND VPWR VPWR _04297_ sky130_fd_sc_hd__nand3_2
XFILLER_115_449 VGND VGND VPWR VPWR sky130_fd_sc_hd__fill_1
XTAP_TAPCELL_ROW_77_1569 VGND VPWR sky130_fd_sc_hd__tapvpwrvgnd_1
X_13268_ clknet_leaf_40_clk _00278_ VGND VGND VPWR VPWR u_interface.fifo_data\[0\]\[10\]
+ sky130_fd_sc_hd__dfxtp_1
XFILLER_123_471 VGND VGND VPWR VPWR sky130_fd_sc_hd__fill_1
XFILLER_97_823 VGND VGND VPWR VPWR sky130_fd_sc_hd__fill_1
X_13199_ clknet_leaf_71_clk _00209_ VGND VGND VPWR VPWR u_interface.fifo_data\[12\]\[9\]
+ sky130_fd_sc_hd__dfxtp_1
X_12219_ net203 _05884_ _05887_ VGND VGND VPWR VPWR _05949_ sky130_fd_sc_hd__and3_1
XFILLER_37_3 VPWR VGND VPWR VGND sky130_ef_sc_hd__decap_12
XPHY_EDGE_ROW_102_Left_258 VGND VGND VPWR VPWR sky130_fd_sc_hd__decap_3
XFILLER_96_333 VPWR VGND VPWR VGND sky130_ef_sc_hd__decap_12
XTAP_TAPCELL_ROW_90_1769 VGND VPWR sky130_fd_sc_hd__tapvpwrvgnd_1
XFILLER_111_666 VGND VGND VPWR VPWR sky130_fd_sc_hd__decap_6
X_07760_ u_interface.u_gelu_fp32.u_q16_to_fp32.s3_exp\[4\] _01798_ VGND VGND VPWR
+ VPWR _01800_ sky130_fd_sc_hd__or2_1
XFILLER_56_219 VPWR VGND VPWR VGND sky130_ef_sc_hd__decap_12
X_06711_ net736 _01275_ VGND VGND VPWR VPWR _01276_ sky130_fd_sc_hd__or2_1
XTAP_TAPCELL_ROW_108_2057 VGND VPWR sky130_fd_sc_hd__tapvpwrvgnd_1
X_09430_ _02680_ _02683_ VGND VGND VPWR VPWR _03188_ sky130_fd_sc_hd__nand2_1
XTAP_TAPCELL_ROW_108_2068 VGND VPWR sky130_fd_sc_hd__tapvpwrvgnd_1
X_07691_ net1719 u_interface.u_gelu_fp32.u_synth_top.s1_hits\[6\] _00490_ VGND VGND
+ VPWR VPWR _00494_ sky130_fd_sc_hd__or3_1
XFILLER_80_701 VPWR VGND VPWR VGND sky130_ef_sc_hd__decap_12
XFILLER_65_764 VGND VGND VPWR VPWR sky130_fd_sc_hd__fill_1
X_06642_ u_interface.fifo_data\[4\]\[1\] u_interface.fifo_data\[5\]\[1\] u_interface.fifo_data\[6\]\[1\]
+ u_interface.fifo_data\[7\]\[1\] net763 net746 VGND VGND VPWR VPWR _01216_ sky130_fd_sc_hd__mux4_1
XFILLER_64_274 VGND VGND VPWR VPWR sky130_fd_sc_hd__fill_1
XFILLER_25_617 VPWR VGND VPWR VGND sky130_ef_sc_hd__decap_12
XFILLER_37_477 VPWR VGND VPWR VGND sky130_ef_sc_hd__decap_12
X_09361_ _03113_ _03118_ VGND VGND VPWR VPWR _03120_ sky130_fd_sc_hd__nand2b_1
XTAP_TAPCELL_ROW_121_2279 VGND VPWR sky130_fd_sc_hd__tapvpwrvgnd_1
XTAP_TAPCELL_ROW_121_2268 VGND VPWR sky130_fd_sc_hd__tapvpwrvgnd_1
X_06573_ _01150_ _01164_ _01163_ net535 VGND VGND VPWR VPWR _01165_ sky130_fd_sc_hd__o2bb2a_1
XFILLER_24_149 VGND VGND VPWR VPWR sky130_fd_sc_hd__fill_1
X_09292_ _03017_ _03045_ _03050_ VGND VGND VPWR VPWR _03051_ sky130_fd_sc_hd__nand3_1
XPHY_EDGE_ROW_111_Left_267 VGND VGND VPWR VPWR sky130_fd_sc_hd__decap_3
X_08312_ net530 _02116_ net1637 VGND VGND VPWR VPWR _02117_ sky130_fd_sc_hd__a21oi_1
X_08243_ net166 _02068_ net315 net290 VGND VGND VPWR VPWR _00741_ sky130_fd_sc_hd__a211oi_1
XTAP_TAPCELL_ROW_103_1990 VGND VPWR sky130_fd_sc_hd__tapvpwrvgnd_1
XANTENNA_12 net118 VGND VGND VPWR VPWR sky130_fd_sc_hd__diode_2
XFILLER_21_889 VGND VGND VPWR VPWR sky130_fd_sc_hd__decap_6
XFILLER_146_541 VPWR VGND VPWR VGND sky130_ef_sc_hd__decap_12
X_08174_ net539 _02010_ VGND VGND VPWR VPWR _02011_ sky130_fd_sc_hd__nand2_1
XFILLER_21_27 VPWR VGND VPWR VGND sky130_ef_sc_hd__decap_12
X_07125_ net991 net324 net227 VGND VGND VPWR VPWR _00165_ sky130_fd_sc_hd__mux2_1
XFILLER_106_405 VGND VGND VPWR VPWR sky130_fd_sc_hd__decap_3
XFILLER_146_596 VPWR VGND VPWR VGND sky130_ef_sc_hd__decap_12
XFILLER_133_213 VGND VGND VPWR VPWR sky130_fd_sc_hd__decap_8
X_07056_ net1415 net370 net209 VGND VGND VPWR VPWR _00096_ sky130_fd_sc_hd__mux2_1
XFILLER_118_287 VGND VGND VPWR VPWR sky130_fd_sc_hd__decap_8
Xoutput141 net141 VGND VGND VPWR VPWR m_axis_tlast sky130_fd_sc_hd__buf_2
XFILLER_133_257 VGND VGND VPWR VPWR sky130_fd_sc_hd__decap_3
XPHY_EDGE_ROW_120_Left_276 VGND VGND VPWR VPWR sky130_fd_sc_hd__decap_3
Xoutput130 net130 VGND VGND VPWR VPWR m_axis_tdata[29] sky130_fd_sc_hd__buf_2
XFILLER_153_15 VPWR VGND VPWR VGND sky130_ef_sc_hd__decap_12
XFILLER_99_193 VGND VGND VPWR VPWR sky130_fd_sc_hd__decap_4
XFILLER_88_867 VGND VGND VPWR VPWR sky130_fd_sc_hd__fill_1
XFILLER_87_344 VGND VGND VPWR VPWR sky130_fd_sc_hd__fill_2
XFILLER_75_517 VPWR VGND VPWR VGND sky130_ef_sc_hd__decap_12
X_07958_ net815 net1782 net300 _01667_ VGND VGND VPWR VPWR _01841_ sky130_fd_sc_hd__a22o_1
XFILLER_56_742 VGND VGND VPWR VPWR sky130_fd_sc_hd__decap_4
XFILLER_56_720 VGND VGND VPWR VPWR sky130_fd_sc_hd__decap_4
XFILLER_28_400 VGND VGND VPWR VPWR sky130_fd_sc_hd__decap_8
X_07889_ net1346 net577 net268 VGND VGND VPWR VPWR _00650_ sky130_fd_sc_hd__mux2_1
X_06909_ _01447_ _01448_ VGND VGND VPWR VPWR _01449_ sky130_fd_sc_hd__and2b_1
XFILLER_83_561 VPWR VGND VPWR VGND sky130_ef_sc_hd__decap_12
XTAP_TAPCELL_ROW_48_1104 VGND VPWR sky130_fd_sc_hd__tapvpwrvgnd_1
XFILLER_46_68 VGND VGND VPWR VPWR sky130_fd_sc_hd__decap_6
XFILLER_28_466 VGND VGND VPWR VPWR sky130_fd_sc_hd__decap_8
XTAP_TAPCELL_ROW_39_962 VGND VPWR sky130_fd_sc_hd__tapvpwrvgnd_1
X_09628_ net490 net495 net680 net689 VGND VGND VPWR VPWR _03384_ sky130_fd_sc_hd__nand4_2
XFILLER_15_105 VGND VGND VPWR VPWR sky130_fd_sc_hd__decap_6
X_09559_ _03314_ _03315_ _03225_ VGND VGND VPWR VPWR _03316_ sky130_fd_sc_hd__a21bo_1
XFILLER_43_447 VGND VGND VPWR VPWR sky130_fd_sc_hd__fill_1
XFILLER_43_436 VGND VGND VPWR VPWR sky130_fd_sc_hd__decap_8
XFILLER_15_149 VPWR VGND VPWR VGND sky130_ef_sc_hd__decap_12
XFILLER_102_85 VGND VGND VPWR VPWR sky130_fd_sc_hd__fill_1
X_12570_ net784 net1752 VGND VGND VPWR VPWR _00868_ sky130_fd_sc_hd__and2_1
XTAP_TAPCELL_ROW_61_1315 VGND VPWR sky130_fd_sc_hd__tapvpwrvgnd_1
XTAP_TAPCELL_ROW_61_1304 VGND VPWR sky130_fd_sc_hd__tapvpwrvgnd_1
XFILLER_62_78 VGND VGND VPWR VPWR sky130_fd_sc_hd__decap_6
XFILLER_8_805 VGND VGND VPWR VPWR sky130_fd_sc_hd__decap_6
XFILLER_12_867 VGND VGND VPWR VPWR sky130_fd_sc_hd__fill_1
XFILLER_23_193 VPWR VGND VPWR VGND sky130_ef_sc_hd__decap_12
X_11521_ net685 net421 _05257_ _05258_ VGND VGND VPWR VPWR _05260_ sky130_fd_sc_hd__nand4_2
XFILLER_11_377 VGND VGND VPWR VPWR sky130_fd_sc_hd__fill_1
XFILLER_8_849 VPWR VGND VPWR VGND sky130_ef_sc_hd__decap_12
X_11452_ _05073_ _05074_ _05093_ _05092_ _05091_ VGND VGND VPWR VPWR _05192_ sky130_fd_sc_hd__o32a_1
X_10403_ _04142_ _04150_ VGND VGND VPWR VPWR _04152_ sky130_fd_sc_hd__xnor2_1
X_11383_ net184 _05027_ _05026_ VGND VGND VPWR VPWR _05123_ sky130_fd_sc_hd__a21o_1
X_14171_ clknet_leaf_76_clk _01097_ VGND VGND VPWR VPWR u_interface.fifo_data\[1\]\[31\]
+ sky130_fd_sc_hd__dfxtp_1
X_13122_ clknet_leaf_54_clk _00132_ VGND VGND VPWR VPWR u_interface.fifo_data\[2\]\[11\]
+ sky130_fd_sc_hd__dfxtp_1
X_10334_ _04082_ _04083_ VGND VGND VPWR VPWR _00817_ sky130_fd_sc_hd__nor2_1
XFILLER_152_544 VGND VGND VPWR VPWR sky130_fd_sc_hd__decap_8
XTAP_TAPCELL_ROW_59_1277 VGND VPWR sky130_fd_sc_hd__tapvpwrvgnd_1
XFILLER_11_93 VPWR VGND VPWR VGND sky130_ef_sc_hd__decap_12
XFILLER_121_920 VGND VGND VPWR VPWR sky130_fd_sc_hd__fill_1
XFILLER_97_119 VGND VGND VPWR VPWR sky130_fd_sc_hd__decap_4
X_10265_ _04004_ _04014_ VGND VGND VPWR VPWR _04015_ sky130_fd_sc_hd__xnor2_1
X_13053_ clknet_leaf_75_clk _00063_ VGND VGND VPWR VPWR u_interface.fifo_data\[14\]\[6\]
+ sky130_fd_sc_hd__dfxtp_1
X_10196_ _03802_ _03945_ VGND VGND VPWR VPWR _03947_ sky130_fd_sc_hd__xor2_1
XFILLER_78_333 VGND VGND VPWR VPWR sky130_fd_sc_hd__fill_2
X_12004_ net204 _05735_ VGND VGND VPWR VPWR _05737_ sky130_fd_sc_hd__xor2_1
XTAP_TAPCELL_ROW_72_1488 VGND VPWR sky130_fd_sc_hd__tapvpwrvgnd_1
XFILLER_143_81 VPWR VGND VPWR VGND sky130_ef_sc_hd__decap_12
XFILLER_59_591 VGND VGND VPWR VPWR sky130_fd_sc_hd__fill_1
Xfanout390 net391 VGND VGND VPWR VPWR net390 sky130_fd_sc_hd__buf_2
X_13955_ clknet_leaf_54_clk net938 VGND VGND VPWR VPWR u_interface.u_gelu_fp32.u_q16_to_fp32.s2_mag\[0\]
+ sky130_fd_sc_hd__dfxtp_1
X_12906_ _01101_ _01508_ net827 VGND VGND VPWR VPWR _06436_ sky130_fd_sc_hd__a21o_1
X_13886_ clknet_leaf_0_clk _00039_ VGND VGND VPWR VPWR u_interface.u_gelu_fp32.u_synth_top.s2_dx\[22\]
+ sky130_fd_sc_hd__dfxtp_1
XTAP_TAPCELL_ROW_17_601 VGND VPWR sky130_fd_sc_hd__tapvpwrvgnd_1
XTAP_TAPCELL_ROW_17_612 VGND VPWR sky130_fd_sc_hd__tapvpwrvgnd_1
XFILLER_34_403 VGND VGND VPWR VPWR sky130_fd_sc_hd__decap_4
XFILLER_34_414 VGND VGND VPWR VPWR sky130_fd_sc_hd__decap_6
XFILLER_34_425 VPWR VGND VPWR VGND sky130_ef_sc_hd__decap_12
X_12837_ net55 net54 net57 net56 VGND VGND VPWR VPWR _06419_ sky130_fd_sc_hd__or4_1
XFILLER_61_222 VGND VGND VPWR VPWR sky130_fd_sc_hd__fill_2
XFILLER_34_469 VGND VGND VPWR VPWR sky130_fd_sc_hd__decap_6
X_12768_ _01778_ _06400_ VGND VGND VPWR VPWR _00944_ sky130_fd_sc_hd__nor2_1
X_12699_ _06356_ _06349_ _06341_ _01745_ net335 net328 VGND VGND VPWR VPWR _06357_
+ sky130_fd_sc_hd__mux4_1
XFILLER_14_193 VGND VGND VPWR VPWR sky130_fd_sc_hd__decap_3
X_11719_ _05438_ _05455_ VGND VGND VPWR VPWR _05456_ sky130_fd_sc_hd__xor2_1
Xinput21 s_axil_araddr[26] VGND VGND VPWR VPWR net21 sky130_fd_sc_hd__clkbuf_1
Xinput10 s_axil_araddr[16] VGND VGND VPWR VPWR net10 sky130_fd_sc_hd__clkbuf_1
Xinput43 s_axil_awaddr[16] VGND VGND VPWR VPWR net43 sky130_fd_sc_hd__clkbuf_1
Xinput32 s_axil_araddr[7] VGND VGND VPWR VPWR net32 sky130_fd_sc_hd__clkbuf_1
Xinput54 s_axil_awaddr[26] VGND VGND VPWR VPWR net54 sky130_fd_sc_hd__clkbuf_2
XFILLER_128_541 VGND VGND VPWR VPWR sky130_fd_sc_hd__decap_3
Xinput65 s_axil_awaddr[7] VGND VGND VPWR VPWR net65 sky130_fd_sc_hd__clkbuf_1
Xhold816 _01021_ VGND VGND VPWR VPWR net1681 sky130_fd_sc_hd__dlygate4sd3_1
XFILLER_155_393 VGND VGND VPWR VPWR sky130_fd_sc_hd__fill_2
Xinput98 s_axis_tdata[31] VGND VGND VPWR VPWR net98 sky130_fd_sc_hd__clkbuf_1
Xinput87 s_axis_tdata[21] VGND VGND VPWR VPWR net87 sky130_fd_sc_hd__clkbuf_1
Xinput76 s_axis_tdata[11] VGND VGND VPWR VPWR net76 sky130_fd_sc_hd__clkbuf_1
Xhold805 u_interface.u_gelu_fp32.u_fp32_to_q16.s3_mag\[2\] VGND VGND VPWR VPWR net1670
+ sky130_fd_sc_hd__dlygate4sd3_1
XFILLER_116_747 VGND VGND VPWR VPWR sky130_fd_sc_hd__decap_8
XTAP_TAPCELL_ROW_92_1809 VGND VPWR sky130_fd_sc_hd__tapvpwrvgnd_1
Xhold827 u_interface.u_gelu_fp32.u_q16_to_fp32.s1_mag\[22\] VGND VGND VPWR VPWR net1692
+ sky130_fd_sc_hd__dlygate4sd3_1
Xhold849 u_interface.u_gelu_fp32.u_q16_to_fp32.s3_exp\[7\] VGND VGND VPWR VPWR net1714
+ sky130_fd_sc_hd__dlygate4sd3_1
Xhold838 u_interface.u_gelu_fp32.u_q16_to_fp32.s3_norm_mag\[10\] VGND VGND VPWR VPWR
+ net1703 sky130_fd_sc_hd__dlygate4sd3_1
XFILLER_143_599 VGND VGND VPWR VPWR sky130_fd_sc_hd__fill_1
X_08930_ _02677_ _02686_ _02687_ VGND VGND VPWR VPWR _02689_ sky130_fd_sc_hd__and3_1
X_08861_ net458 net589 VGND VGND VPWR VPWR _02620_ sky130_fd_sc_hd__nand2_1
XFILLER_97_642 VGND VGND VPWR VPWR sky130_fd_sc_hd__decap_4
X_07812_ net1372 net364 net231 VGND VGND VPWR VPWR _00573_ sky130_fd_sc_hd__mux2_1
XFILLER_96_141 VGND VGND VPWR VPWR sky130_fd_sc_hd__decap_6
XFILLER_85_815 VGND VGND VPWR VPWR sky130_fd_sc_hd__decap_4
XFILLER_84_303 VGND VGND VPWR VPWR sky130_fd_sc_hd__decap_4
X_08792_ _02463_ _02470_ VGND VGND VPWR VPWR _02551_ sky130_fd_sc_hd__xnor2_1
XFILLER_111_496 VGND VGND VPWR VPWR sky130_fd_sc_hd__decap_8
XFILLER_57_539 VGND VGND VPWR VPWR sky130_fd_sc_hd__fill_1
XTAP_TAPCELL_ROW_123_2308 VGND VPWR sky130_fd_sc_hd__tapvpwrvgnd_1
X_07743_ u_interface.u_gelu_fp32.u_q16_to_fp32.s3_norm_mag\[25\] _01786_ VGND VGND
+ VPWR VPWR _01787_ sky130_fd_sc_hd__and2_1
XFILLER_72_509 VGND VGND VPWR VPWR sky130_fd_sc_hd__fill_1
X_07674_ u_interface.u_gelu_fp32.u_synth_top.s1_hits\[17\] u_interface.u_gelu_fp32.u_synth_top.s1_hits\[16\]
+ VGND VGND VPWR VPWR _01753_ sky130_fd_sc_hd__or2_1
XTAP_TAPCELL_ROW_36_910 VGND VPWR sky130_fd_sc_hd__tapvpwrvgnd_1
X_06625_ u_interface.fifo_tlast\[0\] u_interface.fifo_tlast\[1\] u_interface.fifo_tlast\[2\]
+ u_interface.fifo_tlast\[3\] net767 net750 VGND VGND VPWR VPWR _01201_ sky130_fd_sc_hd__mux4_1
X_09413_ net515 net519 net723 VGND VGND VPWR VPWR _03171_ sky130_fd_sc_hd__and3_4
XFILLER_16_27 VGND VGND VPWR VPWR sky130_fd_sc_hd__fill_1
XFILLER_53_789 VGND VGND VPWR VPWR sky130_fd_sc_hd__fill_1
XFILLER_13_609 VGND VGND VPWR VPWR sky130_fd_sc_hd__decap_6
X_09344_ net591 net513 _03102_ _03099_ VGND VGND VPWR VPWR _03103_ sky130_fd_sc_hd__a31o_1
XTAP_TAPCELL_ROW_101_1949 VGND VPWR sky130_fd_sc_hd__tapvpwrvgnd_1
X_06556_ net535 _01149_ VGND VGND VPWR VPWR _01151_ sky130_fd_sc_hd__nor2_1
XFILLER_80_597 VPWR VGND VPWR VGND sky130_ef_sc_hd__decap_12
XTAP_TAPCELL_ROW_43_1023 VGND VPWR sky130_fd_sc_hd__tapvpwrvgnd_1
X_09275_ _02985_ _03032_ _03031_ VGND VGND VPWR VPWR _03034_ sky130_fd_sc_hd__o21ai_1
XTAP_TAPCELL_ROW_138_2551 VGND VPWR sky130_fd_sc_hd__tapvpwrvgnd_1
XFILLER_139_839 VGND VGND VPWR VPWR sky130_fd_sc_hd__fill_1
XFILLER_139_817 VGND VGND VPWR VPWR sky130_fd_sc_hd__fill_1
XTAP_TAPCELL_ROW_138_2540 VGND VPWR sky130_fd_sc_hd__tapvpwrvgnd_1
XFILLER_20_141 VPWR VGND VPWR VGND sky130_ef_sc_hd__decap_12
XFILLER_21_653 VPWR VGND VPWR VGND sky130_ef_sc_hd__decap_12
XFILLER_32_26 VGND VGND VPWR VPWR sky130_fd_sc_hd__fill_2
XFILLER_148_15 VPWR VGND VPWR VGND sky130_ef_sc_hd__decap_12
X_08226_ _02053_ _02054_ VGND VGND VPWR VPWR _02055_ sky130_fd_sc_hd__xnor2_1
XFILLER_21_697 VPWR VGND VPWR VGND sky130_ef_sc_hd__decap_12
X_08157_ net167 _01995_ _01996_ net162 VGND VGND VPWR VPWR _01997_ sky130_fd_sc_hd__a31oi_1
XFILLER_4_307 VGND VGND VPWR VPWR sky130_fd_sc_hd__fill_1
XTAP_TAPCELL_ROW_151_2751 VGND VPWR sky130_fd_sc_hd__tapvpwrvgnd_1
XFILLER_146_393 VPWR VGND VPWR VGND sky130_ef_sc_hd__decap_12
XFILLER_146_371 VPWR VGND VPWR VGND sky130_ef_sc_hd__decap_12
X_07108_ net1162 net569 net226 VGND VGND VPWR VPWR _00148_ sky130_fd_sc_hd__mux2_1
X_08088_ net314 _01937_ _01936_ VGND VGND VPWR VPWR _01939_ sky130_fd_sc_hd__o21ai_1
XFILLER_107_769 VGND VGND VPWR VPWR sky130_fd_sc_hd__decap_6
XFILLER_106_235 VGND VGND VPWR VPWR sky130_fd_sc_hd__decap_3
X_07039_ net1024 net341 net271 VGND VGND VPWR VPWR _00079_ sky130_fd_sc_hd__mux2_1
XFILLER_134_577 VGND VGND VPWR VPWR sky130_fd_sc_hd__decap_8
XFILLER_114_290 VGND VGND VPWR VPWR sky130_fd_sc_hd__decap_8
X_10050_ _03785_ _03800_ _03801_ VGND VGND VPWR VPWR _03802_ sky130_fd_sc_hd__or3_1
XFILLER_87_130 VPWR VGND VPWR VGND sky130_ef_sc_hd__decap_12
XTAP_TAPCELL_ROW_54_1196 VGND VPWR sky130_fd_sc_hd__tapvpwrvgnd_1
XFILLER_0_557 VGND VGND VPWR VPWR sky130_fd_sc_hd__decap_3
XFILLER_113_40 VGND VGND VPWR VPWR sky130_fd_sc_hd__decap_3
XFILLER_28_241 VGND VGND VPWR VPWR sky130_fd_sc_hd__decap_8
XFILLER_29_753 VPWR VGND VPWR VGND sky130_ef_sc_hd__decap_12
X_13740_ clknet_leaf_57_clk _00750_ VGND VGND VPWR VPWR u_interface.u_gelu_fp32.u_q16_to_fp32.s1_mag\[6\]
+ sky130_fd_sc_hd__dfxtp_1
X_10952_ _04675_ _04694_ VGND VGND VPWR VPWR _04696_ sky130_fd_sc_hd__xor2_1
XTAP_TAPCELL_ROW_3_384 VGND VPWR sky130_fd_sc_hd__tapvpwrvgnd_1
XFILLER_29_797 VPWR VGND VPWR VGND sky130_ef_sc_hd__decap_12
XFILLER_43_200 VGND VGND VPWR VPWR sky130_fd_sc_hd__fill_2
XFILLER_73_55 VGND VGND VPWR VPWR sky130_fd_sc_hd__fill_1
XFILLER_44_745 VGND VGND VPWR VPWR sky130_fd_sc_hd__fill_2
X_13671_ clknet_leaf_18_clk _00681_ VGND VGND VPWR VPWR u_interface.u_gelu_fp32.u_fp32_to_q16.s2_sign
+ sky130_fd_sc_hd__dfxtp_1
X_10883_ net611 net408 VGND VGND VPWR VPWR _04628_ sky130_fd_sc_hd__nand2_1
X_12622_ u_interface.u_gelu_fp32.u_q16_to_fp32.s1_mag\[10\] net212 net186 _06324_
+ u_interface.u_gelu_fp32.u_q16_to_fp32.s1_mag\[26\] VGND VGND VPWR VPWR _06325_ sky130_fd_sc_hd__a221o_1
XFILLER_24_480 VGND VGND VPWR VPWR sky130_fd_sc_hd__decap_8
XFILLER_8_613 VPWR VGND VPWR VGND sky130_ef_sc_hd__decap_12
X_12553_ net191 _06273_ VGND VGND VPWR VPWR _06277_ sky130_fd_sc_hd__xnor2_1
X_11504_ net711 net435 VGND VGND VPWR VPWR _05243_ sky130_fd_sc_hd__nand2_1
XFILLER_8_657 VPWR VGND VPWR VGND sky130_ef_sc_hd__decap_12
X_12484_ _06208_ _06209_ VGND VGND VPWR VPWR _06210_ sky130_fd_sc_hd__and2_1
XTAP_TAPCELL_ROW_22_681 VGND VPWR sky130_fd_sc_hd__tapvpwrvgnd_1
XTAP_TAPCELL_ROW_22_692 VGND VPWR sky130_fd_sc_hd__tapvpwrvgnd_1
XFILLER_7_167 VGND VGND VPWR VPWR sky130_fd_sc_hd__fill_1
X_11435_ _05173_ _05174_ VGND VGND VPWR VPWR _05175_ sky130_fd_sc_hd__nor2_1
XFILLER_153_875 VPWR VGND VPWR VGND sky130_ef_sc_hd__decap_12
X_14154_ clknet_leaf_43_clk _01080_ VGND VGND VPWR VPWR u_interface.fifo_data\[1\]\[14\]
+ sky130_fd_sc_hd__dfxtp_1
XTAP_TAPCELL_ROW_74_1517 VGND VPWR sky130_fd_sc_hd__tapvpwrvgnd_1
X_11366_ _04925_ _05006_ _05007_ VGND VGND VPWR VPWR _05107_ sky130_fd_sc_hd__o21a_1
X_14085_ clknet_leaf_17_clk net1334 VGND VGND VPWR VPWR u_interface.u_gelu_fp32.u_fp32_to_q16.s2_norm_mag\[22\]
+ sky130_fd_sc_hd__dfxtp_1
X_13105_ clknet_leaf_41_clk _00115_ VGND VGND VPWR VPWR u_interface.fifo_data\[15\]\[26\]
+ sky130_fd_sc_hd__dfxtp_1
XFILLER_125_577 VGND VGND VPWR VPWR sky130_fd_sc_hd__fill_1
XFILLER_98_85 VGND VGND VPWR VPWR sky130_fd_sc_hd__fill_1
XFILLER_98_74 VGND VGND VPWR VPWR sky130_fd_sc_hd__decap_3
X_10317_ _03996_ _03997_ _04065_ _04066_ VGND VGND VPWR VPWR _04067_ sky130_fd_sc_hd__a22o_1
X_11297_ _05035_ _05036_ VGND VGND VPWR VPWR _05038_ sky130_fd_sc_hd__xnor2_1
X_13036_ clknet_leaf_40_clk _00046_ VGND VGND VPWR VPWR u_interface.fifo_tuser\[0\]
+ sky130_fd_sc_hd__dfxtp_1
X_10248_ _03916_ _03918_ VGND VGND VPWR VPWR _03998_ sky130_fd_sc_hd__nand2b_1
XFILLER_3_373 VPWR VGND VPWR VGND sky130_ef_sc_hd__decap_12
XFILLER_94_601 VGND VGND VPWR VPWR sky130_fd_sc_hd__decap_4
XFILLER_79_664 VGND VGND VPWR VPWR sky130_fd_sc_hd__fill_1
XFILLER_94_645 VGND VGND VPWR VPWR sky130_fd_sc_hd__decap_6
X_10179_ _03926_ _03929_ VGND VGND VPWR VPWR _03930_ sky130_fd_sc_hd__xnor2_1
XFILLER_66_336 VGND VGND VPWR VPWR sky130_fd_sc_hd__decap_4
XTAP_TAPCELL_ROW_89_1760 VGND VPWR sky130_fd_sc_hd__tapvpwrvgnd_1
XTAP_TAPCELL_ROW_105_2016 VGND VPWR sky130_fd_sc_hd__tapvpwrvgnd_1
X_13938_ clknet_leaf_3_clk _00005_ VGND VGND VPWR VPWR u_interface.u_gelu_fp32.u_synth_top.s1_hits\[10\]
+ sky130_fd_sc_hd__dfxtp_1
XFILLER_75_881 VGND VGND VPWR VPWR sky130_fd_sc_hd__decap_6
XFILLER_62_520 VGND VGND VPWR VPWR sky130_fd_sc_hd__decap_8
XFILLER_19_285 VGND VGND VPWR VPWR sky130_fd_sc_hd__fill_1
X_13869_ clknet_leaf_22_clk net871 VGND VGND VPWR VPWR u_interface.u_gelu_fp32.u_synth_top.s2_dx\[5\]
+ sky130_fd_sc_hd__dfxtp_1
XFILLER_35_778 VGND VGND VPWR VPWR sky130_fd_sc_hd__decap_6
X_07390_ net1240 net577 net240 VGND VGND VPWR VPWR _00420_ sky130_fd_sc_hd__mux2_1
XFILLER_34_288 VPWR VGND VPWR VGND sky130_ef_sc_hd__decap_12
XFILLER_147_113 VGND VGND VPWR VPWR sky130_fd_sc_hd__decap_4
X_09060_ _02806_ _02807_ _02802_ VGND VGND VPWR VPWR _02819_ sky130_fd_sc_hd__o21a_1
XFILLER_147_146 VGND VGND VPWR VPWR sky130_fd_sc_hd__fill_1
X_08011_ net930 u_interface.u_gelu_fp32.u_fp32_to_q16.s3_overflow net813 VGND VGND
+ VPWR VPWR _00706_ sky130_fd_sc_hd__mux2_1
XFILLER_8_83 VGND VGND VPWR VPWR sky130_fd_sc_hd__fill_1
XTAP_TAPCELL_ROW_41_990 VGND VPWR sky130_fd_sc_hd__tapvpwrvgnd_1
XFILLER_129_894 VGND VGND VPWR VPWR sky130_fd_sc_hd__fill_2
XFILLER_118_29 VGND VGND VPWR VPWR sky130_fd_sc_hd__decap_8
Xhold602 u_interface.fifo_data\[7\]\[21\] VGND VGND VPWR VPWR net1467 sky130_fd_sc_hd__dlygate4sd3_1
Xhold624 u_interface.u_gelu_fp32.u_fp32_to_q16.s1_mant\[12\] VGND VGND VPWR VPWR net1489
+ sky130_fd_sc_hd__dlygate4sd3_1
XTAP_TAPCELL_ROW_133_2470 VGND VPWR sky130_fd_sc_hd__tapvpwrvgnd_1
Xhold613 u_interface.u_gelu_fp32.u_fp32_to_q16.s3_frac\[12\] VGND VGND VPWR VPWR net1478
+ sky130_fd_sc_hd__dlygate4sd3_1
XFILLER_116_533 VPWR VGND VPWR VGND sky130_ef_sc_hd__decap_12
XTAP_TAPCELL_ROW_116_2189 VGND VPWR sky130_fd_sc_hd__tapvpwrvgnd_1
Xhold635 u_interface.u_gelu_fp32.u_q16_to_fp32.s1_mag\[24\] VGND VGND VPWR VPWR net1500
+ sky130_fd_sc_hd__dlygate4sd3_1
Xhold646 u_interface.fifo_data\[7\]\[7\] VGND VGND VPWR VPWR net1511 sky130_fd_sc_hd__dlygate4sd3_1
XFILLER_116_577 VGND VGND VPWR VPWR sky130_fd_sc_hd__decap_8
Xhold679 u_interface.fifo_data\[12\]\[11\] VGND VGND VPWR VPWR net1544 sky130_fd_sc_hd__dlygate4sd3_1
XFILLER_103_216 VGND VGND VPWR VPWR sky130_fd_sc_hd__decap_8
X_09962_ _03712_ _03713_ _03714_ VGND VGND VPWR VPWR _03715_ sky130_fd_sc_hd__a21oi_1
Xhold668 u_interface.fifo_data\[11\]\[25\] VGND VGND VPWR VPWR net1533 sky130_fd_sc_hd__dlygate4sd3_1
Xhold657 u_interface.fifo_data\[3\]\[9\] VGND VGND VPWR VPWR net1522 sky130_fd_sc_hd__dlygate4sd3_1
X_08913_ _02442_ _02453_ _02452_ VGND VGND VPWR VPWR _02672_ sky130_fd_sc_hd__a21oi_1
X_09893_ _03644_ _03645_ _03634_ VGND VGND VPWR VPWR _03646_ sky130_fd_sc_hd__a21oi_1
X_08844_ net639 net484 VGND VGND VPWR VPWR _02603_ sky130_fd_sc_hd__nand2_1
X_08775_ _02531_ _02532_ _02526_ VGND VGND VPWR VPWR _02534_ sky130_fd_sc_hd__a21o_1
XFILLER_85_656 VGND VGND VPWR VPWR sky130_fd_sc_hd__decap_3
XFILLER_57_369 VGND VGND VPWR VPWR sky130_fd_sc_hd__decap_8
XFILLER_45_509 VGND VGND VPWR VPWR sky130_fd_sc_hd__decap_8
XFILLER_27_15 VPWR VGND VPWR VGND sky130_ef_sc_hd__decap_12
XFILLER_150_27 VGND VGND VPWR VPWR sky130_fd_sc_hd__fill_1
X_07726_ _01188_ _01753_ _01764_ _01773_ VGND VGND VPWR VPWR _00518_ sky130_fd_sc_hd__or4_1
XTAP_TAPCELL_ROW_0_321 VGND VPWR sky130_fd_sc_hd__tapvpwrvgnd_1
XFILLER_26_701 VPWR VGND VPWR VGND sky130_ef_sc_hd__decap_12
XTAP_TAPCELL_ROW_0_332 VGND VPWR sky130_fd_sc_hd__tapvpwrvgnd_1
XTAP_TAPCELL_ROW_0_343 VGND VPWR sky130_fd_sc_hd__tapvpwrvgnd_1
XFILLER_25_233 VGND VGND VPWR VPWR sky130_fd_sc_hd__decap_3
X_07657_ net307 _01740_ _01738_ VGND VGND VPWR VPWR _01741_ sky130_fd_sc_hd__a21o_1
X_07588_ net810 net1780 net302 _01690_ VGND VGND VPWR VPWR _00463_ sky130_fd_sc_hd__a22o_1
X_06608_ u_interface.u_gelu_fp32.u_synth_top.s1_hits\[2\] u_interface.u_gelu_fp32.u_synth_top.s1_hits\[1\]
+ VGND VGND VPWR VPWR _01186_ sky130_fd_sc_hd__or2_2
XFILLER_80_394 VGND VGND VPWR VPWR sky130_fd_sc_hd__fill_1
X_09327_ _03084_ _03085_ VGND VGND VPWR VPWR _03086_ sky130_fd_sc_hd__nand2_1
X_06539_ _01134_ _01135_ VGND VGND VPWR VPWR _01136_ sky130_fd_sc_hd__or2_1
XFILLER_21_461 VGND VGND VPWR VPWR sky130_fd_sc_hd__fill_2
XFILLER_154_617 VPWR VGND VPWR VGND sky130_ef_sc_hd__decap_12
X_09258_ _03014_ _03015_ _03016_ VGND VGND VPWR VPWR _03017_ sky130_fd_sc_hd__or3_1
X_09189_ _02904_ _02918_ _02946_ VGND VGND VPWR VPWR _02948_ sky130_fd_sc_hd__a21o_1
XFILLER_138_179 VGND VGND VPWR VPWR sky130_fd_sc_hd__decap_8
X_08209_ u_interface.u_gelu_fp32.u_fp32_to_q16.s3_mag\[26\] _01890_ VGND VGND VPWR
+ VPWR _02040_ sky130_fd_sc_hd__nor2_1
XFILLER_119_393 VGND VGND VPWR VPWR sky130_fd_sc_hd__decap_3
XFILLER_104_3 VGND VGND VPWR VPWR sky130_fd_sc_hd__decap_4
X_11220_ _04858_ _04862_ _04961_ VGND VGND VPWR VPWR _04962_ sky130_fd_sc_hd__and3_1
XFILLER_135_897 VGND VGND VPWR VPWR sky130_fd_sc_hd__decap_6
XFILLER_122_503 VGND VGND VPWR VPWR sky130_fd_sc_hd__decap_8
X_11151_ _04696_ _04778_ _04777_ VGND VGND VPWR VPWR _04894_ sky130_fd_sc_hd__o21a_1
XTAP_TAPCELL_ROW_56_1236 VGND VPWR sky130_fd_sc_hd__tapvpwrvgnd_1
XTAP_TAPCELL_ROW_56_1225 VGND VPWR sky130_fd_sc_hd__tapvpwrvgnd_1
XFILLER_107_599 VPWR VGND VPWR VGND sky130_ef_sc_hd__decap_12
X_10102_ _03730_ _03732_ _03850_ _03852_ VGND VGND VPWR VPWR _03854_ sky130_fd_sc_hd__o211a_1
XFILLER_0_321 VPWR VGND VPWR VGND sky130_ef_sc_hd__decap_12
XFILLER_1_833 VGND VGND VPWR VPWR sky130_fd_sc_hd__decap_6
XFILLER_110_709 VGND VGND VPWR VPWR sky130_fd_sc_hd__decap_6
XFILLER_95_409 VGND VGND VPWR VPWR sky130_fd_sc_hd__fill_1
X_11082_ net206 _04824_ VGND VGND VPWR VPWR _04825_ sky130_fd_sc_hd__xnor2_1
XTAP_TAPCELL_ROW_8_465 VGND VPWR sky130_fd_sc_hd__tapvpwrvgnd_1
XFILLER_1_877 VPWR VGND VPWR VGND sky130_ef_sc_hd__decap_12
X_10033_ net581 net422 VGND VGND VPWR VPWR _03785_ sky130_fd_sc_hd__nand2_1
XFILLER_75_111 VGND VGND VPWR VPWR sky130_fd_sc_hd__fill_1
XFILLER_0_365 VPWR VGND VPWR VGND sky130_ef_sc_hd__decap_12
XFILLER_91_615 VGND VGND VPWR VPWR sky130_fd_sc_hd__fill_1
XFILLER_90_103 VPWR VGND VPWR VGND sky130_ef_sc_hd__decap_12
XFILLER_29_550 VGND VGND VPWR VPWR sky130_fd_sc_hd__fill_2
XFILLER_29_561 VGND VGND VPWR VPWR sky130_fd_sc_hd__decap_8
XFILLER_75_199 VPWR VGND VPWR VGND sky130_ef_sc_hd__decap_12
XFILLER_29_583 VPWR VGND VPWR VGND sky130_ef_sc_hd__decap_12
X_11984_ net193 _05717_ VGND VGND VPWR VPWR _05718_ sky130_fd_sc_hd__xnor2_1
X_13723_ clknet_leaf_6_clk _00733_ VGND VGND VPWR VPWR u_interface.u_gelu_fp32.s1_data\[23\]
+ sky130_fd_sc_hd__dfxtp_1
XFILLER_71_361 VGND VGND VPWR VPWR sky130_fd_sc_hd__decap_3
X_10935_ _03658_ _04678_ VGND VGND VPWR VPWR _04679_ sky130_fd_sc_hd__xor2_1
XFILLER_17_81 VPWR VGND VPWR VGND sky130_ef_sc_hd__decap_12
XTAP_TAPCELL_ROW_27_762 VGND VPWR sky130_fd_sc_hd__tapvpwrvgnd_1
X_13654_ clknet_leaf_15_clk _00664_ VGND VGND VPWR VPWR u_interface.u_gelu_fp32.u_fp32_to_q16.s1_exp\[0\]
+ sky130_fd_sc_hd__dfxtp_1
XFILLER_140_71 VGND VGND VPWR VPWR sky130_fd_sc_hd__fill_2
X_10866_ _04608_ _04609_ VGND VGND VPWR VPWR _04611_ sky130_fd_sc_hd__xnor2_1
XFILLER_16_277 VPWR VGND VPWR VGND sky130_ef_sc_hd__decap_12
XTAP_TAPCELL_ROW_27_773 VGND VPWR sky130_fd_sc_hd__tapvpwrvgnd_1
XFILLER_31_225 VPWR VGND VPWR VGND sky130_ef_sc_hd__decap_12
XFILLER_32_737 VPWR VGND VPWR VGND sky130_ef_sc_hd__decap_12
X_12605_ u_interface.u_gelu_fp32.u_q16_to_fp32.s1_mag\[6\] net211 u_interface.u_gelu_fp32.u_q16_to_fp32.s1_mag\[22\]
+ VGND VGND VPWR VPWR _06308_ sky130_fd_sc_hd__a21o_1
X_10797_ _04459_ _04460_ _04540_ _04541_ VGND VGND VPWR VPWR _04543_ sky130_fd_sc_hd__a22oi_2
X_13585_ clknet_leaf_62_clk _00595_ VGND VGND VPWR VPWR u_interface.fifo_data\[3\]\[0\]
+ sky130_fd_sc_hd__dfxtp_1
X_12536_ _06257_ _06258_ VGND VGND VPWR VPWR _06260_ sky130_fd_sc_hd__and2b_1
XFILLER_33_80 VPWR VGND VPWR VGND sky130_ef_sc_hd__decap_12
X_12467_ _06081_ _06191_ VGND VGND VPWR VPWR _06193_ sky130_fd_sc_hd__nor2_1
XPHY_EDGE_ROW_144_Right_144 VGND VGND VPWR VPWR sky130_fd_sc_hd__decap_3
XFILLER_125_341 VGND VGND VPWR VPWR sky130_fd_sc_hd__fill_1
X_11418_ _05071_ _05075_ _05157_ VGND VGND VPWR VPWR _05158_ sky130_fd_sc_hd__and3_1
X_14137_ clknet_leaf_30_clk _01063_ VGND VGND VPWR VPWR u_interface.fifo_count\[4\]
+ sky130_fd_sc_hd__dfxtp_1
X_12398_ net182 _06070_ _06069_ VGND VGND VPWR VPWR _06125_ sky130_fd_sc_hd__a21o_1
XFILLER_141_834 VGND VGND VPWR VPWR sky130_fd_sc_hd__decap_6
XFILLER_99_748 VGND VGND VPWR VPWR sky130_fd_sc_hd__decap_4
XFILLER_4_693 VGND VGND VPWR VPWR sky130_fd_sc_hd__decap_6
XFILLER_3_181 VPWR VGND VPWR VGND sky130_ef_sc_hd__decap_12
X_11349_ _05087_ _05088_ VGND VGND VPWR VPWR _05090_ sky130_fd_sc_hd__xor2_1
X_14068_ clknet_leaf_82_clk _00994_ VGND VGND VPWR VPWR u_interface.u_gelu_fp32.u_q16_to_fp32.s1_is_zero
+ sky130_fd_sc_hd__dfxtp_1
X_06890_ _01110_ _01431_ VGND VGND VPWR VPWR _01433_ sky130_fd_sc_hd__or2_1
XFILLER_79_494 VGND VGND VPWR VPWR sky130_fd_sc_hd__decap_8
X_13019_ net170 net165 net161 net160 net151 VGND VGND VPWR VPWR _00846_ sky130_fd_sc_hd__o2111a_1
XFILLER_66_122 VPWR VGND VPWR VGND sky130_ef_sc_hd__decap_12
XFILLER_94_475 VGND VGND VPWR VPWR sky130_fd_sc_hd__fill_1
X_08560_ _02318_ _02326_ _02337_ _02346_ VGND VGND VPWR VPWR _02351_ sky130_fd_sc_hd__or4_1
X_07511_ _01597_ _01590_ net553 VGND VGND VPWR VPWR _01642_ sky130_fd_sc_hd__mux2_1
XFILLER_120_19 VGND VGND VPWR VPWR sky130_fd_sc_hd__decap_4
XFILLER_81_169 VGND VGND VPWR VPWR sky130_fd_sc_hd__fill_2
X_08491_ _02275_ _02276_ _02280_ _02281_ VGND VGND VPWR VPWR _02282_ sky130_fd_sc_hd__or4_1
XFILLER_35_553 VGND VGND VPWR VPWR sky130_fd_sc_hd__decap_6
X_07442_ net553 _01572_ _01576_ VGND VGND VPWR VPWR _01577_ sky130_fd_sc_hd__o21ai_1
XFILLER_149_901 VGND VGND VPWR VPWR sky130_fd_sc_hd__fill_1
X_07373_ net1186 net373 net237 VGND VGND VPWR VPWR _00403_ sky130_fd_sc_hd__mux2_1
X_09112_ net583 u_interface.u_gelu_fp32.u_synth_top.s2_dx\[11\] _02712_ VGND VGND
+ VPWR VPWR _02871_ sky130_fd_sc_hd__a21oi_1
XTAP_TAPCELL_ROW_118_2229 VGND VPWR sky130_fd_sc_hd__tapvpwrvgnd_1
XTAP_TAPCELL_ROW_118_2218 VGND VPWR sky130_fd_sc_hd__tapvpwrvgnd_1
XFILLER_13_39 VPWR VGND VPWR VGND sky130_ef_sc_hd__decap_12
X_09043_ _02781_ _02800_ _02753_ _02766_ VGND VGND VPWR VPWR _02802_ sky130_fd_sc_hd__o211ai_2
XFILLER_135_116 VGND VGND VPWR VPWR sky130_fd_sc_hd__decap_6
Xhold410 u_interface.fifo_data\[6\]\[28\] VGND VGND VPWR VPWR net1275 sky130_fd_sc_hd__dlygate4sd3_1
XTAP_TAPCELL_ROW_131_2429 VGND VPWR sky130_fd_sc_hd__tapvpwrvgnd_1
XPHY_EDGE_ROW_111_Right_111 VGND VGND VPWR VPWR sky130_fd_sc_hd__decap_3
Xhold421 u_interface.fifo_data\[8\]\[26\] VGND VGND VPWR VPWR net1286 sky130_fd_sc_hd__dlygate4sd3_1
Xhold454 u_interface.fifo_data\[4\]\[13\] VGND VGND VPWR VPWR net1319 sky130_fd_sc_hd__dlygate4sd3_1
XFILLER_117_897 VGND VGND VPWR VPWR sky130_fd_sc_hd__decap_4
Xhold432 u_interface.fifo_data\[0\]\[14\] VGND VGND VPWR VPWR net1297 sky130_fd_sc_hd__dlygate4sd3_1
XFILLER_89_203 VPWR VGND VPWR VGND sky130_ef_sc_hd__decap_12
Xhold443 u_interface.fifo_data\[2\]\[6\] VGND VGND VPWR VPWR net1308 sky130_fd_sc_hd__dlygate4sd3_1
XFILLER_145_49 VGND VGND VPWR VPWR sky130_fd_sc_hd__decap_6
XFILLER_145_38 VGND VGND VPWR VPWR sky130_fd_sc_hd__decap_8
Xmax_cap173 _03510_ VGND VGND VPWR VPWR net173 sky130_fd_sc_hd__clkbuf_1
Xhold465 u_interface.fifo_data\[10\]\[18\] VGND VGND VPWR VPWR net1330 sky130_fd_sc_hd__dlygate4sd3_1
Xhold487 u_interface.fifo_data\[0\]\[2\] VGND VGND VPWR VPWR net1352 sky130_fd_sc_hd__dlygate4sd3_1
Xhold476 u_interface.fifo_data\[12\]\[8\] VGND VGND VPWR VPWR net1341 sky130_fd_sc_hd__dlygate4sd3_1
X_09945_ _03584_ _03586_ _03585_ VGND VGND VPWR VPWR _03698_ sky130_fd_sc_hd__a21bo_1
Xhold498 _00911_ VGND VGND VPWR VPWR net1363 sky130_fd_sc_hd__dlygate4sd3_1
XTAP_TAPCELL_ROW_5_413 VGND VPWR sky130_fd_sc_hd__tapvpwrvgnd_1
XFILLER_131_399 VGND VGND VPWR VPWR sky130_fd_sc_hd__fill_1
X_09876_ _03521_ _03528_ _03629_ VGND VGND VPWR VPWR _03630_ sky130_fd_sc_hd__or3_1
XFILLER_98_781 VPWR VGND VPWR VGND sky130_ef_sc_hd__decap_12
XFILLER_57_111 VGND VGND VPWR VPWR sky130_fd_sc_hd__fill_1
XTAP_TAPCELL_ROW_51_1144 VGND VPWR sky130_fd_sc_hd__tapvpwrvgnd_1
X_08827_ _02583_ _02585_ VGND VGND VPWR VPWR _02586_ sky130_fd_sc_hd__and2b_1
XTAP_TAPCELL_ROW_51_1155 VGND VPWR sky130_fd_sc_hd__tapvpwrvgnd_1
XTAP_TAPCELL_ROW_146_2672 VGND VPWR sky130_fd_sc_hd__tapvpwrvgnd_1
XFILLER_57_166 VGND VGND VPWR VPWR sky130_fd_sc_hd__fill_2
X_08758_ _02499_ _02500_ _02486_ VGND VGND VPWR VPWR _02517_ sky130_fd_sc_hd__a21oi_1
XFILLER_72_125 VGND VGND VPWR VPWR sky130_fd_sc_hd__decap_3
X_08689_ net663 net670 net502 net508 VGND VGND VPWR VPWR _02448_ sky130_fd_sc_hd__and4_1
X_07709_ _01755_ _01767_ VGND VGND VPWR VPWR _00507_ sky130_fd_sc_hd__or2_1
XFILLER_60_309 VPWR VGND VPWR VGND sky130_ef_sc_hd__decap_12
XFILLER_81_670 VGND VGND VPWR VPWR sky130_fd_sc_hd__fill_2
X_10720_ _04461_ _04465_ VGND VGND VPWR VPWR _04466_ sky130_fd_sc_hd__and2_1
XFILLER_54_884 VGND VGND VPWR VPWR sky130_fd_sc_hd__fill_1
XFILLER_54_79 VGND VGND VPWR VPWR sky130_fd_sc_hd__decap_4
XFILLER_53_361 VPWR VGND VPWR VGND sky130_ef_sc_hd__decap_12
XFILLER_13_225 VPWR VGND VPWR VGND sky130_ef_sc_hd__decap_12
XFILLER_14_737 VPWR VGND VPWR VGND sky130_ef_sc_hd__decap_12
XTAP_TAPCELL_ROW_24_721 VGND VPWR sky130_fd_sc_hd__tapvpwrvgnd_1
XFILLER_110_41 VGND VGND VPWR VPWR sky130_fd_sc_hd__fill_1
XFILLER_80_191 VGND VGND VPWR VPWR sky130_fd_sc_hd__fill_1
X_10651_ net609 net423 _04285_ _04283_ VGND VGND VPWR VPWR _04398_ sky130_fd_sc_hd__a31o_1
XFILLER_9_229 VGND VGND VPWR VPWR sky130_fd_sc_hd__fill_1
XFILLER_22_781 VPWR VGND VPWR VGND sky130_ef_sc_hd__decap_12
X_13370_ clknet_leaf_50_clk _00380_ VGND VGND VPWR VPWR u_interface.fifo_data\[7\]\[15\]
+ sky130_fd_sc_hd__dfxtp_1
X_10582_ _04326_ _04327_ _04322_ VGND VGND VPWR VPWR _04329_ sky130_fd_sc_hd__a21o_1
X_12321_ _06000_ _06049_ VGND VGND VPWR VPWR _06050_ sky130_fd_sc_hd__xnor2_1
X_12252_ _05980_ _05981_ VGND VGND VPWR VPWR _05982_ sky130_fd_sc_hd__or2_1
XFILLER_135_661 VGND VGND VPWR VPWR sky130_fd_sc_hd__fill_2
X_11203_ _04926_ _04943_ VGND VGND VPWR VPWR _04945_ sky130_fd_sc_hd__xnor2_2
XFILLER_135_694 VGND VGND VPWR VPWR sky130_fd_sc_hd__decap_4
X_12183_ _05877_ _05913_ VGND VGND VPWR VPWR _05914_ sky130_fd_sc_hd__xnor2_1
XFILLER_123_889 VGND VGND VPWR VPWR sky130_fd_sc_hd__fill_1
X_11134_ _04874_ _04875_ VGND VGND VPWR VPWR _04877_ sky130_fd_sc_hd__xor2_1
XFILLER_1_641 VPWR VGND VPWR VGND sky130_ef_sc_hd__decap_12
XFILLER_89_770 VGND VGND VPWR VPWR sky130_fd_sc_hd__decap_6
X_11065_ _04716_ _04718_ _04806_ VGND VGND VPWR VPWR _04808_ sky130_fd_sc_hd__a21oi_1
XFILLER_49_623 VGND VGND VPWR VPWR sky130_fd_sc_hd__fill_1
XFILLER_1_685 VPWR VGND VPWR VGND sky130_ef_sc_hd__decap_12
X_10016_ _03761_ _03765_ _03766_ VGND VGND VPWR VPWR _03768_ sky130_fd_sc_hd__nand3_1
XFILLER_88_291 VGND VGND VPWR VPWR sky130_fd_sc_hd__fill_1
XFILLER_88_280 VGND VGND VPWR VPWR sky130_fd_sc_hd__fill_2
XFILLER_76_453 VGND VGND VPWR VPWR sky130_fd_sc_hd__fill_1
XFILLER_48_133 VGND VGND VPWR VPWR sky130_fd_sc_hd__fill_1
XFILLER_76_475 VGND VGND VPWR VPWR sky130_fd_sc_hd__fill_1
XFILLER_37_829 VGND VGND VPWR VPWR sky130_fd_sc_hd__fill_1
XFILLER_91_434 VGND VGND VPWR VPWR sky130_fd_sc_hd__fill_1
XTAP_TAPCELL_ROW_69_1438 VGND VPWR sky130_fd_sc_hd__tapvpwrvgnd_1
XFILLER_63_125 VGND VGND VPWR VPWR sky130_fd_sc_hd__decap_8
XFILLER_48_188 VGND VGND VPWR VPWR sky130_fd_sc_hd__fill_1
XFILLER_36_339 VGND VGND VPWR VPWR sky130_fd_sc_hd__decap_4
X_11967_ _05666_ _05700_ VGND VGND VPWR VPWR _05701_ sky130_fd_sc_hd__xor2_1
X_13706_ clknet_leaf_22_clk _00716_ VGND VGND VPWR VPWR u_interface.u_gelu_fp32.s1_data\[6\]
+ sky130_fd_sc_hd__dfxtp_1
XTAP_TAPCELL_ROW_82_1649 VGND VPWR sky130_fd_sc_hd__tapvpwrvgnd_1
X_10918_ _04661_ _04662_ VGND VGND VPWR VPWR _04663_ sky130_fd_sc_hd__and2b_1
XFILLER_17_597 VPWR VGND VPWR VGND sky130_ef_sc_hd__decap_12
X_11898_ _05566_ _05631_ VGND VGND VPWR VPWR _05633_ sky130_fd_sc_hd__xnor2_1
X_10849_ _04507_ _04509_ _04590_ _04591_ VGND VGND VPWR VPWR _04594_ sky130_fd_sc_hd__a211oi_1
X_13637_ clknet_leaf_69_clk _00647_ VGND VGND VPWR VPWR u_interface.fifo_data\[13\]\[20\]
+ sky130_fd_sc_hd__dfxtp_1
XFILLER_32_589 VPWR VGND VPWR VGND sky130_ef_sc_hd__decap_12
X_13568_ clknet_leaf_50_clk _00578_ VGND VGND VPWR VPWR u_interface.fifo_data\[4\]\[15\]
+ sky130_fd_sc_hd__dfxtp_1
XFILLER_9_741 VPWR VGND VPWR VGND sky130_ef_sc_hd__decap_12
XFILLER_145_425 VGND VGND VPWR VPWR sky130_fd_sc_hd__decap_8
XFILLER_145_403 VGND VGND VPWR VPWR sky130_fd_sc_hd__fill_1
XFILLER_9_785 VPWR VGND VPWR VGND sky130_ef_sc_hd__decap_12
X_12519_ _06242_ _06243_ VGND VGND VPWR VPWR _06244_ sky130_fd_sc_hd__nor2_1
X_13499_ clknet_leaf_3_clk _00509_ VGND VGND VPWR VPWR u_interface.u_gelu_fp32.u_synth_top.s2_m\[12\]
+ sky130_fd_sc_hd__dfxtp_1
XFILLER_67_3 VPWR VGND VPWR VGND sky130_ef_sc_hd__decap_12
XTAP_TAPCELL_ROW_113_2148 VGND VPWR sky130_fd_sc_hd__tapvpwrvgnd_1
XTAP_TAPCELL_ROW_113_2137 VGND VPWR sky130_fd_sc_hd__tapvpwrvgnd_1
XTAP_TAPCELL_ROW_97_1892 VGND VPWR sky130_fd_sc_hd__tapvpwrvgnd_1
XTAP_TAPCELL_ROW_97_1881 VGND VPWR sky130_fd_sc_hd__tapvpwrvgnd_1
XTAP_TAPCELL_ROW_10_492 VGND VPWR sky130_fd_sc_hd__tapvpwrvgnd_1
XFILLER_114_834 VGND VGND VPWR VPWR sky130_fd_sc_hd__decap_4
XFILLER_5_51 VGND VGND VPWR VPWR sky130_fd_sc_hd__decap_4
XFILLER_140_141 VGND VGND VPWR VPWR sky130_fd_sc_hd__decap_8
X_07991_ net546 net303 _01612_ net278 VGND VGND VPWR VPWR _01858_ sky130_fd_sc_hd__a31o_1
Xfanout219 _01526_ VGND VGND VPWR VPWR net219 sky130_fd_sc_hd__buf_4
XFILLER_113_366 VGND VGND VPWR VPWR sky130_fd_sc_hd__decap_6
XFILLER_99_567 VGND VGND VPWR VPWR sky130_fd_sc_hd__decap_8
Xfanout208 _01525_ VGND VGND VPWR VPWR net208 sky130_fd_sc_hd__buf_2
XFILLER_87_729 VGND VGND VPWR VPWR sky130_fd_sc_hd__decap_6
X_09730_ net483 net672 _03331_ _03330_ VGND VGND VPWR VPWR _03485_ sky130_fd_sc_hd__a31o_1
XFILLER_101_517 VGND VGND VPWR VPWR sky130_fd_sc_hd__decap_8
X_06942_ _01473_ _01474_ VGND VGND VPWR VPWR _00025_ sky130_fd_sc_hd__xnor2_1
XTAP_TAPCELL_ROW_128_2380 VGND VPWR sky130_fd_sc_hd__tapvpwrvgnd_1
X_09661_ _03315_ _03317_ _03413_ _03414_ VGND VGND VPWR VPWR _03417_ sky130_fd_sc_hd__a211o_1
XFILLER_94_250 VGND VGND VPWR VPWR sky130_fd_sc_hd__fill_2
X_06873_ u_interface.fifo_data\[0\]\[30\] u_interface.fifo_data\[1\]\[30\] u_interface.fifo_data\[2\]\[30\]
+ u_interface.fifo_data\[3\]\[30\] net760 net743 VGND VGND VPWR VPWR _01418_ sky130_fd_sc_hd__mux4_1
XFILLER_39_155 VPWR VGND VPWR VGND sky130_ef_sc_hd__decap_12
XTAP_TAPCELL_ROW_128_2391 VGND VPWR sky130_fd_sc_hd__tapvpwrvgnd_1
X_09592_ net454 net607 net612 net458 VGND VGND VPWR VPWR _03348_ sky130_fd_sc_hd__a22oi_1
X_08612_ net158 _02389_ VGND VGND VPWR VPWR _02390_ sky130_fd_sc_hd__nand2_1
X_08543_ _02275_ _02280_ _02333_ VGND VGND VPWR VPWR _02334_ sky130_fd_sc_hd__or3_1
XFILLER_36_862 VGND VGND VPWR VPWR sky130_fd_sc_hd__decap_6
XFILLER_42_309 VGND VGND VPWR VPWR sky130_fd_sc_hd__decap_8
XTAP_TAPCELL_ROW_141_2591 VGND VPWR sky130_fd_sc_hd__tapvpwrvgnd_1
XFILLER_23_501 VGND VGND VPWR VPWR sky130_fd_sc_hd__decap_3
X_08474_ u_interface.u_gelu_fp32.u_synth_top.s3_mult\[39\] u_interface.u_gelu_fp32.u_synth_top.s3_mult\[38\]
+ net527 VGND VGND VPWR VPWR _02265_ sky130_fd_sc_hd__o21ai_1
XFILLER_24_27 VGND VGND VPWR VPWR sky130_fd_sc_hd__fill_1
X_07425_ u_interface.u_gelu_fp32.u_fp32_to_q16.s2_norm_mag\[8\] u_interface.u_gelu_fp32.u_fp32_to_q16.s2_norm_mag\[9\]
+ net560 VGND VGND VPWR VPWR _01561_ sky130_fd_sc_hd__mux2_1
XFILLER_11_729 VPWR VGND VPWR VGND sky130_ef_sc_hd__decap_12
XFILLER_50_397 VGND VGND VPWR VPWR sky130_fd_sc_hd__decap_8
X_07356_ net342 net1467 net241 VGND VGND VPWR VPWR _00386_ sky130_fd_sc_hd__mux2_1
XFILLER_149_797 VPWR VGND VPWR VGND sky130_ef_sc_hd__decap_12
X_07287_ net957 net352 net248 VGND VGND VPWR VPWR _00317_ sky130_fd_sc_hd__mux2_1
XFILLER_109_617 VGND VGND VPWR VPWR sky130_fd_sc_hd__decap_8
XFILLER_40_15 VPWR VGND VPWR VGND sky130_ef_sc_hd__decap_12
X_09026_ net629 net638 net502 net508 VGND VGND VPWR VPWR _02785_ sky130_fd_sc_hd__and4_1
XFILLER_108_149 VGND VGND VPWR VPWR sky130_fd_sc_hd__fill_1
XFILLER_40_48 VPWR VGND VPWR VGND sky130_ef_sc_hd__decap_12
XFILLER_124_609 VPWR VGND VPWR VGND sky130_ef_sc_hd__decap_12
XFILLER_151_428 VGND VGND VPWR VPWR sky130_fd_sc_hd__fill_2
XFILLER_132_620 VGND VGND VPWR VPWR sky130_fd_sc_hd__decap_8
Xhold251 u_interface.fifo_data\[1\]\[15\] VGND VGND VPWR VPWR net1116 sky130_fd_sc_hd__dlygate4sd3_1
Xhold262 u_interface.fifo_data\[9\]\[5\] VGND VGND VPWR VPWR net1127 sky130_fd_sc_hd__dlygate4sd3_1
Xhold240 u_interface.fifo_data\[5\]\[21\] VGND VGND VPWR VPWR net1105 sky130_fd_sc_hd__dlygate4sd3_1
XTAP_TAPCELL_ROW_148_2701 VGND VPWR sky130_fd_sc_hd__tapvpwrvgnd_1
XFILLER_116_193 VGND VGND VPWR VPWR sky130_fd_sc_hd__decap_3
XFILLER_104_344 VPWR VGND VPWR VGND sky130_ef_sc_hd__decap_12
Xhold295 u_interface.fifo_data\[8\]\[18\] VGND VGND VPWR VPWR net1160 sky130_fd_sc_hd__dlygate4sd3_1
XFILLER_78_707 VGND VGND VPWR VPWR sky130_fd_sc_hd__fill_1
Xhold284 u_interface.fifo_data\[2\]\[30\] VGND VGND VPWR VPWR net1149 sky130_fd_sc_hd__dlygate4sd3_1
Xhold273 u_interface.fifo_data\[6\]\[31\] VGND VGND VPWR VPWR net1138 sky130_fd_sc_hd__dlygate4sd3_1
XFILLER_131_163 VGND VGND VPWR VPWR sky130_fd_sc_hd__decap_4
XFILLER_120_837 VGND VGND VPWR VPWR sky130_fd_sc_hd__fill_1
Xfanout731 net732 VGND VGND VPWR VPWR net731 sky130_fd_sc_hd__clkbuf_4
X_09928_ _03567_ _03679_ VGND VGND VPWR VPWR _03681_ sky130_fd_sc_hd__xnor2_1
Xfanout742 _00001_ VGND VGND VPWR VPWR net742 sky130_fd_sc_hd__clkbuf_2
Xfanout720 net721 VGND VGND VPWR VPWR net720 sky130_fd_sc_hd__clkbuf_2
XFILLER_49_57 VGND VGND VPWR VPWR sky130_fd_sc_hd__decap_4
Xfanout753 net754 VGND VGND VPWR VPWR net753 sky130_fd_sc_hd__clkbuf_4
Xfanout775 net776 VGND VGND VPWR VPWR net775 sky130_fd_sc_hd__clkbuf_2
Xfanout764 net771 VGND VGND VPWR VPWR net764 sky130_fd_sc_hd__buf_2
XFILLER_77_239 VPWR VGND VPWR VGND sky130_ef_sc_hd__decap_12
Xfanout786 net791 VGND VGND VPWR VPWR net786 sky130_fd_sc_hd__buf_1
X_09859_ _03578_ _03611_ _03612_ VGND VGND VPWR VPWR _03613_ sky130_fd_sc_hd__and3_1
XFILLER_86_773 VGND VGND VPWR VPWR sky130_fd_sc_hd__fill_2
Xfanout797 net798 VGND VGND VPWR VPWR net797 sky130_fd_sc_hd__clkbuf_4
XTAP_TAPCELL_ROW_29_802 VGND VPWR sky130_fd_sc_hd__tapvpwrvgnd_1
X_12870_ net1420 u_interface.u_gelu_fp32.u_fp32_to_q16.s2_norm_mag\[25\] net818 VGND
+ VGND VPWR VPWR _01014_ sky130_fd_sc_hd__mux2_1
XFILLER_73_434 VGND VGND VPWR VPWR sky130_fd_sc_hd__fill_2
XFILLER_45_125 VPWR VGND VPWR VGND sky130_ef_sc_hd__decap_12
XFILLER_45_169 VGND VGND VPWR VPWR sky130_fd_sc_hd__fill_1
X_11821_ _05400_ _05471_ _05470_ VGND VGND VPWR VPWR _05557_ sky130_fd_sc_hd__a21oi_1
XFILLER_61_629 VGND VGND VPWR VPWR sky130_fd_sc_hd__decap_4
XFILLER_14_523 VGND VGND VPWR VPWR sky130_fd_sc_hd__decap_8
XFILLER_26_372 VGND VGND VPWR VPWR sky130_fd_sc_hd__fill_2
XFILLER_27_895 VGND VGND VPWR VPWR sky130_fd_sc_hd__fill_1
XFILLER_121_73 VGND VGND VPWR VPWR sky130_fd_sc_hd__fill_1
XTAP_TAPCELL_ROW_64_1357 VGND VPWR sky130_fd_sc_hd__tapvpwrvgnd_1
XFILLER_14_545 VPWR VGND VPWR VGND sky130_ef_sc_hd__decap_12
X_11752_ net184 _05403_ _05402_ VGND VGND VPWR VPWR _05488_ sky130_fd_sc_hd__a21bo_1
X_10703_ _04447_ _04448_ _04445_ VGND VGND VPWR VPWR _04449_ sky130_fd_sc_hd__a21o_1
XFILLER_14_589 VPWR VGND VPWR VGND sky130_ef_sc_hd__decap_12
X_11683_ _05333_ _05417_ _05418_ VGND VGND VPWR VPWR _05420_ sky130_fd_sc_hd__nand3b_1
X_13422_ clknet_leaf_18_clk _00432_ VGND VGND VPWR VPWR u_interface.u_gelu_fp32.u_fp32_to_q16.s3_frac\[2\]
+ sky130_fd_sc_hd__dfxtp_1
XFILLER_81_99 VGND VGND VPWR VPWR sky130_fd_sc_hd__fill_1
X_10634_ net635 net433 net427 net626 VGND VGND VPWR VPWR _04381_ sky130_fd_sc_hd__a22o_1
XFILLER_155_701 VGND VGND VPWR VPWR sky130_fd_sc_hd__fill_2
XFILLER_139_274 VGND VGND VPWR VPWR sky130_fd_sc_hd__decap_6
X_13353_ clknet_leaf_68_clk _00363_ VGND VGND VPWR VPWR u_interface.fifo_data\[10\]\[30\]
+ sky130_fd_sc_hd__dfxtp_1
X_10565_ net195 _04312_ VGND VGND VPWR VPWR _04313_ sky130_fd_sc_hd__xnor2_1
X_12304_ _06019_ _06032_ VGND VGND VPWR VPWR _06033_ sky130_fd_sc_hd__xor2_1
X_13284_ clknet_leaf_41_clk _00294_ VGND VGND VPWR VPWR u_interface.fifo_data\[0\]\[26\]
+ sky130_fd_sc_hd__dfxtp_1
XFILLER_127_469 VPWR VGND VPWR VGND sky130_ef_sc_hd__decap_12
XFILLER_108_661 VGND VGND VPWR VPWR sky130_fd_sc_hd__fill_1
X_10496_ net461 net688 _04241_ _04242_ VGND VGND VPWR VPWR _04244_ sky130_fd_sc_hd__nand4_1
XFILLER_6_755 VGND VGND VPWR VPWR sky130_fd_sc_hd__fill_1
X_12235_ net702 net395 _05897_ _05896_ VGND VGND VPWR VPWR _05965_ sky130_fd_sc_hd__a31o_1
XPHY_EDGE_ROW_15_Left_171 VGND VGND VPWR VPWR sky130_fd_sc_hd__decap_3
XFILLER_69_707 VGND VGND VPWR VPWR sky130_fd_sc_hd__fill_1
X_12166_ _05894_ _05895_ VGND VGND VPWR VPWR _05897_ sky130_fd_sc_hd__xnor2_1
XFILLER_69_729 VGND VGND VPWR VPWR sky130_fd_sc_hd__decap_8
X_11117_ _04851_ _04859_ VGND VGND VPWR VPWR _04860_ sky130_fd_sc_hd__nor2_1
XFILLER_110_358 VGND VGND VPWR VPWR sky130_fd_sc_hd__decap_6
X_12097_ net675 net387 VGND VGND VPWR VPWR _05829_ sky130_fd_sc_hd__and2b_1
Xinput8 s_axil_araddr[14] VGND VGND VPWR VPWR net8 sky130_fd_sc_hd__clkbuf_1
XFILLER_110_369 VGND VGND VPWR VPWR sky130_fd_sc_hd__fill_1
X_11048_ _04666_ _04672_ _04790_ net800 VGND VGND VPWR VPWR _04792_ sky130_fd_sc_hd__a31o_1
XFILLER_64_401 VGND VGND VPWR VPWR sky130_fd_sc_hd__decap_3
XFILLER_49_464 VPWR VGND VPWR VGND sky130_ef_sc_hd__decap_12
XFILLER_37_615 VGND VGND VPWR VPWR sky130_fd_sc_hd__fill_1
XFILLER_64_456 VGND VGND VPWR VPWR sky130_fd_sc_hd__decap_4
XPHY_EDGE_ROW_24_Left_180 VGND VGND VPWR VPWR sky130_fd_sc_hd__decap_3
XFILLER_24_309 VGND VGND VPWR VPWR sky130_fd_sc_hd__decap_8
X_12999_ net1079 net353 net223 VGND VGND VPWR VPWR _01082_ sky130_fd_sc_hd__mux2_1
XFILLER_92_798 VGND VGND VPWR VPWR sky130_fd_sc_hd__decap_3
XFILLER_64_489 VGND VGND VPWR VPWR sky130_fd_sc_hd__decap_4
XFILLER_17_361 VPWR VGND VPWR VGND sky130_ef_sc_hd__decap_12
XFILLER_33_821 VPWR VGND VPWR VGND sky130_ef_sc_hd__decap_12
XFILLER_33_865 VPWR VGND VPWR VGND sky130_ef_sc_hd__decap_12
X_08190_ u_interface.u_gelu_fp32.u_fp32_to_q16.s3_mag\[23\] _01888_ VGND VGND VPWR
+ VPWR _02024_ sky130_fd_sc_hd__nor2_1
XTAP_TAPCELL_ROW_99_1921 VGND VPWR sky130_fd_sc_hd__tapvpwrvgnd_1
X_07210_ net349 net1575 net258 VGND VGND VPWR VPWR _00250_ sky130_fd_sc_hd__mux2_1
XTAP_TAPCELL_ROW_15_573 VGND VPWR sky130_fd_sc_hd__tapvpwrvgnd_1
X_07141_ net1454 net359 net219 VGND VGND VPWR VPWR _00181_ sky130_fd_sc_hd__mux2_1
XFILLER_146_778 VGND VGND VPWR VPWR sky130_fd_sc_hd__decap_6
XFILLER_118_469 VGND VGND VPWR VPWR sky130_fd_sc_hd__decap_6
X_07072_ net1486 net578 net210 VGND VGND VPWR VPWR _00112_ sky130_fd_sc_hd__mux2_1
XFILLER_10_29 VPWR VGND VPWR VGND sky130_ef_sc_hd__decap_12
XFILLER_141_461 VPWR VGND VPWR VGND sky130_ef_sc_hd__decap_12
XFILLER_114_697 VGND VGND VPWR VPWR sky130_fd_sc_hd__decap_3
XFILLER_99_375 VGND VGND VPWR VPWR sky130_fd_sc_hd__fill_1
XFILLER_59_217 VGND VGND VPWR VPWR sky130_fd_sc_hd__decap_6
X_07974_ net542 _01685_ net279 _01613_ net812 VGND VGND VPWR VPWR _01849_ sky130_fd_sc_hd__a221o_1
XFILLER_87_559 VGND VGND VPWR VPWR sky130_fd_sc_hd__fill_1
XFILLER_19_27 VPWR VGND VPWR VGND sky130_ef_sc_hd__decap_12
X_09713_ _03464_ _03465_ _03362_ VGND VGND VPWR VPWR _03468_ sky130_fd_sc_hd__o21ba_1
X_06925_ _01459_ _01460_ VGND VGND VPWR VPWR _01461_ sky130_fd_sc_hd__nand2_1
X_06856_ net323 _01400_ net727 VGND VGND VPWR VPWR _01403_ sky130_fd_sc_hd__o21a_1
XTAP_TAPCELL_ROW_143_2631 VGND VPWR sky130_fd_sc_hd__tapvpwrvgnd_1
XTAP_TAPCELL_ROW_143_2620 VGND VPWR sky130_fd_sc_hd__tapvpwrvgnd_1
X_09644_ _03398_ _03399_ _03300_ VGND VGND VPWR VPWR _03400_ sky130_fd_sc_hd__a21oi_2
XFILLER_28_637 VGND VGND VPWR VPWR sky130_fd_sc_hd__decap_6
XFILLER_71_916 VGND VGND VPWR VPWR sky130_fd_sc_hd__fill_1
XFILLER_71_905 VGND VGND VPWR VPWR sky130_fd_sc_hd__fill_2
XFILLER_27_136 VGND VGND VPWR VPWR sky130_fd_sc_hd__fill_1
XFILLER_27_147 VGND VGND VPWR VPWR sky130_fd_sc_hd__fill_1
XFILLER_35_15 VPWR VGND VPWR VGND sky130_ef_sc_hd__decap_12
X_06787_ _01341_ _01342_ net736 VGND VGND VPWR VPWR _01343_ sky130_fd_sc_hd__mux2_1
X_09575_ net477 net656 net662 net479 VGND VGND VPWR VPWR _03331_ sky130_fd_sc_hd__a22o_1
XFILLER_55_478 VGND VGND VPWR VPWR sky130_fd_sc_hd__decap_4
XFILLER_43_629 VGND VGND VPWR VPWR sky130_fd_sc_hd__decap_4
XFILLER_27_169 VPWR VGND VPWR VGND sky130_ef_sc_hd__decap_12
X_08526_ _02161_ _02162_ _02316_ _02313_ VGND VGND VPWR VPWR _02317_ sky130_fd_sc_hd__o31a_1
X_08457_ _02245_ _02247_ VGND VGND VPWR VPWR _02248_ sky130_fd_sc_hd__nor2_1
XTAP_TAPCELL_ROW_46_1076 VGND VPWR sky130_fd_sc_hd__tapvpwrvgnd_1
XTAP_TAPCELL_ROW_46_1065 VGND VPWR sky130_fd_sc_hd__tapvpwrvgnd_1
X_07408_ u_interface.u_gelu_fp32.u_fp32_to_q16.s2_norm_mag\[18\] u_interface.u_gelu_fp32.u_fp32_to_q16.s2_norm_mag\[19\]
+ net558 VGND VGND VPWR VPWR _01544_ sky130_fd_sc_hd__mux2_1
XFILLER_136_6 VGND VGND VPWR VPWR sky130_fd_sc_hd__fill_1
XFILLER_50_194 VGND VGND VPWR VPWR sky130_fd_sc_hd__fill_2
XFILLER_23_386 VGND VGND VPWR VPWR sky130_fd_sc_hd__decap_6
XTAP_TAPCELL_ROW_34_882 VGND VPWR sky130_fd_sc_hd__tapvpwrvgnd_1
XFILLER_149_583 VGND VGND VPWR VPWR sky130_fd_sc_hd__decap_6
X_08388_ u_interface.u_gelu_fp32.u_synth_top.s3_mult\[30\] u_interface.u_gelu_fp32.u_synth_top.s3_b\[14\]
+ VGND VGND VPWR VPWR _02179_ sky130_fd_sc_hd__nand2_1
XFILLER_11_559 VGND VGND VPWR VPWR sky130_fd_sc_hd__fill_1
X_07339_ net377 net1449 net242 VGND VGND VPWR VPWR _00369_ sky130_fd_sc_hd__mux2_1
XTAP_TAPCELL_ROW_154_2793 VGND VPWR sky130_fd_sc_hd__tapvpwrvgnd_1
X_10350_ _04086_ _04096_ _04097_ VGND VGND VPWR VPWR _04099_ sky130_fd_sc_hd__nand3_1
XFILLER_151_225 VGND VGND VPWR VPWR sky130_fd_sc_hd__decap_3
X_09009_ net582 net590 net481 net485 VGND VGND VPWR VPWR _02768_ sky130_fd_sc_hd__and4_1
X_10281_ _04029_ _04030_ _03942_ VGND VGND VPWR VPWR _04031_ sky130_fd_sc_hd__o21ai_1
X_12020_ _05751_ _05752_ VGND VGND VPWR VPWR _05753_ sky130_fd_sc_hd__nor2_1
XFILLER_120_601 VPWR VGND VPWR VGND sky130_ef_sc_hd__decap_12
XFILLER_104_141 VPWR VGND VPWR VGND sky130_ef_sc_hd__decap_12
Xfanout550 net551 VGND VGND VPWR VPWR net550 sky130_fd_sc_hd__buf_2
XFILLER_120_656 VGND VGND VPWR VPWR sky130_fd_sc_hd__decap_3
Xfanout583 net584 VGND VGND VPWR VPWR net583 sky130_fd_sc_hd__buf_2
Xfanout572 u_interface.core_data_out\[26\] VGND VGND VPWR VPWR net572 sky130_fd_sc_hd__buf_1
XFILLER_101_870 VGND VGND VPWR VPWR sky130_fd_sc_hd__decap_3
X_13971_ clknet_leaf_84_clk net1048 VGND VGND VPWR VPWR u_interface.u_gelu_fp32.u_q16_to_fp32.s2_mag\[16\]
+ sky130_fd_sc_hd__dfxtp_1
XFILLER_59_762 VGND VGND VPWR VPWR sky130_fd_sc_hd__decap_6
Xfanout561 u_interface.core_data_out\[31\] VGND VGND VPWR VPWR net561 sky130_fd_sc_hd__clkbuf_2
X_12922_ u_interface.in_flight_count\[1\] _06441_ _06448_ net788 VGND VGND VPWR VPWR
+ _01054_ sky130_fd_sc_hd__o211a_1
Xfanout594 net595 VGND VGND VPWR VPWR net594 sky130_fd_sc_hd__clkbuf_2
XFILLER_74_721 VGND VGND VPWR VPWR sky130_fd_sc_hd__decap_8
XFILLER_59_795 VGND VGND VPWR VPWR sky130_fd_sc_hd__fill_1
X_12853_ net1177 u_interface.u_gelu_fp32.u_fp32_to_q16.s2_norm_mag\[8\] net817 VGND
+ VGND VPWR VPWR _00997_ sky130_fd_sc_hd__mux2_1
XFILLER_74_798 VGND VGND VPWR VPWR sky130_fd_sc_hd__fill_2
XFILLER_46_489 VGND VGND VPWR VPWR sky130_fd_sc_hd__decap_6
XFILLER_15_821 VPWR VGND VPWR VGND sky130_ef_sc_hd__decap_12
X_12784_ net1748 _01783_ _06408_ VGND VGND VPWR VPWR _00952_ sky130_fd_sc_hd__a21oi_1
XFILLER_26_191 VGND VGND VPWR VPWR sky130_fd_sc_hd__fill_1
X_11804_ _05522_ _05539_ VGND VGND VPWR VPWR _05540_ sky130_fd_sc_hd__xnor2_1
X_11735_ _05400_ _05471_ VGND VGND VPWR VPWR _05472_ sky130_fd_sc_hd__xnor2_1
XFILLER_15_865 VPWR VGND VPWR VGND sky130_ef_sc_hd__decap_12
XFILLER_25_81 VPWR VGND VPWR VGND sky130_ef_sc_hd__decap_12
XFILLER_30_813 VPWR VGND VPWR VGND sky130_ef_sc_hd__decap_12
XTAP_TAPCELL_ROW_12_521 VGND VPWR sky130_fd_sc_hd__tapvpwrvgnd_1
X_13405_ clknet_leaf_51_clk _00415_ VGND VGND VPWR VPWR u_interface.fifo_data\[6\]\[18\]
+ sky130_fd_sc_hd__dfxtp_1
XTAP_TAPCELL_ROW_12_532 VGND VPWR sky130_fd_sc_hd__tapvpwrvgnd_1
X_11666_ net179 _05401_ VGND VGND VPWR VPWR _05403_ sky130_fd_sc_hd__xor2_1
XFILLER_127_222 VGND VGND VPWR VPWR sky130_fd_sc_hd__fill_2
X_10617_ _04360_ _04361_ _04362_ VGND VGND VPWR VPWR _04364_ sky130_fd_sc_hd__and3_1
XFILLER_10_581 VGND VGND VPWR VPWR sky130_fd_sc_hd__decap_6
X_11597_ _05331_ _05332_ _05333_ VGND VGND VPWR VPWR _05335_ sky130_fd_sc_hd__o21ai_1
X_13336_ clknet_leaf_34_clk _00346_ VGND VGND VPWR VPWR u_interface.fifo_data\[10\]\[13\]
+ sky130_fd_sc_hd__dfxtp_1
X_10548_ _04294_ _04295_ _04173_ VGND VGND VPWR VPWR _04296_ sky130_fd_sc_hd__a21o_1
XFILLER_143_726 VGND VGND VPWR VPWR sky130_fd_sc_hd__fill_2
XFILLER_115_428 VGND VGND VPWR VPWR sky130_fd_sc_hd__decap_8
XTAP_TAPCELL_ROW_94_1840 VGND VPWR sky130_fd_sc_hd__tapvpwrvgnd_1
X_13267_ clknet_leaf_62_clk _00277_ VGND VGND VPWR VPWR u_interface.fifo_data\[0\]\[9\]
+ sky130_fd_sc_hd__dfxtp_1
X_10479_ net464 net468 net700 net707 VGND VGND VPWR VPWR _04227_ sky130_fd_sc_hd__and4_1
X_12218_ _05946_ _05947_ VGND VGND VPWR VPWR _05948_ sky130_fd_sc_hd__nor2_1
XFILLER_123_461 VGND VGND VPWR VPWR sky130_fd_sc_hd__fill_2
XFILLER_111_601 VPWR VGND VPWR VGND sky130_ef_sc_hd__decap_12
X_13198_ clknet_leaf_72_clk _00208_ VGND VGND VPWR VPWR u_interface.fifo_data\[12\]\[8\]
+ sky130_fd_sc_hd__dfxtp_1
XFILLER_111_656 VGND VGND VPWR VPWR sky130_fd_sc_hd__fill_1
XFILLER_97_857 VGND VGND VPWR VPWR sky130_fd_sc_hd__decap_4
XFILLER_96_345 VPWR VGND VPWR VGND sky130_ef_sc_hd__decap_12
X_12149_ net203 _05878_ VGND VGND VPWR VPWR _05880_ sky130_fd_sc_hd__or2_1
XFILLER_110_155 VPWR VGND VPWR VGND sky130_ef_sc_hd__decap_12
XFILLER_2_41 VPWR VGND VPWR VGND sky130_ef_sc_hd__decap_12
X_06710_ u_interface.fifo_data\[8\]\[10\] u_interface.fifo_data\[9\]\[10\] u_interface.fifo_data\[10\]\[10\]
+ u_interface.fifo_data\[11\]\[10\] net769 net752 VGND VGND VPWR VPWR _01275_ sky130_fd_sc_hd__mux4_1
XTAP_TAPCELL_ROW_108_2058 VGND VPWR sky130_fd_sc_hd__tapvpwrvgnd_1
XFILLER_2_85 VPWR VGND VPWR VGND sky130_ef_sc_hd__decap_12
XTAP_TAPCELL_ROW_108_2069 VGND VPWR sky130_fd_sc_hd__tapvpwrvgnd_1
X_07690_ _01128_ _01755_ _01756_ _01761_ VGND VGND VPWR VPWR _00493_ sky130_fd_sc_hd__or4_1
XFILLER_37_456 VGND VGND VPWR VPWR sky130_fd_sc_hd__fill_1
X_06641_ u_interface.fifo_data\[0\]\[1\] u_interface.fifo_data\[1\]\[1\] u_interface.fifo_data\[2\]\[1\]
+ u_interface.fifo_data\[3\]\[1\] net763 net746 VGND VGND VPWR VPWR _01215_ sky130_fd_sc_hd__mux4_1
XFILLER_92_584 VGND VGND VPWR VPWR sky130_fd_sc_hd__decap_4
XFILLER_80_735 VGND VGND VPWR VPWR sky130_fd_sc_hd__decap_3
XFILLER_80_713 VGND VGND VPWR VPWR sky130_fd_sc_hd__decap_3
XFILLER_18_681 VPWR VGND VPWR VGND sky130_ef_sc_hd__decap_12
XFILLER_25_629 VPWR VGND VPWR VGND sky130_ef_sc_hd__decap_12
XFILLER_37_489 VPWR VGND VPWR VGND sky130_ef_sc_hd__decap_12
X_09360_ _03118_ _03113_ VGND VGND VPWR VPWR _03119_ sky130_fd_sc_hd__nand2b_1
XTAP_TAPCELL_ROW_121_2269 VGND VPWR sky130_fd_sc_hd__tapvpwrvgnd_1
X_06572_ net537 _01156_ _01162_ net535 VGND VGND VPWR VPWR _01164_ sky130_fd_sc_hd__a22o_1
XFILLER_80_757 VPWR VGND VPWR VGND sky130_ef_sc_hd__decap_12
X_09291_ _03047_ _03048_ _03046_ VGND VGND VPWR VPWR _03050_ sky130_fd_sc_hd__o21bai_1
X_08311_ u_interface.u_gelu_fp32.s2_data\[17\] _02113_ VGND VGND VPWR VPWR _02116_
+ sky130_fd_sc_hd__or2_1
XFILLER_33_673 VPWR VGND VPWR VGND sky130_ef_sc_hd__decap_12
X_08242_ _01895_ _02067_ VGND VGND VPWR VPWR _02068_ sky130_fd_sc_hd__xor2_1
XTAP_TAPCELL_ROW_103_1991 VGND VPWR sky130_fd_sc_hd__tapvpwrvgnd_1
XTAP_TAPCELL_ROW_103_1980 VGND VPWR sky130_fd_sc_hd__tapvpwrvgnd_1
XANTENNA_13 net122 VGND VGND VPWR VPWR sky130_fd_sc_hd__diode_2
XTAP_TAPCELL_ROW_31_830 VGND VPWR sky130_fd_sc_hd__tapvpwrvgnd_1
X_08173_ _02003_ _02004_ VGND VGND VPWR VPWR _02010_ sky130_fd_sc_hd__nand2_1
XFILLER_146_553 VGND VGND VPWR VPWR sky130_fd_sc_hd__decap_4
X_07124_ net324 net1207 net284 VGND VGND VPWR VPWR _00164_ sky130_fd_sc_hd__mux2_1
XFILLER_21_39 VPWR VGND VPWR VGND sky130_ef_sc_hd__decap_12
XFILLER_133_225 VPWR VGND VPWR VGND sky130_ef_sc_hd__decap_12
X_07055_ net1151 net372 net207 VGND VGND VPWR VPWR _00095_ sky130_fd_sc_hd__mux2_1
Xoutput142 net142 VGND VGND VPWR VPWR m_axis_tuser sky130_fd_sc_hd__buf_2
Xoutput120 net120 VGND VGND VPWR VPWR m_axis_tdata[1] sky130_fd_sc_hd__buf_2
Xoutput131 net131 VGND VGND VPWR VPWR m_axis_tdata[2] sky130_fd_sc_hd__buf_2
XFILLER_153_27 VPWR VGND VPWR VGND sky130_ef_sc_hd__decap_12
X_07957_ net545 _01598_ net278 _01840_ VGND VGND VPWR VPWR _00683_ sky130_fd_sc_hd__a31o_1
X_06908_ _01443_ _01446_ _01444_ VGND VGND VPWR VPWR _01448_ sky130_fd_sc_hd__a21bo_1
XFILLER_75_529 VGND VGND VPWR VPWR sky130_fd_sc_hd__fill_2
X_07888_ net1136 net341 net267 VGND VGND VPWR VPWR _00649_ sky130_fd_sc_hd__mux2_1
XFILLER_55_231 VGND VGND VPWR VPWR sky130_fd_sc_hd__fill_1
XTAP_TAPCELL_ROW_39_952 VGND VPWR sky130_fd_sc_hd__tapvpwrvgnd_1
XTAP_TAPCELL_ROW_39_963 VGND VPWR sky130_fd_sc_hd__tapvpwrvgnd_1
X_06839_ net323 _01387_ VGND VGND VPWR VPWR _01388_ sky130_fd_sc_hd__or2_1
X_09627_ net483 net662 _03284_ _03283_ VGND VGND VPWR VPWR _03383_ sky130_fd_sc_hd__a31o_1
XFILLER_83_573 VGND VGND VPWR VPWR sky130_fd_sc_hd__decap_6
XFILLER_55_286 VGND VGND VPWR VPWR sky130_fd_sc_hd__fill_1
XFILLER_55_253 VGND VGND VPWR VPWR sky130_fd_sc_hd__decap_4
XTAP_TAPCELL_ROW_48_1105 VGND VPWR sky130_fd_sc_hd__tapvpwrvgnd_1
X_09558_ _03213_ _03215_ _03311_ _03312_ VGND VGND VPWR VPWR _03315_ sky130_fd_sc_hd__a211o_1
XFILLER_102_53 VGND VGND VPWR VPWR sky130_fd_sc_hd__decap_8
XFILLER_70_245 VGND VGND VPWR VPWR sky130_fd_sc_hd__decap_6
XTAP_TAPCELL_ROW_61_1305 VGND VPWR sky130_fd_sc_hd__tapvpwrvgnd_1
XFILLER_12_813 VPWR VGND VPWR VGND sky130_ef_sc_hd__decap_12
X_08509_ net524 u_interface.u_gelu_fp32.u_synth_top.s3_mult\[54\] VGND VGND VPWR VPWR
+ _02300_ sky130_fd_sc_hd__nand2_1
XFILLER_24_640 VGND VGND VPWR VPWR sky130_fd_sc_hd__decap_4
X_09489_ net484 net657 _03137_ _03136_ VGND VGND VPWR VPWR _03246_ sky130_fd_sc_hd__a31o_1
XTAP_TAPCELL_ROW_61_1316 VGND VPWR sky130_fd_sc_hd__tapvpwrvgnd_1
X_11520_ net684 net421 _05257_ _05258_ VGND VGND VPWR VPWR _05259_ sky130_fd_sc_hd__a22o_1
XFILLER_134_3 VGND VGND VPWR VPWR sky130_fd_sc_hd__fill_2
XFILLER_11_334 VGND VGND VPWR VPWR sky130_fd_sc_hd__fill_2
X_11451_ _05171_ _05190_ VGND VGND VPWR VPWR _05191_ sky130_fd_sc_hd__xnor2_2
X_10402_ _04142_ _04150_ VGND VGND VPWR VPWR _04151_ sky130_fd_sc_hd__nand2b_1
X_14170_ clknet_leaf_68_clk _01096_ VGND VGND VPWR VPWR u_interface.fifo_data\[1\]\[30\]
+ sky130_fd_sc_hd__dfxtp_1
X_11382_ net195 _05113_ _05112_ VGND VGND VPWR VPWR _05122_ sky130_fd_sc_hd__a21oi_1
XFILLER_152_501 VGND VGND VPWR VPWR sky130_fd_sc_hd__decap_8
X_13121_ clknet_leaf_40_clk _00131_ VGND VGND VPWR VPWR u_interface.fifo_data\[2\]\[10\]
+ sky130_fd_sc_hd__dfxtp_1
X_10333_ _03965_ _03972_ _04081_ net801 VGND VGND VPWR VPWR _04083_ sky130_fd_sc_hd__a31o_1
XTAP_TAPCELL_ROW_59_1278 VGND VPWR sky130_fd_sc_hd__tapvpwrvgnd_1
XFILLER_152_589 VPWR VGND VPWR VGND sky130_ef_sc_hd__decap_12
X_10264_ _04011_ _04013_ VGND VGND VPWR VPWR _04014_ sky130_fd_sc_hd__nor2_1
X_13052_ clknet_leaf_70_clk _00062_ VGND VGND VPWR VPWR u_interface.fifo_data\[14\]\[5\]
+ sky130_fd_sc_hd__dfxtp_1
XFILLER_132_291 VPWR VGND VPWR VGND sky130_ef_sc_hd__decap_12
XFILLER_87_65 VGND VGND VPWR VPWR sky130_fd_sc_hd__decap_3
X_10195_ _03802_ _03945_ VGND VGND VPWR VPWR _03946_ sky130_fd_sc_hd__or2_1
XFILLER_78_345 VGND VGND VPWR VPWR sky130_fd_sc_hd__fill_1
X_12003_ net204 _05735_ VGND VGND VPWR VPWR _05736_ sky130_fd_sc_hd__and2b_1
XTAP_TAPCELL_ROW_72_1489 VGND VPWR sky130_fd_sc_hd__tapvpwrvgnd_1
XFILLER_120_475 VGND VGND VPWR VPWR sky130_fd_sc_hd__fill_1
XFILLER_93_337 VGND VGND VPWR VPWR sky130_fd_sc_hd__decap_4
Xfanout380 u_interface.core_data_out\[2\] VGND VGND VPWR VPWR net380 sky130_fd_sc_hd__clkbuf_2
Xfanout391 net392 VGND VGND VPWR VPWR net391 sky130_fd_sc_hd__buf_2
XFILLER_143_93 VGND VGND VPWR VPWR sky130_fd_sc_hd__decap_4
X_13954_ clknet_leaf_55_clk _00880_ VGND VGND VPWR VPWR u_interface.u_gelu_fp32.u_q16_to_fp32.s2_exp\[7\]
+ sky130_fd_sc_hd__dfxtp_1
XFILLER_93_348 VGND VGND VPWR VPWR sky130_fd_sc_hd__fill_2
XFILLER_19_434 VGND VGND VPWR VPWR sky130_fd_sc_hd__decap_8
X_12905_ net1724 _06435_ _01504_ VGND VGND VPWR VPWR _01050_ sky130_fd_sc_hd__a21bo_1
X_13885_ clknet_leaf_0_clk _00038_ VGND VGND VPWR VPWR u_interface.u_gelu_fp32.u_synth_top.s2_dx\[21\]
+ sky130_fd_sc_hd__dfxtp_1
XFILLER_74_584 VGND VGND VPWR VPWR sky130_fd_sc_hd__decap_4
XFILLER_46_253 VPWR VGND VPWR VGND sky130_ef_sc_hd__decap_12
XTAP_TAPCELL_ROW_17_602 VGND VPWR sky130_fd_sc_hd__tapvpwrvgnd_1
XTAP_TAPCELL_ROW_17_613 VGND VPWR sky130_fd_sc_hd__tapvpwrvgnd_1
XFILLER_62_757 VGND VGND VPWR VPWR sky130_fd_sc_hd__decap_4
X_12836_ net797 net528 net1604 _02152_ VGND VGND VPWR VPWR _00994_ sky130_fd_sc_hd__nor4_1
XFILLER_34_437 VGND VGND VPWR VPWR sky130_fd_sc_hd__decap_6
XFILLER_15_673 VPWR VGND VPWR VGND sky130_ef_sc_hd__decap_12
X_12767_ u_interface.u_gelu_fp32.u_q16_to_fp32.s3_norm_mag\[12\] _01777_ net296 VGND
+ VGND VPWR VPWR _06400_ sky130_fd_sc_hd__o21ai_1
X_12698_ u_interface.u_gelu_fp32.u_q16_to_fp32.s2_mag\[20\] u_interface.u_gelu_fp32.u_q16_to_fp32.s2_mag\[19\]
+ net336 VGND VGND VPWR VPWR _06356_ sky130_fd_sc_hd__mux2_1
XFILLER_30_643 VGND VGND VPWR VPWR sky130_fd_sc_hd__fill_1
X_11718_ _05453_ _05454_ VGND VGND VPWR VPWR _05455_ sky130_fd_sc_hd__xnor2_1
Xinput22 s_axil_araddr[27] VGND VGND VPWR VPWR net22 sky130_fd_sc_hd__clkbuf_1
Xinput11 s_axil_araddr[17] VGND VGND VPWR VPWR net11 sky130_fd_sc_hd__buf_1
XFILLER_128_531 VGND VGND VPWR VPWR sky130_fd_sc_hd__fill_1
X_11649_ _05384_ _05385_ VGND VGND VPWR VPWR _05387_ sky130_fd_sc_hd__xor2_1
Xinput55 s_axil_awaddr[27] VGND VGND VPWR VPWR net55 sky130_fd_sc_hd__dlymetal6s2s_1
Xinput44 s_axil_awaddr[17] VGND VGND VPWR VPWR net44 sky130_fd_sc_hd__clkbuf_1
Xinput33 s_axil_araddr[8] VGND VGND VPWR VPWR net33 sky130_fd_sc_hd__clkbuf_1
Xinput66 s_axil_awaddr[8] VGND VGND VPWR VPWR net66 sky130_fd_sc_hd__clkbuf_1
Xinput88 s_axis_tdata[22] VGND VGND VPWR VPWR net88 sky130_fd_sc_hd__clkbuf_1
Xinput77 s_axis_tdata[12] VGND VGND VPWR VPWR net77 sky130_fd_sc_hd__clkbuf_1
X_13319_ clknet_leaf_39_clk _00329_ VGND VGND VPWR VPWR u_interface.fifo_data\[8\]\[28\]
+ sky130_fd_sc_hd__dfxtp_1
XFILLER_116_737 VGND VGND VPWR VPWR sky130_fd_sc_hd__fill_2
XFILLER_115_214 VGND VGND VPWR VPWR sky130_fd_sc_hd__fill_1
Xhold817 u_interface.u_gelu_fp32.u_synth_top.s2_b\[6\] VGND VGND VPWR VPWR net1682
+ sky130_fd_sc_hd__dlygate4sd3_1
Xhold806 u_interface.u_gelu_fp32.u_q16_to_fp32.s2_clz\[4\] VGND VGND VPWR VPWR net1671
+ sky130_fd_sc_hd__dlygate4sd3_1
Xhold828 _00903_ VGND VGND VPWR VPWR net1693 sky130_fd_sc_hd__dlygate4sd3_1
Xinput99 s_axis_tdata[3] VGND VGND VPWR VPWR net99 sky130_fd_sc_hd__clkbuf_1
XFILLER_115_225 VPWR VGND VPWR VGND sky130_ef_sc_hd__decap_12
Xhold839 u_interface.u_gelu_fp32.u_q16_to_fp32.s1_mag\[3\] VGND VGND VPWR VPWR net1704
+ sky130_fd_sc_hd__dlygate4sd3_1
XFILLER_69_301 VPWR VGND VPWR VGND sky130_ef_sc_hd__decap_12
X_08860_ net585 net458 net593 net462 VGND VGND VPWR VPWR _02619_ sky130_fd_sc_hd__a22o_1
X_07811_ net1244 net366 net229 VGND VGND VPWR VPWR _00572_ sky130_fd_sc_hd__mux2_1
X_08791_ _02502_ _02519_ _02547_ _02548_ VGND VGND VPWR VPWR _02550_ sky130_fd_sc_hd__a211oi_1
XFILLER_96_197 VGND VGND VPWR VPWR sky130_fd_sc_hd__decap_3
XTAP_TAPCELL_ROW_123_2309 VGND VPWR sky130_fd_sc_hd__tapvpwrvgnd_1
X_07742_ u_interface.u_gelu_fp32.u_q16_to_fp32.s3_norm_mag\[24\] u_interface.u_gelu_fp32.u_q16_to_fp32.s3_norm_mag\[23\]
+ _01785_ VGND VGND VPWR VPWR _01786_ sky130_fd_sc_hd__and3_1
XFILLER_26_905 VPWR VGND VPWR VGND sky130_ef_sc_hd__decap_12
X_07673_ u_interface.u_gelu_fp32.u_synth_top.s1_hits\[18\] u_interface.u_gelu_fp32.u_synth_top.comb_b\[18\]
+ VGND VGND VPWR VPWR _00486_ sky130_fd_sc_hd__or2_1
XFILLER_80_510 VGND VGND VPWR VPWR sky130_fd_sc_hd__decap_8
XTAP_TAPCELL_ROW_36_911 VGND VPWR sky130_fd_sc_hd__tapvpwrvgnd_1
X_06624_ net322 _01199_ net727 VGND VGND VPWR VPWR _01200_ sky130_fd_sc_hd__o21a_1
X_09412_ net515 net714 net723 net519 VGND VGND VPWR VPWR _03170_ sky130_fd_sc_hd__a22oi_1
X_09343_ net600 net517 _03101_ net584 VGND VGND VPWR VPWR _03102_ sky130_fd_sc_hd__a22o_1
XFILLER_80_554 VGND VGND VPWR VPWR sky130_fd_sc_hd__decap_8
XFILLER_12_109 VPWR VGND VPWR VGND sky130_ef_sc_hd__decap_12
X_06555_ _01106_ _01139_ VGND VGND VPWR VPWR _01150_ sky130_fd_sc_hd__and2_1
XFILLER_80_587 VGND VGND VPWR VPWR sky130_fd_sc_hd__fill_1
XTAP_TAPCELL_ROW_43_1024 VGND VPWR sky130_fd_sc_hd__tapvpwrvgnd_1
XFILLER_40_429 VGND VGND VPWR VPWR sky130_fd_sc_hd__fill_2
X_09274_ _02985_ _03031_ _03032_ VGND VGND VPWR VPWR _03033_ sky130_fd_sc_hd__or3_2
XTAP_TAPCELL_ROW_138_2541 VGND VPWR sky130_fd_sc_hd__tapvpwrvgnd_1
XFILLER_21_665 VGND VGND VPWR VPWR sky130_fd_sc_hd__decap_6
XFILLER_148_27 VGND VGND VPWR VPWR sky130_fd_sc_hd__fill_1
X_08225_ _02046_ _02049_ net539 VGND VGND VPWR VPWR _02054_ sky130_fd_sc_hd__o21a_1
X_08156_ net540 _01994_ _01993_ VGND VGND VPWR VPWR _01996_ sky130_fd_sc_hd__a21o_1
XFILLER_5_809 VPWR VGND VPWR VGND sky130_ef_sc_hd__decap_12
XFILLER_20_197 VPWR VGND VPWR VGND sky130_ef_sc_hd__decap_12
XTAP_TAPCELL_ROW_151_2752 VGND VPWR sky130_fd_sc_hd__tapvpwrvgnd_1
XFILLER_146_383 VGND VGND VPWR VPWR sky130_fd_sc_hd__decap_6
X_07107_ net1401 net571 net227 VGND VGND VPWR VPWR _00147_ sky130_fd_sc_hd__mux2_1
XFILLER_119_575 VPWR VGND VPWR VGND sky130_ef_sc_hd__decap_12
XFILLER_106_214 VGND VGND VPWR VPWR sky130_fd_sc_hd__decap_4
X_08087_ net314 _01936_ _01937_ VGND VGND VPWR VPWR _01938_ sky130_fd_sc_hd__or3_1
XFILLER_134_589 VGND VGND VPWR VPWR sky130_fd_sc_hd__decap_4
X_07038_ net983 net342 net269 VGND VGND VPWR VPWR _00078_ sky130_fd_sc_hd__mux2_1
XFILLER_88_643 VGND VGND VPWR VPWR sky130_fd_sc_hd__fill_1
XFILLER_102_453 VGND VGND VPWR VPWR sky130_fd_sc_hd__fill_2
XFILLER_88_665 VGND VGND VPWR VPWR sky130_fd_sc_hd__fill_1
XFILLER_87_142 VPWR VGND VPWR VGND sky130_ef_sc_hd__decap_12
XTAP_TAPCELL_ROW_54_1197 VGND VPWR sky130_fd_sc_hd__tapvpwrvgnd_1
X_08989_ _02743_ _02744_ _02746_ _02747_ VGND VGND VPWR VPWR _02748_ sky130_fd_sc_hd__o2bb2a_1
XFILLER_88_698 VGND VGND VPWR VPWR sky130_fd_sc_hd__fill_2
XFILLER_75_337 VPWR VGND VPWR VGND sky130_ef_sc_hd__decap_12
XFILLER_69_890 VGND VGND VPWR VPWR sky130_fd_sc_hd__fill_2
XFILLER_57_57 VPWR VGND VPWR VGND sky130_ef_sc_hd__decap_12
XFILLER_57_46 VGND VGND VPWR VPWR sky130_fd_sc_hd__decap_8
XFILLER_29_721 VGND VGND VPWR VPWR sky130_fd_sc_hd__decap_6
XFILLER_29_765 VPWR VGND VPWR VGND sky130_ef_sc_hd__decap_12
X_10951_ _04694_ _04675_ VGND VGND VPWR VPWR _04695_ sky130_fd_sc_hd__and2b_1
XTAP_TAPCELL_ROW_3_385 VGND VPWR sky130_fd_sc_hd__tapvpwrvgnd_1
XFILLER_28_253 VPWR VGND VPWR VGND sky130_ef_sc_hd__decap_12
X_13670_ clknet_leaf_13_clk net935 VGND VGND VPWR VPWR u_interface.u_gelu_fp32.u_fp32_to_q16.s2_is_zero
+ sky130_fd_sc_hd__dfxtp_1
XFILLER_56_595 VGND VGND VPWR VPWR sky130_fd_sc_hd__fill_1
XFILLER_43_223 VGND VGND VPWR VPWR sky130_fd_sc_hd__fill_1
X_12621_ u_interface.u_gelu_fp32.u_q16_to_fp32.s1_mag\[2\] net212 u_interface.u_gelu_fp32.u_q16_to_fp32.s1_mag\[18\]
+ VGND VGND VPWR VPWR _06324_ sky130_fd_sc_hd__a21o_1
X_10882_ _04617_ _04625_ VGND VGND VPWR VPWR _04627_ sky130_fd_sc_hd__xor2_1
XFILLER_31_407 VGND VGND VPWR VPWR sky130_fd_sc_hd__fill_2
XFILLER_43_256 VGND VGND VPWR VPWR sky130_fd_sc_hd__decap_3
XPHY_EDGE_ROW_125_Right_125 VGND VGND VPWR VPWR sky130_fd_sc_hd__decap_3
XFILLER_12_643 VGND VGND VPWR VPWR sky130_fd_sc_hd__fill_1
X_12552_ net191 _06244_ _06243_ VGND VGND VPWR VPWR _06276_ sky130_fd_sc_hd__a21oi_1
XFILLER_8_625 VPWR VGND VPWR VGND sky130_ef_sc_hd__decap_12
XFILLER_7_113 VPWR VGND VPWR VGND sky130_ef_sc_hd__decap_12
X_12483_ _06125_ _06162_ _06161_ VGND VGND VPWR VPWR _06209_ sky130_fd_sc_hd__a21oi_1
X_11503_ net703 net429 net424 net694 VGND VGND VPWR VPWR _05242_ sky130_fd_sc_hd__a22oi_1
XFILLER_144_309 VGND VGND VPWR VPWR sky130_fd_sc_hd__decap_8
XFILLER_8_669 VPWR VGND VPWR VGND sky130_ef_sc_hd__decap_12
XTAP_TAPCELL_ROW_22_682 VGND VPWR sky130_fd_sc_hd__tapvpwrvgnd_1
XTAP_TAPCELL_ROW_22_693 VGND VPWR sky130_fd_sc_hd__tapvpwrvgnd_1
X_11434_ net642 net403 net399 net633 VGND VGND VPWR VPWR _05174_ sky130_fd_sc_hd__a22oi_2
XFILLER_137_350 VPWR VGND VPWR VGND sky130_ef_sc_hd__decap_12
XFILLER_138_82 VGND VGND VPWR VPWR sky130_fd_sc_hd__fill_2
X_14153_ clknet_leaf_26_clk _01079_ VGND VGND VPWR VPWR u_interface.fifo_data\[1\]\[13\]
+ sky130_fd_sc_hd__dfxtp_1
XFILLER_99_919 VGND VGND VPWR VPWR sky130_fd_sc_hd__fill_2
XTAP_TAPCELL_ROW_74_1518 VGND VPWR sky130_fd_sc_hd__tapvpwrvgnd_1
X_11365_ _05028_ _05105_ VGND VGND VPWR VPWR _05106_ sky130_fd_sc_hd__xor2_1
XFILLER_153_887 VGND VGND VPWR VPWR sky130_fd_sc_hd__fill_1
X_14084_ clknet_leaf_17_clk net1243 VGND VGND VPWR VPWR u_interface.u_gelu_fp32.u_fp32_to_q16.s2_norm_mag\[21\]
+ sky130_fd_sc_hd__dfxtp_1
XFILLER_113_729 VGND VGND VPWR VPWR sky130_fd_sc_hd__decap_4
XFILLER_113_718 VGND VGND VPWR VPWR sky130_fd_sc_hd__decap_8
X_13104_ clknet_leaf_47_clk _00114_ VGND VGND VPWR VPWR u_interface.fifo_data\[15\]\[25\]
+ sky130_fd_sc_hd__dfxtp_1
X_10316_ _03946_ _03949_ _04063_ net181 VGND VGND VPWR VPWR _04066_ sky130_fd_sc_hd__a211o_1
X_11296_ _05036_ _05035_ VGND VGND VPWR VPWR _05037_ sky130_fd_sc_hd__and2b_1
X_13035_ clknet_leaf_37_clk _00045_ VGND VGND VPWR VPWR u_interface.fifo_tuser\[10\]
+ sky130_fd_sc_hd__dfxtp_1
XFILLER_140_537 VGND VGND VPWR VPWR sky130_fd_sc_hd__fill_1
X_10247_ _03975_ _03994_ _03995_ VGND VGND VPWR VPWR _03997_ sky130_fd_sc_hd__nand3_2
XFILLER_3_385 VGND VGND VPWR VPWR sky130_fd_sc_hd__decap_6
X_10178_ _03927_ _03928_ VGND VGND VPWR VPWR _03929_ sky130_fd_sc_hd__and2b_1
XFILLER_78_197 VGND VGND VPWR VPWR sky130_fd_sc_hd__decap_6
XTAP_TAPCELL_ROW_105_2017 VGND VPWR sky130_fd_sc_hd__tapvpwrvgnd_1
X_13937_ clknet_leaf_3_clk _00022_ VGND VGND VPWR VPWR u_interface.u_gelu_fp32.u_synth_top.s1_hits\[9\]
+ sky130_fd_sc_hd__dfxtp_2
XTAP_TAPCELL_ROW_89_1761 VGND VPWR sky130_fd_sc_hd__tapvpwrvgnd_1
XFILLER_81_307 VGND VGND VPWR VPWR sky130_fd_sc_hd__fill_1
XFILLER_19_253 VGND VGND VPWR VPWR sky130_fd_sc_hd__fill_2
X_13868_ clknet_leaf_22_clk net867 VGND VGND VPWR VPWR u_interface.u_gelu_fp32.u_synth_top.s2_dx\[4\]
+ sky130_fd_sc_hd__dfxtp_1
X_12819_ net777 net78 VGND VGND VPWR VPWR _00977_ sky130_fd_sc_hd__and2_1
X_13799_ clknet_leaf_25_clk _00809_ VGND VGND VPWR VPWR u_interface.u_gelu_fp32.u_synth_top.s3_mult\[17\]
+ sky130_fd_sc_hd__dfxtp_1
XFILLER_97_3 VGND VGND VPWR VPWR sky130_fd_sc_hd__decap_3
XFILLER_62_587 VGND VGND VPWR VPWR sky130_fd_sc_hd__fill_1
XFILLER_30_462 VPWR VGND VPWR VGND sky130_ef_sc_hd__decap_12
X_08010_ net816 u_interface.u_gelu_fp32.u_fp32_to_q16.round_bit _01541_ net301 _01871_
+ VGND VGND VPWR VPWR _00705_ sky130_fd_sc_hd__a221o_1
XPHY_EDGE_ROW_7_Left_163 VGND VGND VPWR VPWR sky130_fd_sc_hd__decap_3
XTAP_TAPCELL_ROW_41_991 VGND VPWR sky130_fd_sc_hd__tapvpwrvgnd_1
XFILLER_128_361 VGND VGND VPWR VPWR sky130_fd_sc_hd__decap_3
Xhold603 u_interface.fifo_data\[11\]\[0\] VGND VGND VPWR VPWR net1468 sky130_fd_sc_hd__dlygate4sd3_1
Xhold625 _01009_ VGND VGND VPWR VPWR net1490 sky130_fd_sc_hd__dlygate4sd3_1
Xhold614 u_interface.fifo_data\[3\]\[22\] VGND VGND VPWR VPWR net1479 sky130_fd_sc_hd__dlygate4sd3_1
XTAP_TAPCELL_ROW_133_2471 VGND VPWR sky130_fd_sc_hd__tapvpwrvgnd_1
XTAP_TAPCELL_ROW_133_2460 VGND VPWR sky130_fd_sc_hd__tapvpwrvgnd_1
XFILLER_128_383 VGND VGND VPWR VPWR sky130_fd_sc_hd__decap_8
XFILLER_116_545 VGND VGND VPWR VPWR sky130_fd_sc_hd__fill_2
Xhold636 _00905_ VGND VGND VPWR VPWR net1501 sky130_fd_sc_hd__dlygate4sd3_1
Xhold658 u_interface.fifo_data\[7\]\[22\] VGND VGND VPWR VPWR net1523 sky130_fd_sc_hd__dlygate4sd3_1
XFILLER_116_589 VPWR VGND VPWR VGND sky130_ef_sc_hd__decap_12
XFILLER_104_718 VGND VGND VPWR VPWR sky130_fd_sc_hd__fill_1
X_09961_ _03595_ _03601_ _03602_ VGND VGND VPWR VPWR _03714_ sky130_fd_sc_hd__a21bo_1
Xhold669 u_interface.u_gelu_fp32.u_q16_to_fp32.s3_exp\[2\] VGND VGND VPWR VPWR net1534
+ sky130_fd_sc_hd__dlygate4sd3_1
Xhold647 u_interface.fifo_data\[11\]\[6\] VGND VGND VPWR VPWR net1512 sky130_fd_sc_hd__dlygate4sd3_1
X_08912_ _02663_ _02670_ VGND VGND VPWR VPWR _02671_ sky130_fd_sc_hd__xnor2_1
XFILLER_134_29 VGND VGND VPWR VPWR sky130_fd_sc_hd__decap_4
XFILLER_131_559 VGND VGND VPWR VPWR sky130_fd_sc_hd__fill_1
X_09892_ _03635_ _03642_ _03643_ VGND VGND VPWR VPWR _03645_ sky130_fd_sc_hd__nand3_2
X_08843_ _02600_ _02601_ VGND VGND VPWR VPWR _02602_ sky130_fd_sc_hd__or2_1
XFILLER_112_773 VPWR VGND VPWR VGND sky130_ef_sc_hd__decap_12
XFILLER_84_101 VGND VGND VPWR VPWR sky130_fd_sc_hd__fill_1
X_08774_ _02526_ _02532_ VGND VGND VPWR VPWR _02533_ sky130_fd_sc_hd__and2b_1
XFILLER_57_337 VPWR VGND VPWR VGND sky130_ef_sc_hd__decap_12
XFILLER_27_27 VPWR VGND VPWR VGND sky130_ef_sc_hd__decap_12
X_07725_ net386 _01772_ _01773_ VGND VGND VPWR VPWR _00517_ sky130_fd_sc_hd__or3_1
XFILLER_66_882 VGND VGND VPWR VPWR sky130_fd_sc_hd__fill_1
XFILLER_26_713 VPWR VGND VPWR VGND sky130_ef_sc_hd__decap_12
XFILLER_81_841 VGND VGND VPWR VPWR sky130_fd_sc_hd__fill_2
XTAP_TAPCELL_ROW_0_322 VGND VPWR sky130_fd_sc_hd__tapvpwrvgnd_1
XTAP_TAPCELL_ROW_0_333 VGND VPWR sky130_fd_sc_hd__tapvpwrvgnd_1
XFILLER_26_757 VPWR VGND VPWR VGND sky130_ef_sc_hd__decap_12
X_07656_ _01739_ _01732_ _01726_ _01719_ net333 net330 VGND VGND VPWR VPWR _01740_
+ sky130_fd_sc_hd__mux4_1
X_07587_ net308 _01658_ VGND VGND VPWR VPWR _01690_ sky130_fd_sc_hd__and2_1
X_06607_ u_interface.u_gelu_fp32.u_synth_top.s1_hits\[8\] _01183_ VGND VGND VPWR VPWR
+ _01185_ sky130_fd_sc_hd__or2_1
XFILLER_80_362 VGND VGND VPWR VPWR sky130_fd_sc_hd__fill_2
XFILLER_43_15 VPWR VGND VPWR VGND sky130_ef_sc_hd__decap_12
X_09326_ _03055_ _03075_ _03083_ VGND VGND VPWR VPWR _03085_ sky130_fd_sc_hd__nand3_1
XFILLER_139_604 VPWR VGND VPWR VGND sky130_ef_sc_hd__decap_12
X_06538_ net536 u_interface.u_gelu_fp32.s1_data\[30\] u_interface.u_gelu_fp32.s1_data\[29\]
+ u_interface.u_gelu_fp32.s1_data\[28\] VGND VGND VPWR VPWR _01135_ sky130_fd_sc_hd__or4_1
X_09257_ net591 net501 net506 net597 VGND VGND VPWR VPWR _03016_ sky130_fd_sc_hd__a22oi_2
XFILLER_126_309 VGND VGND VPWR VPWR sky130_fd_sc_hd__decap_6
X_08208_ net289 _02039_ VGND VGND VPWR VPWR _00735_ sky130_fd_sc_hd__nor2_1
XFILLER_154_629 VGND VGND VPWR VPWR sky130_fd_sc_hd__fill_2
X_09188_ _02904_ _02918_ _02946_ VGND VGND VPWR VPWR _02947_ sky130_fd_sc_hd__nand3_1
XFILLER_147_670 VGND VGND VPWR VPWR sky130_fd_sc_hd__fill_2
XFILLER_119_350 VPWR VGND VPWR VGND sky130_ef_sc_hd__decap_12
XFILLER_5_617 VPWR VGND VPWR VGND sky130_ef_sc_hd__decap_12
X_08139_ net291 _01981_ VGND VGND VPWR VPWR _00724_ sky130_fd_sc_hd__nor2_1
XFILLER_135_876 VGND VGND VPWR VPWR sky130_fd_sc_hd__fill_2
XFILLER_108_41 VPWR VGND VPWR VGND sky130_ef_sc_hd__decap_12
X_11150_ _04810_ _04892_ VGND VGND VPWR VPWR _04893_ sky130_fd_sc_hd__xnor2_1
XTAP_TAPCELL_ROW_56_1237 VGND VPWR sky130_fd_sc_hd__tapvpwrvgnd_1
XTAP_TAPCELL_ROW_56_1226 VGND VPWR sky130_fd_sc_hd__tapvpwrvgnd_1
XFILLER_134_386 VGND VGND VPWR VPWR sky130_fd_sc_hd__decap_6
X_10101_ _03850_ _03852_ _03730_ _03732_ VGND VGND VPWR VPWR _03853_ sky130_fd_sc_hd__a211oi_1
X_11081_ _04812_ _04822_ VGND VGND VPWR VPWR _04824_ sky130_fd_sc_hd__xor2_1
XTAP_TAPCELL_ROW_8_466 VGND VPWR sky130_fd_sc_hd__tapvpwrvgnd_1
XFILLER_0_333 VGND VGND VPWR VPWR sky130_fd_sc_hd__decap_3
X_10032_ _03754_ _03781_ _03782_ VGND VGND VPWR VPWR _03784_ sky130_fd_sc_hd__nand3_2
XFILLER_0_377 VPWR VGND VPWR VGND sky130_ef_sc_hd__decap_12
XFILLER_1_889 VGND VGND VPWR VPWR sky130_fd_sc_hd__decap_6
XFILLER_102_283 VPWR VGND VPWR VGND sky130_ef_sc_hd__decap_12
XFILLER_48_337 VPWR VGND VPWR VGND sky130_ef_sc_hd__decap_12
X_13722_ clknet_leaf_7_clk _00732_ VGND VGND VPWR VPWR u_interface.u_gelu_fp32.s1_data\[22\]
+ sky130_fd_sc_hd__dfxtp_1
XFILLER_90_115 VGND VGND VPWR VPWR sky130_fd_sc_hd__fill_1
XFILLER_29_595 VPWR VGND VPWR VGND sky130_ef_sc_hd__decap_12
X_11983_ _05714_ _05715_ VGND VGND VPWR VPWR _05717_ sky130_fd_sc_hd__xor2_1
XFILLER_90_148 VGND VGND VPWR VPWR sky130_fd_sc_hd__decap_4
X_10934_ net388 net215 VGND VGND VPWR VPWR _04678_ sky130_fd_sc_hd__xnor2_1
XTAP_TAPCELL_ROW_27_763 VGND VPWR sky130_fd_sc_hd__tapvpwrvgnd_1
X_13653_ clknet_leaf_20_clk _00663_ VGND VGND VPWR VPWR u_interface.u_gelu_fp32.u_fp32_to_q16.s1_sign
+ sky130_fd_sc_hd__dfxtp_1
XTAP_TAPCELL_ROW_84_1680 VGND VPWR sky130_fd_sc_hd__tapvpwrvgnd_1
X_10865_ _04609_ _04608_ VGND VGND VPWR VPWR _04610_ sky130_fd_sc_hd__and2b_1
XFILLER_16_289 VGND VGND VPWR VPWR sky130_fd_sc_hd__fill_2
XFILLER_17_93 VPWR VGND VPWR VGND sky130_ef_sc_hd__decap_12
XTAP_TAPCELL_ROW_27_774 VGND VPWR sky130_fd_sc_hd__tapvpwrvgnd_1
XFILLER_32_749 VGND VGND VPWR VPWR sky130_fd_sc_hd__decap_6
X_12604_ u_interface.u_gelu_fp32.u_q16_to_fp32.s1_mag\[15\] net211 _06303_ u_interface.u_gelu_fp32.u_q16_to_fp32.s1_mag\[31\]
+ VGND VGND VPWR VPWR _06307_ sky130_fd_sc_hd__a211oi_1
X_13584_ clknet_leaf_71_clk _00594_ VGND VGND VPWR VPWR u_interface.fifo_data\[4\]\[31\]
+ sky130_fd_sc_hd__dfxtp_1
XFILLER_31_237 VGND VGND VPWR VPWR sky130_fd_sc_hd__fill_2
X_10796_ _04541_ VGND VGND VPWR VPWR _04542_ sky130_fd_sc_hd__inv_2
X_12535_ _06258_ _06257_ VGND VGND VPWR VPWR _06259_ sky130_fd_sc_hd__and2b_1
XFILLER_12_473 VGND VGND VPWR VPWR sky130_fd_sc_hd__decap_3
XFILLER_40_782 VGND VGND VPWR VPWR sky130_fd_sc_hd__decap_3
XFILLER_145_607 VGND VGND VPWR VPWR sky130_fd_sc_hd__decap_3
XFILLER_129_147 VPWR VGND VPWR VGND sky130_ef_sc_hd__decap_12
XFILLER_33_92 VPWR VGND VPWR VGND sky130_ef_sc_hd__decap_12
XFILLER_40_793 VGND VGND VPWR VPWR sky130_fd_sc_hd__decap_4
XFILLER_129_169 VGND VGND VPWR VPWR sky130_fd_sc_hd__decap_8
XFILLER_8_477 VPWR VGND VPWR VGND sky130_ef_sc_hd__decap_12
X_12466_ _06081_ _06191_ VGND VGND VPWR VPWR _06192_ sky130_fd_sc_hd__and2_1
X_11417_ _05148_ _05156_ VGND VGND VPWR VPWR _05157_ sky130_fd_sc_hd__xnor2_1
X_12397_ _06111_ _06113_ VGND VGND VPWR VPWR _06124_ sky130_fd_sc_hd__nand2_1
X_14136_ clknet_leaf_31_clk _01062_ VGND VGND VPWR VPWR u_interface.fifo_count\[3\]
+ sky130_fd_sc_hd__dfxtp_1
XFILLER_125_353 VGND VGND VPWR VPWR sky130_fd_sc_hd__fill_1
XFILLER_99_716 VGND VGND VPWR VPWR sky130_fd_sc_hd__decap_8
X_11348_ _05087_ _05088_ VGND VGND VPWR VPWR _05089_ sky130_fd_sc_hd__nand2_1
XFILLER_113_537 VPWR VGND VPWR VGND sky130_ef_sc_hd__decap_12
X_11279_ _05018_ _05020_ VGND VGND VPWR VPWR _05021_ sky130_fd_sc_hd__or2_1
X_14067_ clknet_leaf_82_clk _00993_ VGND VGND VPWR VPWR u_interface.u_gelu_fp32.u_q16_to_fp32.s1_sign
+ sky130_fd_sc_hd__dfxtp_1
XFILLER_3_193 VPWR VGND VPWR VGND sky130_ef_sc_hd__decap_12
XFILLER_121_570 VGND VGND VPWR VPWR sky130_fd_sc_hd__fill_2
XFILLER_100_209 VGND VGND VPWR VPWR sky130_fd_sc_hd__fill_2
X_13018_ net170 net165 net161 net160 net151 VGND VGND VPWR VPWR _00845_ sky130_fd_sc_hd__o2111a_1
XFILLER_94_421 VPWR VGND VPWR VGND sky130_ef_sc_hd__decap_12
XFILLER_66_134 VGND VGND VPWR VPWR sky130_fd_sc_hd__decap_6
XFILLER_12_3 VPWR VGND VPWR VGND sky130_ef_sc_hd__decap_12
XFILLER_39_337 VPWR VGND VPWR VGND sky130_ef_sc_hd__decap_12
XFILLER_94_465 VGND VGND VPWR VPWR sky130_fd_sc_hd__fill_2
X_07510_ _01593_ _01572_ net552 VGND VGND VPWR VPWR _01641_ sky130_fd_sc_hd__mux2_1
XFILLER_81_148 VGND VGND VPWR VPWR sky130_fd_sc_hd__fill_2
XFILLER_63_874 VGND VGND VPWR VPWR sky130_fd_sc_hd__decap_3
X_08490_ net523 u_interface.u_gelu_fp32.u_synth_top.s3_mult\[46\] VGND VGND VPWR VPWR
+ _02281_ sky130_fd_sc_hd__xnor2_1
X_07441_ _01575_ net553 VGND VGND VPWR VPWR _01576_ sky130_fd_sc_hd__nand2b_1
XFILLER_23_727 VGND VGND VPWR VPWR sky130_fd_sc_hd__fill_1
X_07372_ net1481 net375 net238 VGND VGND VPWR VPWR _00402_ sky130_fd_sc_hd__mux2_1
XFILLER_22_226 VGND VGND VPWR VPWR sky130_fd_sc_hd__fill_2
XFILLER_22_237 VPWR VGND VPWR VGND sky130_ef_sc_hd__decap_12
X_09111_ _02859_ _02860_ _02854_ VGND VGND VPWR VPWR _02870_ sky130_fd_sc_hd__a21oi_1
XTAP_TAPCELL_ROW_118_2219 VGND VPWR sky130_fd_sc_hd__tapvpwrvgnd_1
XTAP_TAPCELL_ROW_135_2500 VGND VPWR sky130_fd_sc_hd__tapvpwrvgnd_1
X_09042_ _02781_ _02782_ _02799_ VGND VGND VPWR VPWR _02801_ sky130_fd_sc_hd__or3_1
XFILLER_108_309 VGND VGND VPWR VPWR sky130_fd_sc_hd__decap_6
XFILLER_30_292 VGND VGND VPWR VPWR sky130_fd_sc_hd__decap_8
Xhold400 u_interface.u_gelu_fp32.u_fp32_to_q16.s3_frac\[17\] VGND VGND VPWR VPWR net1265
+ sky130_fd_sc_hd__dlygate4sd3_1
Xhold411 u_interface.fifo_data\[6\]\[1\] VGND VGND VPWR VPWR net1276 sky130_fd_sc_hd__dlygate4sd3_1
Xhold422 u_interface.fifo_data\[14\]\[10\] VGND VGND VPWR VPWR net1287 sky130_fd_sc_hd__dlygate4sd3_1
XFILLER_145_17 VGND VGND VPWR VPWR sky130_fd_sc_hd__decap_4
XFILLER_144_651 VGND VGND VPWR VPWR sky130_fd_sc_hd__fill_1
XFILLER_117_876 VGND VGND VPWR VPWR sky130_fd_sc_hd__decap_8
Xhold444 u_interface.fifo_data\[11\]\[11\] VGND VGND VPWR VPWR net1309 sky130_fd_sc_hd__dlygate4sd3_1
Xhold433 u_interface.fifo_data\[15\]\[31\] VGND VGND VPWR VPWR net1298 sky130_fd_sc_hd__dlygate4sd3_1
Xmax_cap174 _03405_ VGND VGND VPWR VPWR net174 sky130_fd_sc_hd__clkbuf_1
XFILLER_89_215 VGND VGND VPWR VPWR sky130_fd_sc_hd__decap_8
Xhold466 u_interface.fifo_data\[13\]\[5\] VGND VGND VPWR VPWR net1331 sky130_fd_sc_hd__dlygate4sd3_1
Xhold455 u_interface.fifo_data\[8\]\[8\] VGND VGND VPWR VPWR net1320 sky130_fd_sc_hd__dlygate4sd3_1
Xhold477 u_interface.fifo_data\[13\]\[3\] VGND VGND VPWR VPWR net1342 sky130_fd_sc_hd__dlygate4sd3_1
Xhold488 u_interface.fifo_data\[1\]\[19\] VGND VGND VPWR VPWR net1353 sky130_fd_sc_hd__dlygate4sd3_1
X_09944_ _03693_ _03694_ _03695_ VGND VGND VPWR VPWR _03697_ sky130_fd_sc_hd__nand3_1
Xhold499 u_interface.fifo_data\[0\]\[9\] VGND VGND VPWR VPWR net1364 sky130_fd_sc_hd__dlygate4sd3_1
XFILLER_100_710 VPWR VGND VPWR VGND sky130_ef_sc_hd__decap_12
XFILLER_98_793 VGND VGND VPWR VPWR sky130_fd_sc_hd__decap_3
X_09875_ _03530_ _03628_ VGND VGND VPWR VPWR _03629_ sky130_fd_sc_hd__xor2_1
XTAP_TAPCELL_ROW_5_414 VGND VPWR sky130_fd_sc_hd__tapvpwrvgnd_1
XFILLER_38_15 VPWR VGND VPWR VGND sky130_ef_sc_hd__decap_12
X_08826_ net646 net503 net509 net655 VGND VGND VPWR VPWR _02585_ sky130_fd_sc_hd__a22o_1
XFILLER_97_281 VPWR VGND VPWR VGND sky130_ef_sc_hd__decap_12
XFILLER_57_123 VPWR VGND VPWR VGND sky130_ef_sc_hd__decap_12
XTAP_TAPCELL_ROW_51_1156 VGND VPWR sky130_fd_sc_hd__tapvpwrvgnd_1
XTAP_TAPCELL_ROW_51_1145 VGND VPWR sky130_fd_sc_hd__tapvpwrvgnd_1
XFILLER_38_37 VGND VGND VPWR VPWR sky130_fd_sc_hd__fill_1
XTAP_TAPCELL_ROW_146_2673 VGND VPWR sky130_fd_sc_hd__tapvpwrvgnd_1
X_08757_ _02509_ _02514_ _02515_ VGND VGND VPWR VPWR _02516_ sky130_fd_sc_hd__nand3_2
XFILLER_73_638 VGND VGND VPWR VPWR sky130_fd_sc_hd__fill_1
X_08688_ _02445_ _02446_ VGND VGND VPWR VPWR _02447_ sky130_fd_sc_hd__nor2_1
X_07708_ u_interface.u_gelu_fp32.u_synth_top.s1_hits\[11\] net1753 _01767_ VGND VGND
+ VPWR VPWR _00506_ sky130_fd_sc_hd__or3_1
XFILLER_26_565 VGND VGND VPWR VPWR sky130_fd_sc_hd__fill_1
XFILLER_81_682 VPWR VGND VPWR VGND sky130_ef_sc_hd__decap_12
X_07639_ _01726_ _01719_ _01711_ _01704_ net333 net330 VGND VGND VPWR VPWR _01727_
+ sky130_fd_sc_hd__mux4_1
XFILLER_53_373 VGND VGND VPWR VPWR sky130_fd_sc_hd__decap_8
XFILLER_26_587 VGND VGND VPWR VPWR sky130_fd_sc_hd__fill_1
X_10650_ _04393_ _04396_ VGND VGND VPWR VPWR _04397_ sky130_fd_sc_hd__xnor2_1
XFILLER_13_237 VGND VGND VPWR VPWR sky130_fd_sc_hd__decap_8
XFILLER_14_749 VGND VGND VPWR VPWR sky130_fd_sc_hd__decap_6
XTAP_TAPCELL_ROW_24_722 VGND VPWR sky130_fd_sc_hd__tapvpwrvgnd_1
X_09309_ _03066_ _03067_ _03035_ VGND VGND VPWR VPWR _03068_ sky130_fd_sc_hd__and3b_1
XFILLER_139_456 VGND VGND VPWR VPWR sky130_fd_sc_hd__fill_1
XFILLER_70_46 VPWR VGND VPWR VGND sky130_ef_sc_hd__decap_12
X_10581_ _04326_ _04327_ VGND VGND VPWR VPWR _04328_ sky130_fd_sc_hd__and2_1
XFILLER_22_793 VPWR VGND VPWR VGND sky130_ef_sc_hd__decap_12
XFILLER_70_79 VGND VGND VPWR VPWR sky130_fd_sc_hd__decap_4
XFILLER_21_292 VGND VGND VPWR VPWR sky130_fd_sc_hd__decap_8
X_12320_ _06046_ _06047_ VGND VGND VPWR VPWR _06049_ sky130_fd_sc_hd__xor2_1
XFILLER_126_139 VGND VGND VPWR VPWR sky130_fd_sc_hd__fill_1
X_12251_ _05877_ _05913_ _05912_ VGND VGND VPWR VPWR _05981_ sky130_fd_sc_hd__a21oi_1
XFILLER_108_865 VGND VGND VPWR VPWR sky130_fd_sc_hd__decap_3
X_11202_ _04926_ _04941_ _04942_ VGND VGND VPWR VPWR _04944_ sky130_fd_sc_hd__nor3_1
XFILLER_150_632 VPWR VGND VPWR VGND sky130_ef_sc_hd__decap_12
XFILLER_134_161 VGND VGND VPWR VPWR sky130_fd_sc_hd__decap_8
XFILLER_79_55 VGND VGND VPWR VPWR sky130_fd_sc_hd__fill_1
X_12182_ _05910_ _05911_ VGND VGND VPWR VPWR _05913_ sky130_fd_sc_hd__xnor2_1
XPHY_EDGE_ROW_79_Left_235 VGND VGND VPWR VPWR sky130_fd_sc_hd__decap_3
X_11133_ _04874_ _04875_ VGND VGND VPWR VPWR _04876_ sky130_fd_sc_hd__nand2_1
XFILLER_0_130 VGND VGND VPWR VPWR sky130_fd_sc_hd__decap_8
XFILLER_1_653 VPWR VGND VPWR VGND sky130_ef_sc_hd__decap_12
X_11064_ _04716_ _04718_ _04806_ VGND VGND VPWR VPWR _04807_ sky130_fd_sc_hd__and3_1
XFILLER_0_141 VPWR VGND VPWR VGND sky130_ef_sc_hd__decap_12
XFILLER_135_94 VGND VGND VPWR VPWR sky130_fd_sc_hd__fill_1
X_10015_ _03765_ _03766_ _03761_ VGND VGND VPWR VPWR _03767_ sky130_fd_sc_hd__a21o_1
XFILLER_76_421 VGND VGND VPWR VPWR sky130_fd_sc_hd__fill_1
XFILLER_1_697 VPWR VGND VPWR VGND sky130_ef_sc_hd__decap_12
XFILLER_95_76 VGND VGND VPWR VPWR sky130_fd_sc_hd__fill_1
XFILLER_36_307 VGND VGND VPWR VPWR sky130_fd_sc_hd__fill_1
XTAP_TAPCELL_ROW_69_1439 VGND VPWR sky130_fd_sc_hd__tapvpwrvgnd_1
XFILLER_63_159 VGND VGND VPWR VPWR sky130_fd_sc_hd__fill_2
XFILLER_63_148 VGND VGND VPWR VPWR sky130_fd_sc_hd__fill_1
X_11966_ _05697_ _05698_ VGND VGND VPWR VPWR _05700_ sky130_fd_sc_hd__xnor2_1
X_13705_ clknet_leaf_22_clk _00715_ VGND VGND VPWR VPWR u_interface.u_gelu_fp32.s1_data\[5\]
+ sky130_fd_sc_hd__dfxtp_1
XPHY_EDGE_ROW_88_Left_244 VGND VGND VPWR VPWR sky130_fd_sc_hd__decap_3
X_10917_ _04557_ _04659_ _04660_ VGND VGND VPWR VPWR _04662_ sky130_fd_sc_hd__or3_1
XFILLER_44_362 VGND VGND VPWR VPWR sky130_fd_sc_hd__fill_2
X_13636_ clknet_leaf_42_clk _00646_ VGND VGND VPWR VPWR u_interface.fifo_data\[13\]\[19\]
+ sky130_fd_sc_hd__dfxtp_1
XFILLER_71_181 VGND VGND VPWR VPWR sky130_fd_sc_hd__decap_4
XFILLER_44_80 VGND VGND VPWR VPWR sky130_fd_sc_hd__decap_4
X_11897_ _05566_ _05631_ VGND VGND VPWR VPWR _05632_ sky130_fd_sc_hd__and2_1
X_10848_ _04590_ _04591_ _04507_ _04509_ VGND VGND VPWR VPWR _04593_ sky130_fd_sc_hd__o211a_1
X_13567_ clknet_leaf_43_clk _00577_ VGND VGND VPWR VPWR u_interface.fifo_data\[4\]\[14\]
+ sky130_fd_sc_hd__dfxtp_1
X_10779_ _04519_ _04522_ _04523_ VGND VGND VPWR VPWR _04525_ sky130_fd_sc_hd__nand3_2
XFILLER_9_753 VPWR VGND VPWR VGND sky130_ef_sc_hd__decap_12
X_13498_ clknet_leaf_3_clk _00508_ VGND VGND VPWR VPWR u_interface.u_gelu_fp32.u_synth_top.s2_m\[13\]
+ sky130_fd_sc_hd__dfxtp_2
X_12518_ _06240_ _06241_ VGND VGND VPWR VPWR _06243_ sky130_fd_sc_hd__nor2_1
XFILLER_60_90 VGND VGND VPWR VPWR sky130_fd_sc_hd__decap_3
XFILLER_9_797 VPWR VGND VPWR VGND sky130_ef_sc_hd__decap_12
X_12449_ _06056_ _06057_ _06119_ VGND VGND VPWR VPWR _06176_ sky130_fd_sc_hd__or3_1
XFILLER_114_813 VGND VGND VPWR VPWR sky130_fd_sc_hd__decap_4
XTAP_TAPCELL_ROW_113_2149 VGND VPWR sky130_fd_sc_hd__tapvpwrvgnd_1
XTAP_TAPCELL_ROW_113_2138 VGND VPWR sky130_fd_sc_hd__tapvpwrvgnd_1
XTAP_TAPCELL_ROW_97_1893 VGND VPWR sky130_fd_sc_hd__tapvpwrvgnd_1
XTAP_TAPCELL_ROW_97_1882 VGND VPWR sky130_fd_sc_hd__tapvpwrvgnd_1
XTAP_TAPCELL_ROW_10_493 VGND VPWR sky130_fd_sc_hd__tapvpwrvgnd_1
XPHY_EDGE_ROW_97_Left_253 VGND VGND VPWR VPWR sky130_fd_sc_hd__decap_3
X_14119_ clknet_leaf_31_clk _01045_ VGND VGND VPWR VPWR u_interface.fifo_rd_ptr\[0\]
+ sky130_fd_sc_hd__dfxtp_1
Xfanout209 net210 VGND VGND VPWR VPWR net209 sky130_fd_sc_hd__buf_4
X_07990_ net814 net1585 net301 _01691_ _01857_ VGND VGND VPWR VPWR _00699_ sky130_fd_sc_hd__a221o_1
XFILLER_141_698 VGND VGND VPWR VPWR sky130_fd_sc_hd__fill_2
XFILLER_141_687 VGND VGND VPWR VPWR sky130_fd_sc_hd__fill_2
XFILLER_86_218 VGND VGND VPWR VPWR sky130_fd_sc_hd__decap_4
X_06941_ u_interface.u_gelu_fp32.u_synth_top.s1_x\[24\] net275 _01472_ VGND VGND VPWR
+ VPWR _01474_ sky130_fd_sc_hd__a21o_1
XFILLER_140_186 VGND VGND VPWR VPWR sky130_fd_sc_hd__fill_1
X_09660_ _03315_ _03317_ _03413_ _03414_ VGND VGND VPWR VPWR _03416_ sky130_fd_sc_hd__a211oi_1
XFILLER_95_752 VGND VGND VPWR VPWR sky130_fd_sc_hd__decap_4
XFILLER_79_281 VPWR VGND VPWR VGND sky130_ef_sc_hd__decap_12
XFILLER_67_432 VGND VGND VPWR VPWR sky130_fd_sc_hd__fill_2
XTAP_TAPCELL_ROW_128_2381 VGND VPWR sky130_fd_sc_hd__tapvpwrvgnd_1
X_06872_ net321 _01416_ net726 VGND VGND VPWR VPWR _01417_ sky130_fd_sc_hd__o21a_1
X_08611_ _02234_ _02235_ VGND VGND VPWR VPWR _02389_ sky130_fd_sc_hd__xnor2_1
XFILLER_67_465 VGND VGND VPWR VPWR sky130_fd_sc_hd__fill_1
XFILLER_27_307 VGND VGND VPWR VPWR sky130_fd_sc_hd__fill_1
XFILLER_39_167 VGND VGND VPWR VPWR sky130_fd_sc_hd__fill_1
X_09591_ net455 net459 net607 net612 VGND VGND VPWR VPWR _03347_ sky130_fd_sc_hd__and4_1
XFILLER_55_638 VGND VGND VPWR VPWR sky130_fd_sc_hd__decap_6
XFILLER_48_690 VGND VGND VPWR VPWR sky130_fd_sc_hd__decap_8
XFILLER_39_178 VGND VGND VPWR VPWR sky130_fd_sc_hd__decap_4
X_08542_ _02266_ _02274_ _02285_ VGND VGND VPWR VPWR _02333_ sky130_fd_sc_hd__o21ba_1
XTAP_TAPCELL_ROW_141_2592 VGND VPWR sky130_fd_sc_hd__tapvpwrvgnd_1
XFILLER_63_682 VGND VGND VPWR VPWR sky130_fd_sc_hd__fill_2
X_08473_ _02263_ VGND VGND VPWR VPWR _02264_ sky130_fd_sc_hd__inv_2
XFILLER_23_513 VGND VGND VPWR VPWR sky130_fd_sc_hd__decap_3
X_07424_ _01549_ _01559_ net549 VGND VGND VPWR VPWR _01560_ sky130_fd_sc_hd__mux2_1
X_07355_ net344 net1586 net242 VGND VGND VPWR VPWR _00385_ sky130_fd_sc_hd__mux2_1
X_07286_ net1332 net354 net246 VGND VGND VPWR VPWR _00316_ sky130_fd_sc_hd__mux2_1
XFILLER_40_27 VGND VGND VPWR VPWR sky130_fd_sc_hd__fill_1
XFILLER_152_908 VGND VGND VPWR VPWR sky130_fd_sc_hd__decap_4
X_09025_ _02746_ _02747_ VGND VGND VPWR VPWR _02784_ sky130_fd_sc_hd__xor2_1
XFILLER_117_662 VGND VGND VPWR VPWR sky130_fd_sc_hd__fill_1
Xhold241 u_interface.fifo_data\[12\]\[16\] VGND VGND VPWR VPWR net1106 sky130_fd_sc_hd__dlygate4sd3_1
XFILLER_144_481 VGND VGND VPWR VPWR sky130_fd_sc_hd__decap_6
Xhold252 u_interface.fifo_data\[1\]\[8\] VGND VGND VPWR VPWR net1117 sky130_fd_sc_hd__dlygate4sd3_1
Xhold230 u_interface.fifo_data\[9\]\[6\] VGND VGND VPWR VPWR net1095 sky130_fd_sc_hd__dlygate4sd3_1
XTAP_TAPCELL_ROW_148_2702 VGND VPWR sky130_fd_sc_hd__tapvpwrvgnd_1
Xhold296 u_interface.fifo_data\[4\]\[22\] VGND VGND VPWR VPWR net1161 sky130_fd_sc_hd__dlygate4sd3_1
Xhold263 u_interface.fifo_data\[9\]\[26\] VGND VGND VPWR VPWR net1128 sky130_fd_sc_hd__dlygate4sd3_1
XFILLER_104_356 VGND VGND VPWR VPWR sky130_fd_sc_hd__decap_8
Xhold285 u_interface.fifo_data\[13\]\[30\] VGND VGND VPWR VPWR net1150 sky130_fd_sc_hd__dlygate4sd3_1
Xhold274 u_interface.fifo_data\[0\]\[31\] VGND VGND VPWR VPWR net1139 sky130_fd_sc_hd__dlygate4sd3_1
Xfanout732 net737 VGND VGND VPWR VPWR net732 sky130_fd_sc_hd__clkbuf_4
X_09927_ _03567_ _03679_ VGND VGND VPWR VPWR _03680_ sky130_fd_sc_hd__nand2_1
Xfanout721 u_interface.u_gelu_fp32.u_synth_top.s2_m\[17\] VGND VGND VPWR VPWR net721
+ sky130_fd_sc_hd__clkbuf_2
Xfanout710 net716 VGND VGND VPWR VPWR net710 sky130_fd_sc_hd__clkbuf_2
Xfanout754 _00001_ VGND VGND VPWR VPWR net754 sky130_fd_sc_hd__clkbuf_4
Xfanout776 net777 VGND VGND VPWR VPWR net776 sky130_fd_sc_hd__clkbuf_2
Xfanout765 net771 VGND VGND VPWR VPWR net765 sky130_fd_sc_hd__buf_4
Xfanout743 net745 VGND VGND VPWR VPWR net743 sky130_fd_sc_hd__clkbuf_4
Xfanout787 net791 VGND VGND VPWR VPWR net787 sky130_fd_sc_hd__clkbuf_2
XFILLER_105_75 VPWR VGND VPWR VGND sky130_ef_sc_hd__decap_12
X_09858_ _03608_ _03609_ _03458_ _03460_ VGND VGND VPWR VPWR _03612_ sky130_fd_sc_hd__a211o_1
Xfanout798 net2 VGND VGND VPWR VPWR net798 sky130_fd_sc_hd__clkbuf_2
XTAP_TAPCELL_ROW_29_803 VGND VPWR sky130_fd_sc_hd__tapvpwrvgnd_1
X_08809_ net630 net496 VGND VGND VPWR VPWR _02568_ sky130_fd_sc_hd__nand2_1
X_09789_ net482 net681 _03432_ _03431_ VGND VGND VPWR VPWR _03543_ sky130_fd_sc_hd__a31o_1
XFILLER_65_57 VGND VGND VPWR VPWR sky130_fd_sc_hd__fill_1
XFILLER_65_35 VGND VGND VPWR VPWR sky130_fd_sc_hd__decap_3
XFILLER_46_649 VGND VGND VPWR VPWR sky130_fd_sc_hd__fill_1
XFILLER_45_137 VPWR VGND VPWR VGND sky130_ef_sc_hd__decap_12
X_11820_ _05488_ _05555_ VGND VGND VPWR VPWR _05556_ sky130_fd_sc_hd__xnor2_1
XFILLER_27_841 VPWR VGND VPWR VGND sky130_ef_sc_hd__decap_12
XFILLER_121_41 VGND VGND VPWR VPWR sky130_fd_sc_hd__fill_2
XFILLER_54_682 VGND VGND VPWR VPWR sky130_fd_sc_hd__fill_1
X_11751_ net193 _05475_ _05474_ VGND VGND VPWR VPWR _05487_ sky130_fd_sc_hd__a21o_1
XFILLER_26_351 VGND VGND VPWR VPWR sky130_fd_sc_hd__fill_1
X_10702_ _04326_ _04327_ _04446_ VGND VGND VPWR VPWR _04448_ sky130_fd_sc_hd__nand3_1
XTAP_TAPCELL_ROW_64_1358 VGND VPWR sky130_fd_sc_hd__tapvpwrvgnd_1
XFILLER_14_557 VPWR VGND VPWR VGND sky130_ef_sc_hd__decap_12
Xclkbuf_leaf_80_clk clknet_3_4__leaf_clk VGND VGND VPWR VPWR clknet_leaf_80_clk sky130_fd_sc_hd__clkbuf_8
XFILLER_41_310 VGND VGND VPWR VPWR sky130_fd_sc_hd__fill_1
X_11682_ _05417_ _05418_ _05333_ VGND VGND VPWR VPWR _05419_ sky130_fd_sc_hd__a21bo_1
X_13421_ clknet_leaf_18_clk _00431_ VGND VGND VPWR VPWR u_interface.u_gelu_fp32.u_fp32_to_q16.s3_frac\[1\]
+ sky130_fd_sc_hd__dfxtp_1
X_10633_ net626 net635 net433 net427 VGND VGND VPWR VPWR _04380_ sky130_fd_sc_hd__nand4_1
X_13352_ clknet_leaf_45_clk _00362_ VGND VGND VPWR VPWR u_interface.fifo_data\[10\]\[29\]
+ sky130_fd_sc_hd__dfxtp_1
X_10564_ _04309_ _04310_ VGND VGND VPWR VPWR _04312_ sky130_fd_sc_hd__xnor2_1
XFILLER_6_701 VPWR VGND VPWR VGND sky130_ef_sc_hd__decap_12
XFILLER_14_83 VGND VGND VPWR VPWR sky130_fd_sc_hd__fill_1
XFILLER_155_757 VGND VGND VPWR VPWR sky130_fd_sc_hd__fill_2
X_12303_ _06029_ _06030_ VGND VGND VPWR VPWR _06032_ sky130_fd_sc_hd__xnor2_1
X_13283_ clknet_leaf_49_clk _00293_ VGND VGND VPWR VPWR u_interface.fifo_data\[0\]\[25\]
+ sky130_fd_sc_hd__dfxtp_1
X_10495_ net461 net688 _04241_ _04242_ VGND VGND VPWR VPWR _04243_ sky130_fd_sc_hd__a22o_1
XFILLER_123_610 VGND VGND VPWR VPWR sky130_fd_sc_hd__decap_6
XFILLER_107_172 VGND VGND VPWR VPWR sky130_fd_sc_hd__fill_1
X_12234_ _05962_ _05963_ VGND VGND VPWR VPWR _05964_ sky130_fd_sc_hd__xnor2_1
XFILLER_150_440 VPWR VGND VPWR VGND sky130_ef_sc_hd__decap_12
XFILLER_146_82 VGND VGND VPWR VPWR sky130_fd_sc_hd__fill_2
X_12165_ net693 net390 _05894_ VGND VGND VPWR VPWR _05896_ sky130_fd_sc_hd__and3_1
XFILLER_68_229 VGND VGND VPWR VPWR sky130_fd_sc_hd__fill_2
X_11116_ _04852_ _04857_ VGND VGND VPWR VPWR _04859_ sky130_fd_sc_hd__xor2_1
XFILLER_1_461 VPWR VGND VPWR VGND sky130_ef_sc_hd__decap_12
X_12096_ net692 net395 VGND VGND VPWR VPWR _05828_ sky130_fd_sc_hd__nand2_1
X_11047_ _04666_ _04672_ _04790_ VGND VGND VPWR VPWR _04791_ sky130_fd_sc_hd__a21oi_1
XFILLER_49_476 VPWR VGND VPWR VGND sky130_ef_sc_hd__decap_12
Xinput9 s_axil_araddr[15] VGND VGND VPWR VPWR net9 sky130_fd_sc_hd__clkbuf_1
XFILLER_76_273 VGND VGND VPWR VPWR sky130_fd_sc_hd__fill_1
X_12998_ net1116 net355 net222 VGND VGND VPWR VPWR _01081_ sky130_fd_sc_hd__mux2_1
XFILLER_45_671 VGND VGND VPWR VPWR sky130_fd_sc_hd__fill_1
Xclkbuf_leaf_71_clk clknet_3_5__leaf_clk VGND VGND VPWR VPWR clknet_leaf_71_clk sky130_fd_sc_hd__clkbuf_8
XFILLER_44_181 VGND VGND VPWR VPWR sky130_fd_sc_hd__decap_8
X_11949_ net675 net393 VGND VGND VPWR VPWR _05683_ sky130_fd_sc_hd__nand2_1
XFILLER_32_332 VPWR VGND VPWR VGND sky130_ef_sc_hd__decap_12
XFILLER_33_833 VGND VGND VPWR VPWR sky130_fd_sc_hd__decap_6
XFILLER_32_354 VGND VGND VPWR VPWR sky130_fd_sc_hd__decap_4
XFILLER_33_877 VPWR VGND VPWR VGND sky130_ef_sc_hd__decap_12
XTAP_TAPCELL_ROW_15_574 VGND VPWR sky130_fd_sc_hd__tapvpwrvgnd_1
X_13619_ clknet_leaf_74_clk _00629_ VGND VGND VPWR VPWR u_interface.fifo_data\[13\]\[2\]
+ sky130_fd_sc_hd__dfxtp_1
XTAP_TAPCELL_ROW_99_1922 VGND VPWR sky130_fd_sc_hd__tapvpwrvgnd_1
X_07140_ net1093 net361 net218 VGND VGND VPWR VPWR _00180_ sky130_fd_sc_hd__mux2_1
XFILLER_9_561 VPWR VGND VPWR VGND sky130_ef_sc_hd__decap_12
X_07071_ net1227 net341 net209 VGND VGND VPWR VPWR _00111_ sky130_fd_sc_hd__mux2_1
XFILLER_133_407 VGND VGND VPWR VPWR sky130_fd_sc_hd__fill_1
XFILLER_141_473 VPWR VGND VPWR VGND sky130_ef_sc_hd__decap_12
XFILLER_87_505 VGND VGND VPWR VPWR sky130_fd_sc_hd__decap_4
X_07973_ net780 net1265 _01848_ VGND VGND VPWR VPWR _00691_ sky130_fd_sc_hd__o21a_1
X_09712_ _03466_ VGND VGND VPWR VPWR _03467_ sky130_fd_sc_hd__inv_2
XFILLER_101_337 VPWR VGND VPWR VGND sky130_ef_sc_hd__decap_12
XFILLER_142_29 VGND VGND VPWR VPWR sky130_fd_sc_hd__decap_8
X_06924_ u_interface.u_gelu_fp32.u_synth_top.s1_x\[22\] net273 VGND VGND VPWR VPWR
+ _01460_ sky130_fd_sc_hd__nand2_1
XFILLER_19_39 VPWR VGND VPWR VGND sky130_ef_sc_hd__decap_12
X_06855_ net736 _01401_ VGND VGND VPWR VPWR _01402_ sky130_fd_sc_hd__or2_1
XTAP_TAPCELL_ROW_143_2621 VGND VPWR sky130_fd_sc_hd__tapvpwrvgnd_1
X_09643_ _03380_ _03396_ _03397_ VGND VGND VPWR VPWR _03399_ sky130_fd_sc_hd__or3_1
XFILLER_83_733 VGND VGND VPWR VPWR sky130_fd_sc_hd__fill_1
XFILLER_27_104 VGND VGND VPWR VPWR sky130_fd_sc_hd__fill_2
X_09574_ net477 net478 net656 net662 VGND VGND VPWR VPWR _03330_ sky130_fd_sc_hd__and4_1
XFILLER_82_221 VGND VGND VPWR VPWR sky130_fd_sc_hd__fill_1
X_06786_ u_interface.fifo_data\[4\]\[19\] u_interface.fifo_data\[5\]\[19\] u_interface.fifo_data\[6\]\[19\]
+ u_interface.fifo_data\[7\]\[19\] net767 net750 VGND VGND VPWR VPWR _01342_ sky130_fd_sc_hd__mux4_1
XFILLER_24_811 VGND VGND VPWR VPWR sky130_fd_sc_hd__fill_1
X_08525_ net524 u_interface.u_gelu_fp32.u_synth_top.s3_mult\[59\] _02160_ _02315_
+ _02311_ VGND VGND VPWR VPWR _02316_ sky130_fd_sc_hd__a221oi_4
XFILLER_35_27 VPWR VGND VPWR VGND sky130_ef_sc_hd__decap_12
XFILLER_42_118 VGND VGND VPWR VPWR sky130_fd_sc_hd__fill_1
Xclkbuf_leaf_62_clk clknet_3_5__leaf_clk VGND VGND VPWR VPWR clknet_leaf_62_clk sky130_fd_sc_hd__clkbuf_8
XFILLER_23_310 VGND VGND VPWR VPWR sky130_fd_sc_hd__fill_1
X_08456_ net527 u_interface.u_gelu_fp32.u_synth_top.s3_mult\[34\] VGND VGND VPWR VPWR
+ _02247_ sky130_fd_sc_hd__nor2_1
XTAP_TAPCELL_ROW_46_1077 VGND VPWR sky130_fd_sc_hd__tapvpwrvgnd_1
XTAP_TAPCELL_ROW_46_1066 VGND VPWR sky130_fd_sc_hd__tapvpwrvgnd_1
XFILLER_11_505 VPWR VGND VPWR VGND sky130_ef_sc_hd__decap_12
X_07407_ u_interface.u_gelu_fp32.u_fp32_to_q16.s2_norm_mag\[16\] u_interface.u_gelu_fp32.u_fp32_to_q16.s2_norm_mag\[17\]
+ net558 VGND VGND VPWR VPWR _01543_ sky130_fd_sc_hd__mux2_1
X_08387_ u_interface.u_gelu_fp32.u_synth_top.s3_mult\[31\] u_interface.u_gelu_fp32.u_synth_top.s3_b\[15\]
+ VGND VGND VPWR VPWR _02178_ sky130_fd_sc_hd__or2_1
XFILLER_51_15 VPWR VGND VPWR VGND sky130_ef_sc_hd__decap_12
XTAP_TAPCELL_ROW_34_872 VGND VPWR sky130_fd_sc_hd__tapvpwrvgnd_1
XTAP_TAPCELL_ROW_34_883 VGND VPWR sky130_fd_sc_hd__tapvpwrvgnd_1
XFILLER_149_551 VGND VGND VPWR VPWR sky130_fd_sc_hd__fill_2
X_07338_ net379 net1590 net241 VGND VGND VPWR VPWR _00368_ sky130_fd_sc_hd__mux2_1
XFILLER_137_735 VGND VGND VPWR VPWR sky130_fd_sc_hd__fill_2
XFILLER_136_201 VGND VGND VPWR VPWR sky130_fd_sc_hd__fill_1
XFILLER_109_437 VGND VGND VPWR VPWR sky130_fd_sc_hd__decap_8
X_07269_ net108 net788 net150 VGND VGND VPWR VPWR _00672_ sky130_fd_sc_hd__and3_1
XTAP_TAPCELL_ROW_154_2794 VGND VPWR sky130_fd_sc_hd__tapvpwrvgnd_1
X_09008_ _02715_ _02732_ _02731_ VGND VGND VPWR VPWR _02767_ sky130_fd_sc_hd__a21oi_1
XFILLER_124_429 VGND VGND VPWR VPWR sky130_fd_sc_hd__decap_3
X_10280_ _04015_ _04027_ _04028_ VGND VGND VPWR VPWR _04030_ sky130_fd_sc_hd__nor3_1
XFILLER_120_613 VPWR VGND VPWR VGND sky130_ef_sc_hd__decap_12
XFILLER_104_153 VGND VGND VPWR VPWR sky130_fd_sc_hd__decap_3
Xfanout551 u_interface.u_gelu_fp32.u_fp32_to_q16.s2_shift\[2\] VGND VGND VPWR VPWR
+ net551 sky130_fd_sc_hd__clkbuf_2
XFILLER_116_85 VGND VGND VPWR VPWR sky130_fd_sc_hd__decap_4
Xfanout540 net541 VGND VGND VPWR VPWR net540 sky130_fd_sc_hd__dlymetal6s2s_1
XFILLER_104_197 VGND VGND VPWR VPWR sky130_fd_sc_hd__decap_3
Xfanout584 net585 VGND VGND VPWR VPWR net584 sky130_fd_sc_hd__clkbuf_2
XFILLER_116_96 VGND VGND VPWR VPWR sky130_fd_sc_hd__decap_3
Xfanout573 u_interface.core_data_out\[25\] VGND VGND VPWR VPWR net573 sky130_fd_sc_hd__clkbuf_2
X_13970_ clknet_leaf_61_clk net1676 VGND VGND VPWR VPWR u_interface.u_gelu_fp32.u_q16_to_fp32.s2_mag\[15\]
+ sky130_fd_sc_hd__dfxtp_1
Xfanout562 u_interface.core_data_out\[31\] VGND VGND VPWR VPWR net562 sky130_fd_sc_hd__buf_1
XFILLER_19_605 VGND VGND VPWR VPWR sky130_fd_sc_hd__decap_8
X_12921_ _06446_ _06447_ _06441_ VGND VGND VPWR VPWR _06448_ sky130_fd_sc_hd__a21bo_1
Xfanout595 net596 VGND VGND VPWR VPWR net595 sky130_fd_sc_hd__buf_2
XFILLER_76_78 VGND VGND VPWR VPWR sky130_fd_sc_hd__fill_2
XFILLER_59_785 VGND VGND VPWR VPWR sky130_fd_sc_hd__fill_1
XFILLER_92_11 VGND VGND VPWR VPWR sky130_fd_sc_hd__fill_1
X_12852_ _06422_ _06432_ net820 VGND VGND VPWR VPWR _00996_ sky130_fd_sc_hd__a21oi_1
XFILLER_61_427 VGND VGND VPWR VPWR sky130_fd_sc_hd__decap_3
XFILLER_61_405 VGND VGND VPWR VPWR sky130_fd_sc_hd__decap_8
XFILLER_27_671 VGND VGND VPWR VPWR sky130_fd_sc_hd__fill_1
Xclkbuf_leaf_53_clk clknet_3_6__leaf_clk VGND VGND VPWR VPWR clknet_leaf_53_clk sky130_fd_sc_hd__clkbuf_8
X_12783_ u_interface.u_gelu_fp32.u_q16_to_fp32.s3_norm_mag\[20\] _01783_ net295 VGND
+ VGND VPWR VPWR _06408_ sky130_fd_sc_hd__o21ai_1
XFILLER_61_449 VGND VGND VPWR VPWR sky130_fd_sc_hd__fill_2
XFILLER_15_833 VGND VGND VPWR VPWR sky130_fd_sc_hd__decap_6
X_11803_ _05537_ _05538_ VGND VGND VPWR VPWR _05539_ sky130_fd_sc_hd__xnor2_1
X_11734_ _05468_ _05469_ VGND VGND VPWR VPWR _05471_ sky130_fd_sc_hd__xor2_1
XFILLER_15_877 VPWR VGND VPWR VGND sky130_ef_sc_hd__decap_12
XFILLER_25_93 VPWR VGND VPWR VGND sky130_ef_sc_hd__decap_12
XFILLER_30_825 VPWR VGND VPWR VGND sky130_ef_sc_hd__decap_12
X_11665_ net179 _05401_ VGND VGND VPWR VPWR _05402_ sky130_fd_sc_hd__nand2_1
X_13404_ clknet_leaf_26_clk _00414_ VGND VGND VPWR VPWR u_interface.fifo_data\[6\]\[17\]
+ sky130_fd_sc_hd__dfxtp_1
X_10616_ _04360_ _04361_ _04362_ VGND VGND VPWR VPWR _04363_ sky130_fd_sc_hd__a21oi_1
XTAP_TAPCELL_ROW_12_522 VGND VPWR sky130_fd_sc_hd__tapvpwrvgnd_1
XTAP_TAPCELL_ROW_12_533 VGND VPWR sky130_fd_sc_hd__tapvpwrvgnd_1
XFILLER_30_869 VPWR VGND VPWR VGND sky130_ef_sc_hd__decap_12
X_11596_ _05331_ _05332_ _05333_ VGND VGND VPWR VPWR _05334_ sky130_fd_sc_hd__or3_1
XFILLER_155_576 VGND VGND VPWR VPWR sky130_fd_sc_hd__fill_1
X_13335_ clknet_leaf_65_clk _00345_ VGND VGND VPWR VPWR u_interface.fifo_data\[10\]\[12\]
+ sky130_fd_sc_hd__dfxtp_1
X_10547_ _04276_ _04277_ _04293_ VGND VGND VPWR VPWR _04295_ sky130_fd_sc_hd__nand3_2
XFILLER_6_531 VGND VGND VPWR VPWR sky130_fd_sc_hd__fill_1
XFILLER_41_70 VGND VGND VPWR VPWR sky130_fd_sc_hd__decap_8
XFILLER_155_587 VGND VGND VPWR VPWR sky130_fd_sc_hd__fill_1
XFILLER_143_738 VGND VGND VPWR VPWR sky130_fd_sc_hd__decap_6
XTAP_TAPCELL_ROW_94_1841 VGND VPWR sky130_fd_sc_hd__tapvpwrvgnd_1
X_10478_ _04000_ _04225_ VGND VGND VPWR VPWR _04226_ sky130_fd_sc_hd__xnor2_4
X_13266_ clknet_leaf_72_clk _00276_ VGND VGND VPWR VPWR u_interface.fifo_data\[0\]\[8\]
+ sky130_fd_sc_hd__dfxtp_1
X_12217_ net199 _05945_ VGND VGND VPWR VPWR _05947_ sky130_fd_sc_hd__nor2_1
XFILLER_151_782 VGND VGND VPWR VPWR sky130_fd_sc_hd__fill_2
X_13197_ clknet_leaf_41_clk _00207_ VGND VGND VPWR VPWR u_interface.fifo_data\[12\]\[7\]
+ sky130_fd_sc_hd__dfxtp_1
XFILLER_111_613 VGND VGND VPWR VPWR sky130_fd_sc_hd__decap_3
XFILLER_110_123 VGND VGND VPWR VPWR sky130_fd_sc_hd__decap_8
XFILLER_2_781 VPWR VGND VPWR VGND sky130_ef_sc_hd__decap_12
X_12148_ net203 _05878_ VGND VGND VPWR VPWR _05879_ sky130_fd_sc_hd__nand2_1
XFILLER_110_145 VGND VGND VPWR VPWR sky130_fd_sc_hd__decap_6
XFILLER_96_357 VGND VGND VPWR VPWR sky130_fd_sc_hd__decap_3
XPHY_EDGE_ROW_10_Right_10 VGND VGND VPWR VPWR sky130_fd_sc_hd__decap_3
XFILLER_2_53 VPWR VGND VPWR VGND sky130_ef_sc_hd__decap_12
X_12079_ net203 _05746_ _05749_ VGND VGND VPWR VPWR _05811_ sky130_fd_sc_hd__and3_1
XFILLER_110_167 VPWR VGND VPWR VGND sky130_ef_sc_hd__decap_12
XFILLER_65_711 VGND VGND VPWR VPWR sky130_fd_sc_hd__fill_1
XPHY_EDGE_ROW_139_Right_139 VGND VGND VPWR VPWR sky130_fd_sc_hd__decap_3
XTAP_TAPCELL_ROW_125_2340 VGND VPWR sky130_fd_sc_hd__tapvpwrvgnd_1
XTAP_TAPCELL_ROW_108_2059 VGND VPWR sky130_fd_sc_hd__tapvpwrvgnd_1
X_06640_ net322 _01211_ net728 VGND VGND VPWR VPWR _01214_ sky130_fd_sc_hd__o21a_1
XFILLER_2_97 VPWR VGND VPWR VGND sky130_ef_sc_hd__decap_12
Xclkbuf_leaf_44_clk clknet_3_7__leaf_clk VGND VGND VPWR VPWR clknet_leaf_44_clk sky130_fd_sc_hd__clkbuf_8
X_06571_ _01156_ _01162_ _01106_ VGND VGND VPWR VPWR _01163_ sky130_fd_sc_hd__o21a_1
XFILLER_80_769 VGND VGND VPWR VPWR sky130_fd_sc_hd__fill_1
XFILLER_80_747 VGND VGND VPWR VPWR sky130_fd_sc_hd__decap_8
XFILLER_18_693 VGND VGND VPWR VPWR sky130_fd_sc_hd__decap_6
XFILLER_24_129 VGND VGND VPWR VPWR sky130_fd_sc_hd__decap_8
X_09290_ _03046_ _03047_ _03048_ VGND VGND VPWR VPWR _03049_ sky130_fd_sc_hd__or3_1
X_08310_ _02114_ _02115_ VGND VGND VPWR VPWR _00761_ sky130_fd_sc_hd__nor2_1
XFILLER_33_641 VPWR VGND VPWR VGND sky130_ef_sc_hd__decap_12
X_08241_ _02046_ _02064_ _02062_ VGND VGND VPWR VPWR _02067_ sky130_fd_sc_hd__or3b_1
XTAP_TAPCELL_ROW_103_1981 VGND VPWR sky130_fd_sc_hd__tapvpwrvgnd_1
XANTENNA_14 net320 VGND VGND VPWR VPWR sky130_fd_sc_hd__diode_2
XFILLER_20_302 VGND VGND VPWR VPWR sky130_fd_sc_hd__decap_6
XFILLER_33_685 VPWR VGND VPWR VGND sky130_ef_sc_hd__decap_12
XFILLER_60_493 VGND VGND VPWR VPWR sky130_fd_sc_hd__fill_1
XFILLER_20_346 VPWR VGND VPWR VGND sky130_ef_sc_hd__decap_12
XTAP_TAPCELL_ROW_31_831 VGND VPWR sky130_fd_sc_hd__tapvpwrvgnd_1
XFILLER_32_195 VGND VGND VPWR VPWR sky130_fd_sc_hd__fill_1
XFILLER_119_724 VGND VGND VPWR VPWR sky130_fd_sc_hd__decap_4
X_08172_ _01887_ _02008_ VGND VGND VPWR VPWR _02009_ sky130_fd_sc_hd__nor2_1
XFILLER_146_565 VGND VGND VPWR VPWR sky130_fd_sc_hd__decap_3
X_07123_ net989 net324 net231 VGND VGND VPWR VPWR _00163_ sky130_fd_sc_hd__mux2_1
XFILLER_9_391 VGND VGND VPWR VPWR sky130_fd_sc_hd__fill_1
Xoutput110 net110 VGND VGND VPWR VPWR m_axis_tdata[10] sky130_fd_sc_hd__buf_2
XFILLER_146_587 VGND VGND VPWR VPWR sky130_fd_sc_hd__fill_1
X_07054_ net986 net374 net207 VGND VGND VPWR VPWR _00094_ sky130_fd_sc_hd__mux2_1
Xoutput143 net143 VGND VGND VPWR VPWR m_axis_tvalid sky130_fd_sc_hd__buf_2
XFILLER_133_237 VPWR VGND VPWR VGND sky130_ef_sc_hd__decap_12
Xoutput132 net132 VGND VGND VPWR VPWR m_axis_tdata[30] sky130_fd_sc_hd__buf_2
Xoutput121 net121 VGND VGND VPWR VPWR m_axis_tdata[20] sky130_fd_sc_hd__buf_2
XFILLER_114_462 VGND VGND VPWR VPWR sky130_fd_sc_hd__fill_1
XFILLER_0_729 VPWR VGND VPWR VGND sky130_ef_sc_hd__decap_12
XFILLER_153_39 VPWR VGND VPWR VGND sky130_ef_sc_hd__decap_12
XFILLER_141_281 VGND VGND VPWR VPWR sky130_fd_sc_hd__fill_1
X_07956_ net815 net1781 net300 _01664_ VGND VGND VPWR VPWR _01840_ sky130_fd_sc_hd__a22o_1
XFILLER_101_167 VGND VGND VPWR VPWR sky130_fd_sc_hd__fill_1
X_06907_ u_interface.u_gelu_fp32.u_synth_top.s1_x\[18\] net274 VGND VGND VPWR VPWR
+ _01447_ sky130_fd_sc_hd__xnor2_1
XFILLER_46_15 VPWR VGND VPWR VGND sky130_ef_sc_hd__decap_12
XPHY_EDGE_ROW_106_Right_106 VGND VGND VPWR VPWR sky130_fd_sc_hd__decap_3
XFILLER_83_541 VGND VGND VPWR VPWR sky130_fd_sc_hd__decap_6
XFILLER_46_37 VGND VGND VPWR VPWR sky130_fd_sc_hd__decap_3
XTAP_TAPCELL_ROW_39_953 VGND VPWR sky130_fd_sc_hd__tapvpwrvgnd_1
X_07887_ net988 net342 net265 VGND VGND VPWR VPWR _00648_ sky130_fd_sc_hd__mux2_1
X_06838_ u_interface.fifo_data\[12\]\[26\] u_interface.fifo_data\[13\]\[26\] u_interface.fifo_data\[14\]\[26\]
+ u_interface.fifo_data\[15\]\[26\] net770 net753 VGND VGND VPWR VPWR _01387_ sky130_fd_sc_hd__mux4_1
X_09626_ _03247_ _03250_ VGND VGND VPWR VPWR _03382_ sky130_fd_sc_hd__nand2_1
XFILLER_56_777 VGND VGND VPWR VPWR sky130_fd_sc_hd__fill_1
XTAP_TAPCELL_ROW_48_1106 VGND VPWR sky130_fd_sc_hd__tapvpwrvgnd_1
XTAP_TAPCELL_ROW_39_964 VGND VPWR sky130_fd_sc_hd__tapvpwrvgnd_1
X_09557_ _03311_ _03312_ _03213_ _03215_ VGND VGND VPWR VPWR _03314_ sky130_fd_sc_hd__o211ai_2
X_06769_ u_interface.fifo_data\[0\]\[17\] u_interface.fifo_data\[1\]\[17\] u_interface.fifo_data\[2\]\[17\]
+ u_interface.fifo_data\[3\]\[17\] net764 net747 VGND VGND VPWR VPWR _01327_ sky130_fd_sc_hd__mux4_1
XFILLER_71_736 VGND VGND VPWR VPWR sky130_fd_sc_hd__fill_2
Xclkbuf_leaf_35_clk clknet_3_6__leaf_clk VGND VGND VPWR VPWR clknet_leaf_35_clk sky130_fd_sc_hd__clkbuf_8
X_09488_ _03190_ _03193_ VGND VGND VPWR VPWR _03245_ sky130_fd_sc_hd__nand2_1
XFILLER_102_65 VPWR VGND VPWR VGND sky130_ef_sc_hd__decap_12
XFILLER_70_268 VPWR VGND VPWR VGND sky130_ef_sc_hd__decap_12
XTAP_TAPCELL_ROW_61_1306 VGND VPWR sky130_fd_sc_hd__tapvpwrvgnd_1
X_08508_ _02297_ _02298_ VGND VGND VPWR VPWR _02299_ sky130_fd_sc_hd__nand2_1
X_08439_ _02193_ _02229_ _02189_ _02190_ VGND VGND VPWR VPWR _02230_ sky130_fd_sc_hd__o211a_1
XTAP_TAPCELL_ROW_61_1317 VGND VPWR sky130_fd_sc_hd__tapvpwrvgnd_1
XFILLER_12_825 VPWR VGND VPWR VGND sky130_ef_sc_hd__decap_12
XFILLER_12_869 VPWR VGND VPWR VGND sky130_ef_sc_hd__decap_12
XPHY_EDGE_ROW_43_Left_199 VGND VGND VPWR VPWR sky130_fd_sc_hd__decap_3
XFILLER_127_3 VGND VGND VPWR VPWR sky130_fd_sc_hd__fill_1
X_11450_ _05186_ _05187_ VGND VGND VPWR VPWR _05190_ sky130_fd_sc_hd__xnor2_1
XFILLER_137_543 VGND VGND VPWR VPWR sky130_fd_sc_hd__fill_1
X_10401_ _04147_ _04148_ VGND VGND VPWR VPWR _04150_ sky130_fd_sc_hd__xnor2_1
X_11381_ _05120_ _05121_ VGND VGND VPWR VPWR _00826_ sky130_fd_sc_hd__nor2_1
XFILLER_137_598 VGND VGND VPWR VPWR sky130_fd_sc_hd__decap_8
X_10332_ _03965_ _03972_ _04081_ VGND VGND VPWR VPWR _04082_ sky130_fd_sc_hd__a21oi_1
X_13120_ clknet_leaf_83_clk _00130_ VGND VGND VPWR VPWR u_interface.fifo_data\[2\]\[9\]
+ sky130_fd_sc_hd__dfxtp_1
XFILLER_11_51 VGND VGND VPWR VPWR sky130_fd_sc_hd__decap_4
X_13051_ clknet_leaf_67_clk _00061_ VGND VGND VPWR VPWR u_interface.fifo_data\[14\]\[4\]
+ sky130_fd_sc_hd__dfxtp_1
XTAP_TAPCELL_ROW_59_1279 VGND VPWR sky130_fd_sc_hd__tapvpwrvgnd_1
XFILLER_127_62 VGND VGND VPWR VPWR sky130_fd_sc_hd__decap_8
XFILLER_78_302 VGND VGND VPWR VPWR sky130_fd_sc_hd__decap_6
X_10263_ _04008_ _04009_ _04010_ VGND VGND VPWR VPWR _04013_ sky130_fd_sc_hd__and3_1
X_12002_ _05667_ _05676_ _05675_ VGND VGND VPWR VPWR _05735_ sky130_fd_sc_hd__a21o_1
XFILLER_133_782 VGND VGND VPWR VPWR sky130_fd_sc_hd__fill_2
XFILLER_87_55 VGND VGND VPWR VPWR sky130_fd_sc_hd__fill_1
XFILLER_79_858 VGND VGND VPWR VPWR sky130_fd_sc_hd__decap_8
X_10194_ _03925_ _03943_ VGND VGND VPWR VPWR _03945_ sky130_fd_sc_hd__xnor2_1
XFILLER_94_817 VGND VGND VPWR VPWR sky130_fd_sc_hd__decap_3
XFILLER_66_508 VPWR VGND VPWR VGND sky130_ef_sc_hd__decap_12
Xfanout370 u_interface.core_data_out\[7\] VGND VGND VPWR VPWR net370 sky130_fd_sc_hd__clkbuf_2
XFILLER_93_305 VGND VGND VPWR VPWR sky130_fd_sc_hd__decap_6
Xfanout392 u_interface.u_gelu_fp32.u_synth_top.s2_dx\[30\] VGND VGND VPWR VPWR net392
+ sky130_fd_sc_hd__buf_2
Xfanout381 u_interface.core_data_out\[2\] VGND VGND VPWR VPWR net381 sky130_fd_sc_hd__buf_1
X_13953_ clknet_leaf_55_clk _00879_ VGND VGND VPWR VPWR u_interface.u_gelu_fp32.u_q16_to_fp32.s2_exp\[5\]
+ sky130_fd_sc_hd__dfxtp_1
X_12904_ u_interface.core_valid_out net1776 _06435_ VGND VGND VPWR VPWR _01049_ sky130_fd_sc_hd__o21a_1
X_13884_ clknet_leaf_6_clk _00037_ VGND VGND VPWR VPWR u_interface.u_gelu_fp32.u_synth_top.s2_dx\[20\]
+ sky130_fd_sc_hd__dfxtp_1
XFILLER_47_799 VGND VGND VPWR VPWR sky130_fd_sc_hd__fill_2
XFILLER_46_265 VPWR VGND VPWR VGND sky130_ef_sc_hd__decap_12
XTAP_TAPCELL_ROW_17_603 VGND VPWR sky130_fd_sc_hd__tapvpwrvgnd_1
XFILLER_74_596 VPWR VGND VPWR VGND sky130_ef_sc_hd__decap_12
X_12835_ net772 net528 VGND VGND VPWR VPWR _00993_ sky130_fd_sc_hd__and2_1
XTAP_TAPCELL_ROW_17_614 VGND VPWR sky130_fd_sc_hd__tapvpwrvgnd_1
Xclkbuf_leaf_26_clk clknet_3_6__leaf_clk VGND VGND VPWR VPWR clknet_leaf_26_clk sky130_fd_sc_hd__clkbuf_8
XFILLER_61_246 VGND VGND VPWR VPWR sky130_fd_sc_hd__decap_6
XFILLER_15_641 VPWR VGND VPWR VGND sky130_ef_sc_hd__decap_12
X_12766_ _01777_ _06399_ VGND VGND VPWR VPWR _00943_ sky130_fd_sc_hd__nor2_1
XFILLER_61_279 VGND VGND VPWR VPWR sky130_fd_sc_hd__fill_1
XFILLER_15_685 VPWR VGND VPWR VGND sky130_ef_sc_hd__decap_12
X_12697_ net781 net1733 _06352_ _06355_ VGND VGND VPWR VPWR _00918_ sky130_fd_sc_hd__o211a_1
X_11717_ _05362_ _05371_ _05370_ VGND VGND VPWR VPWR _05454_ sky130_fd_sc_hd__a21oi_1
XFILLER_42_493 VGND VGND VPWR VPWR sky130_fd_sc_hd__fill_1
Xinput12 s_axil_araddr[18] VGND VGND VPWR VPWR net12 sky130_fd_sc_hd__clkbuf_1
XFILLER_30_699 VGND VGND VPWR VPWR sky130_fd_sc_hd__fill_1
X_11648_ _05384_ _05385_ VGND VGND VPWR VPWR _05386_ sky130_fd_sc_hd__nand2_1
Xinput23 s_axil_araddr[28] VGND VGND VPWR VPWR net23 sky130_fd_sc_hd__clkbuf_1
Xinput45 s_axil_awaddr[18] VGND VGND VPWR VPWR net45 sky130_fd_sc_hd__clkbuf_1
Xinput34 s_axil_araddr[9] VGND VGND VPWR VPWR net34 sky130_fd_sc_hd__clkbuf_1
X_11579_ net179 _05316_ VGND VGND VPWR VPWR _05317_ sky130_fd_sc_hd__nand2_1
Xinput67 s_axil_awaddr[9] VGND VGND VPWR VPWR net67 sky130_fd_sc_hd__clkbuf_1
Xinput56 s_axil_awaddr[28] VGND VGND VPWR VPWR net56 sky130_fd_sc_hd__clkbuf_1
XFILLER_155_384 VGND VGND VPWR VPWR sky130_fd_sc_hd__decap_4
XFILLER_155_351 VGND VGND VPWR VPWR sky130_fd_sc_hd__fill_1
Xinput78 s_axis_tdata[13] VGND VGND VPWR VPWR net78 sky130_fd_sc_hd__clkbuf_1
Xinput89 s_axis_tdata[23] VGND VGND VPWR VPWR net89 sky130_fd_sc_hd__clkbuf_1
XFILLER_143_524 VGND VGND VPWR VPWR sky130_fd_sc_hd__decap_4
XFILLER_143_502 VGND VGND VPWR VPWR sky130_fd_sc_hd__fill_2
XFILLER_128_587 VGND VGND VPWR VPWR sky130_fd_sc_hd__fill_1
Xhold818 u_interface.u_gelu_fp32.u_fp32_to_q16.s3_mag\[26\] VGND VGND VPWR VPWR net1683
+ sky130_fd_sc_hd__dlygate4sd3_1
X_13318_ clknet_leaf_67_clk _00328_ VGND VGND VPWR VPWR u_interface.fifo_data\[8\]\[27\]
+ sky130_fd_sc_hd__dfxtp_1
Xhold807 u_interface.u_gelu_fp32.s2_data\[25\] VGND VGND VPWR VPWR net1672 sky130_fd_sc_hd__dlygate4sd3_1
XFILLER_7_895 VGND VGND VPWR VPWR sky130_fd_sc_hd__fill_1
XFILLER_115_237 VGND VGND VPWR VPWR sky130_fd_sc_hd__decap_8
Xhold829 u_interface.u_gelu_fp32.u_q16_to_fp32.s2_mag\[13\] VGND VGND VPWR VPWR net1694
+ sky130_fd_sc_hd__dlygate4sd3_1
X_13249_ clknet_leaf_67_clk _00259_ VGND VGND VPWR VPWR u_interface.fifo_data\[11\]\[27\]
+ sky130_fd_sc_hd__dfxtp_1
XFILLER_42_3 VPWR VGND VPWR VGND sky130_ef_sc_hd__decap_12
XFILLER_123_281 VGND VGND VPWR VPWR sky130_fd_sc_hd__decap_6
XFILLER_96_121 VGND VGND VPWR VPWR sky130_fd_sc_hd__fill_2
XFILLER_69_313 VGND VGND VPWR VPWR sky130_fd_sc_hd__decap_4
X_08790_ _02547_ _02548_ _02502_ _02519_ VGND VGND VPWR VPWR _02549_ sky130_fd_sc_hd__o211a_1
X_07810_ net1282 net368 net229 VGND VGND VPWR VPWR _00571_ sky130_fd_sc_hd__mux2_1
XFILLER_97_688 VGND VGND VPWR VPWR sky130_fd_sc_hd__fill_1
XFILLER_96_165 VGND VGND VPWR VPWR sky130_fd_sc_hd__fill_2
X_07741_ u_interface.u_gelu_fp32.u_q16_to_fp32.s3_norm_mag\[22\] _01784_ VGND VGND
+ VPWR VPWR _01785_ sky130_fd_sc_hd__and2_1
XFILLER_85_839 VGND VGND VPWR VPWR sky130_fd_sc_hd__fill_1
XFILLER_37_221 VGND VGND VPWR VPWR sky130_fd_sc_hd__decap_3
XFILLER_38_755 VGND VGND VPWR VPWR sky130_fd_sc_hd__fill_1
XFILLER_38_766 VGND VGND VPWR VPWR sky130_fd_sc_hd__fill_1
XFILLER_80_500 VGND VGND VPWR VPWR sky130_fd_sc_hd__decap_4
X_07672_ _01725_ net280 _01752_ VGND VGND VPWR VPWR _00485_ sky130_fd_sc_hd__a21o_1
XFILLER_26_917 VGND VGND VPWR VPWR sky130_fd_sc_hd__fill_1
XTAP_TAPCELL_ROW_36_912 VGND VPWR sky130_fd_sc_hd__tapvpwrvgnd_1
XFILLER_38_788 VGND VGND VPWR VPWR sky130_fd_sc_hd__decap_6
X_06623_ u_interface.fifo_tlast\[12\] u_interface.fifo_tlast\[13\] u_interface.fifo_tlast\[14\]
+ u_interface.fifo_tlast\[15\] net768 net751 VGND VGND VPWR VPWR _01199_ sky130_fd_sc_hd__mux4_1
X_09411_ _02661_ _02662_ _02670_ _02669_ _02668_ VGND VGND VPWR VPWR _03169_ sky130_fd_sc_hd__a32o_1
XFILLER_92_371 VGND VGND VPWR VPWR sky130_fd_sc_hd__fill_2
XFILLER_80_533 VGND VGND VPWR VPWR sky130_fd_sc_hd__decap_8
XFILLER_16_29 VPWR VGND VPWR VGND sky130_ef_sc_hd__decap_12
Xclkbuf_leaf_17_clk clknet_3_3__leaf_clk VGND VGND VPWR VPWR clknet_leaf_17_clk sky130_fd_sc_hd__clkbuf_8
X_09342_ net512 net517 VGND VGND VPWR VPWR _03101_ sky130_fd_sc_hd__or2_1
X_06554_ net538 _01138_ _01140_ VGND VGND VPWR VPWR _00013_ sky130_fd_sc_hd__and3_1
XFILLER_52_257 VGND VGND VPWR VPWR sky130_fd_sc_hd__fill_1
XFILLER_52_246 VGND VGND VPWR VPWR sky130_fd_sc_hd__decap_6
XTAP_TAPCELL_ROW_43_1025 VGND VPWR sky130_fd_sc_hd__tapvpwrvgnd_1
XFILLER_40_419 VGND VGND VPWR VPWR sky130_fd_sc_hd__fill_1
X_09273_ _02981_ _02982_ _02984_ VGND VGND VPWR VPWR _03032_ sky130_fd_sc_hd__a21oi_1
XFILLER_139_808 VGND VGND VPWR VPWR sky130_fd_sc_hd__fill_1
XTAP_TAPCELL_ROW_138_2542 VGND VPWR sky130_fd_sc_hd__tapvpwrvgnd_1
XFILLER_138_307 VGND VGND VPWR VPWR sky130_fd_sc_hd__fill_1
XFILLER_20_121 VPWR VGND VPWR VGND sky130_ef_sc_hd__decap_12
XFILLER_33_493 VGND VGND VPWR VPWR sky130_fd_sc_hd__decap_8
X_08224_ net166 _02052_ VGND VGND VPWR VPWR _02053_ sky130_fd_sc_hd__nand2_1
XFILLER_119_543 VPWR VGND VPWR VGND sky130_ef_sc_hd__decap_12
X_08155_ net540 _01993_ _01994_ VGND VGND VPWR VPWR _01995_ sky130_fd_sc_hd__nand3_1
XTAP_TAPCELL_ROW_151_2753 VGND VPWR sky130_fd_sc_hd__tapvpwrvgnd_1
XFILLER_119_587 VPWR VGND VPWR VGND sky130_ef_sc_hd__decap_12
X_07106_ net1290 net573 net228 VGND VGND VPWR VPWR _00146_ sky130_fd_sc_hd__mux2_1
XFILLER_4_309 VPWR VGND VPWR VGND sky130_ef_sc_hd__decap_12
X_08086_ _01926_ _01927_ _01932_ VGND VGND VPWR VPWR _01937_ sky130_fd_sc_hd__and3_1
XFILLER_103_900 VGND VGND VPWR VPWR sky130_fd_sc_hd__fill_1
X_07037_ net1515 net344 net269 VGND VGND VPWR VPWR _00077_ sky130_fd_sc_hd__mux2_1
XFILLER_121_218 VGND VGND VPWR VPWR sky130_fd_sc_hd__fill_2
XFILLER_102_421 VPWR VGND VPWR VGND sky130_ef_sc_hd__decap_12
XFILLER_87_154 VPWR VGND VPWR VGND sky130_ef_sc_hd__decap_12
X_08988_ _02743_ _02744_ VGND VGND VPWR VPWR _02747_ sky130_fd_sc_hd__xnor2_1
XFILLER_57_69 VGND VGND VPWR VPWR sky130_fd_sc_hd__decap_4
XTAP_TAPCELL_ROW_54_1198 VGND VPWR sky130_fd_sc_hd__tapvpwrvgnd_1
X_07939_ net817 net551 _01830_ VGND VGND VPWR VPWR _00675_ sky130_fd_sc_hd__a21o_1
X_10950_ _04676_ _04693_ VGND VGND VPWR VPWR _04694_ sky130_fd_sc_hd__xnor2_1
XTAP_TAPCELL_ROW_3_386 VGND VPWR sky130_fd_sc_hd__tapvpwrvgnd_1
XFILLER_16_405 VGND VGND VPWR VPWR sky130_fd_sc_hd__decap_3
XFILLER_28_265 VPWR VGND VPWR VGND sky130_ef_sc_hd__decap_12
XFILLER_29_777 VGND VGND VPWR VPWR sky130_fd_sc_hd__decap_6
X_09609_ _03303_ _03362_ _03363_ VGND VGND VPWR VPWR _03365_ sky130_fd_sc_hd__nor3_1
XFILLER_73_35 VGND VGND VPWR VPWR sky130_fd_sc_hd__decap_3
XFILLER_71_533 VGND VGND VPWR VPWR sky130_fd_sc_hd__decap_3
X_10881_ _04617_ _04625_ VGND VGND VPWR VPWR _04626_ sky130_fd_sc_hd__nand2_1
XFILLER_44_725 VGND VGND VPWR VPWR sky130_fd_sc_hd__fill_2
XFILLER_16_438 VGND VGND VPWR VPWR sky130_fd_sc_hd__decap_3
X_12620_ _06313_ _06322_ _06315_ VGND VGND VPWR VPWR _06323_ sky130_fd_sc_hd__a21o_1
XFILLER_73_57 VPWR VGND VPWR VGND sky130_ef_sc_hd__decap_12
XPHY_EDGE_ROW_51_Left_207 VGND VGND VPWR VPWR sky130_fd_sc_hd__decap_3
XFILLER_43_235 VGND VGND VPWR VPWR sky130_fd_sc_hd__fill_1
X_12551_ _06245_ _06246_ net772 VGND VGND VPWR VPWR _06275_ sky130_fd_sc_hd__o21a_1
XFILLER_8_637 VGND VGND VPWR VPWR sky130_fd_sc_hd__decap_6
X_12482_ _06180_ _06207_ VGND VGND VPWR VPWR _06208_ sky130_fd_sc_hd__xnor2_1
X_11502_ net694 net703 net429 net424 VGND VGND VPWR VPWR _05241_ sky130_fd_sc_hd__and4_1
XFILLER_7_125 VPWR VGND VPWR VGND sky130_ef_sc_hd__decap_12
XFILLER_12_699 VGND VGND VPWR VPWR sky130_fd_sc_hd__fill_1
XTAP_TAPCELL_ROW_22_683 VGND VPWR sky130_fd_sc_hd__tapvpwrvgnd_1
XTAP_TAPCELL_ROW_22_694 VGND VPWR sky130_fd_sc_hd__tapvpwrvgnd_1
X_11433_ net633 net642 net403 net399 VGND VGND VPWR VPWR _05173_ sky130_fd_sc_hd__and4_1
XFILLER_137_362 VPWR VGND VPWR VGND sky130_ef_sc_hd__decap_12
X_14152_ clknet_leaf_63_clk _01078_ VGND VGND VPWR VPWR u_interface.fifo_data\[1\]\[12\]
+ sky130_fd_sc_hd__dfxtp_1
XFILLER_7_169 VPWR VGND VPWR VGND sky130_ef_sc_hd__decap_12
XFILLER_22_83 VGND VGND VPWR VPWR sky130_fd_sc_hd__fill_1
XFILLER_152_321 VPWR VGND VPWR VGND sky130_ef_sc_hd__decap_12
XFILLER_138_94 VGND VGND VPWR VPWR sky130_fd_sc_hd__decap_6
XTAP_TAPCELL_ROW_74_1519 VGND VPWR sky130_fd_sc_hd__tapvpwrvgnd_1
X_11364_ _05102_ _05103_ VGND VGND VPWR VPWR _05105_ sky130_fd_sc_hd__xnor2_1
X_14083_ clknet_leaf_17_clk net1490 VGND VGND VPWR VPWR u_interface.u_gelu_fp32.u_fp32_to_q16.s2_norm_mag\[20\]
+ sky130_fd_sc_hd__dfxtp_1
X_13103_ clknet_leaf_46_clk _00113_ VGND VGND VPWR VPWR u_interface.fifo_data\[15\]\[24\]
+ sky130_fd_sc_hd__dfxtp_1
X_10315_ _04063_ net181 _03946_ _03949_ VGND VGND VPWR VPWR _04065_ sky130_fd_sc_hd__o211ai_2
XPHY_EDGE_ROW_60_Left_216 VGND VGND VPWR VPWR sky130_fd_sc_hd__decap_3
X_11295_ _04928_ _04936_ _04935_ VGND VGND VPWR VPWR _05036_ sky130_fd_sc_hd__a21oi_1
X_13034_ clknet_leaf_37_clk _00044_ VGND VGND VPWR VPWR u_interface.fifo_tuser\[11\]
+ sky130_fd_sc_hd__dfxtp_1
X_10246_ _03994_ _03995_ _03975_ VGND VGND VPWR VPWR _03996_ sky130_fd_sc_hd__a21o_1
XFILLER_79_611 VGND VGND VPWR VPWR sky130_fd_sc_hd__decap_4
XFILLER_154_60 VPWR VGND VPWR VGND sky130_ef_sc_hd__decap_12
XFILLER_105_281 VPWR VGND VPWR VGND sky130_ef_sc_hd__decap_12
XFILLER_79_688 VGND VGND VPWR VPWR sky130_fd_sc_hd__fill_2
XFILLER_78_187 VGND VGND VPWR VPWR sky130_fd_sc_hd__fill_1
X_10177_ net627 net446 net441 net619 VGND VGND VPWR VPWR _03928_ sky130_fd_sc_hd__a22o_1
XFILLER_67_828 VGND VGND VPWR VPWR sky130_fd_sc_hd__decap_3
XFILLER_66_327 VGND VGND VPWR VPWR sky130_fd_sc_hd__decap_4
XTAP_TAPCELL_ROW_105_2018 VGND VPWR sky130_fd_sc_hd__tapvpwrvgnd_1
X_13936_ clknet_leaf_5_clk _00021_ VGND VGND VPWR VPWR u_interface.u_gelu_fp32.u_synth_top.s1_hits\[8\]
+ sky130_fd_sc_hd__dfxtp_1
XTAP_TAPCELL_ROW_89_1762 VGND VPWR sky130_fd_sc_hd__tapvpwrvgnd_1
XFILLER_81_319 VGND VGND VPWR VPWR sky130_fd_sc_hd__fill_1
XFILLER_74_360 VGND VGND VPWR VPWR sky130_fd_sc_hd__decap_4
XFILLER_35_747 VPWR VGND VPWR VGND sky130_ef_sc_hd__decap_12
X_13867_ clknet_leaf_22_clk net866 VGND VGND VPWR VPWR u_interface.u_gelu_fp32.u_synth_top.s2_dx\[3\]
+ sky130_fd_sc_hd__dfxtp_1
XFILLER_23_909 VPWR VGND VPWR VGND sky130_ef_sc_hd__decap_12
X_12818_ net777 net77 VGND VGND VPWR VPWR _00976_ sky130_fd_sc_hd__and2_1
X_13798_ clknet_leaf_25_clk _00808_ VGND VGND VPWR VPWR u_interface.u_gelu_fp32.u_synth_top.s3_mult\[16\]
+ sky130_fd_sc_hd__dfxtp_1
XFILLER_148_616 VPWR VGND VPWR VGND sky130_ef_sc_hd__decap_12
X_12749_ net1540 u_interface.u_gelu_fp32.u_q16_to_fp32.s3_exp\[1\] net823 VGND VGND
+ VPWR VPWR _00931_ sky130_fd_sc_hd__mux2_1
XFILLER_15_493 VGND VGND VPWR VPWR sky130_fd_sc_hd__fill_1
XFILLER_148_649 VGND VGND VPWR VPWR sky130_fd_sc_hd__fill_1
XTAP_TAPCELL_ROW_100_1940 VGND VPWR sky130_fd_sc_hd__tapvpwrvgnd_1
XFILLER_8_41 VPWR VGND VPWR VGND sky130_ef_sc_hd__decap_12
XFILLER_30_441 VGND VGND VPWR VPWR sky130_fd_sc_hd__decap_8
XFILLER_30_474 VGND VGND VPWR VPWR sky130_fd_sc_hd__fill_2
XFILLER_129_841 VGND VGND VPWR VPWR sky130_fd_sc_hd__decap_6
XFILLER_8_85 VPWR VGND VPWR VGND sky130_ef_sc_hd__decap_12
XTAP_TAPCELL_ROW_41_992 VGND VPWR sky130_fd_sc_hd__tapvpwrvgnd_1
XFILLER_144_800 VPWR VGND VPWR VGND sky130_ef_sc_hd__decap_12
XFILLER_129_874 VGND VGND VPWR VPWR sky130_fd_sc_hd__fill_1
XFILLER_128_351 VGND VGND VPWR VPWR sky130_fd_sc_hd__fill_1
XFILLER_144_855 VGND VGND VPWR VPWR sky130_fd_sc_hd__decap_3
XFILLER_143_310 VPWR VGND VPWR VGND sky130_ef_sc_hd__decap_12
XTAP_TAPCELL_ROW_133_2461 VGND VPWR sky130_fd_sc_hd__tapvpwrvgnd_1
Xhold626 u_interface.fifo_data\[3\]\[18\] VGND VGND VPWR VPWR net1491 sky130_fd_sc_hd__dlygate4sd3_1
Xhold615 u_interface.fifo_data\[6\]\[30\] VGND VGND VPWR VPWR net1480 sky130_fd_sc_hd__dlygate4sd3_1
Xhold604 u_interface.fifo_data\[11\]\[20\] VGND VGND VPWR VPWR net1469 sky130_fd_sc_hd__dlygate4sd3_1
XFILLER_144_877 VGND VGND VPWR VPWR sky130_fd_sc_hd__decap_6
Xhold659 u_interface.fifo_data\[7\]\[24\] VGND VGND VPWR VPWR net1524 sky130_fd_sc_hd__dlygate4sd3_1
X_09960_ _03704_ _03710_ _03711_ VGND VGND VPWR VPWR _03713_ sky130_fd_sc_hd__nand3_1
Xclkbuf_leaf_6_clk clknet_3_0__leaf_clk VGND VGND VPWR VPWR clknet_leaf_6_clk sky130_fd_sc_hd__clkbuf_8
Xhold648 u_interface.fifo_data\[7\]\[5\] VGND VGND VPWR VPWR net1513 sky130_fd_sc_hd__dlygate4sd3_1
Xhold637 u_interface.fifo_data\[3\]\[31\] VGND VGND VPWR VPWR net1502 sky130_fd_sc_hd__dlygate4sd3_1
X_08911_ _02668_ _02669_ VGND VGND VPWR VPWR _02670_ sky130_fd_sc_hd__xor2_1
XFILLER_112_752 VGND VGND VPWR VPWR sky130_fd_sc_hd__decap_4
XFILLER_112_730 VGND VGND VPWR VPWR sky130_fd_sc_hd__decap_4
XFILLER_97_430 VGND VGND VPWR VPWR sky130_fd_sc_hd__decap_8
X_09891_ _03642_ _03643_ _03635_ VGND VGND VPWR VPWR _03644_ sky130_fd_sc_hd__a21o_1
XFILLER_69_132 VGND VGND VPWR VPWR sky130_fd_sc_hd__fill_2
X_08842_ _02531_ _02533_ VGND VGND VPWR VPWR _02601_ sky130_fd_sc_hd__xnor2_1
XFILLER_112_785 VGND VGND VPWR VPWR sky130_fd_sc_hd__decap_4
XFILLER_100_914 VGND VGND VPWR VPWR sky130_fd_sc_hd__fill_2
XFILLER_85_603 VGND VGND VPWR VPWR sky130_fd_sc_hd__fill_2
XFILLER_57_305 VPWR VGND VPWR VGND sky130_ef_sc_hd__decap_12
X_08773_ _02523_ _02524_ _02525_ VGND VGND VPWR VPWR _02532_ sky130_fd_sc_hd__a21o_1
XFILLER_111_284 VGND VGND VPWR VPWR sky130_fd_sc_hd__decap_8
XFILLER_57_349 VGND VGND VPWR VPWR sky130_fd_sc_hd__decap_4
XFILLER_150_29 VPWR VGND VPWR VGND sky130_ef_sc_hd__decap_12
XPHY_EDGE_ROW_108_Left_264 VGND VGND VPWR VPWR sky130_fd_sc_hd__decap_3
X_07724_ u_interface.u_gelu_fp32.u_synth_top.s1_hits\[13\] u_interface.u_gelu_fp32.u_synth_top.s1_hits\[12\]
+ VGND VGND VPWR VPWR _01773_ sky130_fd_sc_hd__or2_1
XTAP_TAPCELL_ROW_0_312 VGND VPWR sky130_fd_sc_hd__tapvpwrvgnd_1
XFILLER_27_39 VPWR VGND VPWR VGND sky130_ef_sc_hd__decap_12
X_07655_ u_interface.u_gelu_fp32.u_q16_to_fp32.s2_mag\[12\] u_interface.u_gelu_fp32.u_q16_to_fp32.s2_mag\[11\]
+ net337 VGND VGND VPWR VPWR _01739_ sky130_fd_sc_hd__mux2_1
XFILLER_65_382 VGND VGND VPWR VPWR sky130_fd_sc_hd__fill_1
XTAP_TAPCELL_ROW_0_323 VGND VPWR sky130_fd_sc_hd__tapvpwrvgnd_1
XTAP_TAPCELL_ROW_0_334 VGND VPWR sky130_fd_sc_hd__tapvpwrvgnd_1
XFILLER_26_725 VPWR VGND VPWR VGND sky130_ef_sc_hd__decap_12
X_06606_ u_interface.u_gelu_fp32.u_synth_top.s1_hits\[8\] _01183_ VGND VGND VPWR VPWR
+ _01184_ sky130_fd_sc_hd__nor2_1
XFILLER_26_769 VPWR VGND VPWR VGND sky130_ef_sc_hd__decap_12
X_07586_ net810 net1735 net302 _01689_ VGND VGND VPWR VPWR _00462_ sky130_fd_sc_hd__a22o_1
XFILLER_43_27 VPWR VGND VPWR VGND sky130_ef_sc_hd__decap_12
X_09325_ _03055_ _03075_ _03083_ VGND VGND VPWR VPWR _03084_ sky130_fd_sc_hd__a21o_1
X_06537_ u_interface.u_gelu_fp32.s1_data\[27\] u_interface.u_gelu_fp32.s1_data\[26\]
+ u_interface.u_gelu_fp32.s1_data\[25\] u_interface.u_gelu_fp32.s1_data\[24\] VGND
+ VGND VPWR VPWR _01134_ sky130_fd_sc_hd__or4_1
X_09256_ net606 net512 VGND VGND VPWR VPWR _03015_ sky130_fd_sc_hd__nand2_1
XPHY_EDGE_ROW_117_Left_273 VGND VGND VPWR VPWR sky130_fd_sc_hd__decap_3
X_08207_ net166 _02037_ _02038_ net162 VGND VGND VPWR VPWR _02039_ sky130_fd_sc_hd__a31oi_1
X_09187_ _02941_ _02942_ _02944_ _02924_ _02881_ VGND VGND VPWR VPWR _02946_ sky130_fd_sc_hd__a32o_1
XFILLER_119_362 VGND VGND VPWR VPWR sky130_fd_sc_hd__decap_8
XFILLER_5_629 VPWR VGND VPWR VGND sky130_ef_sc_hd__decap_12
XFILLER_134_332 VGND VGND VPWR VPWR sky130_fd_sc_hd__decap_3
X_08138_ net168 _01979_ _01980_ net163 VGND VGND VPWR VPWR _01981_ sky130_fd_sc_hd__a31oi_1
XFILLER_4_139 VGND VGND VPWR VPWR sky130_fd_sc_hd__fill_1
XFILLER_134_365 VPWR VGND VPWR VGND sky130_ef_sc_hd__decap_12
X_08069_ _01921_ _01922_ VGND VGND VPWR VPWR _01923_ sky130_fd_sc_hd__xnor2_1
XFILLER_108_53 VGND VGND VPWR VPWR sky130_fd_sc_hd__fill_1
XTAP_TAPCELL_ROW_56_1238 VGND VPWR sky130_fd_sc_hd__tapvpwrvgnd_1
XTAP_TAPCELL_ROW_56_1227 VGND VPWR sky130_fd_sc_hd__tapvpwrvgnd_1
X_10100_ _03753_ _03848_ _03849_ VGND VGND VPWR VPWR _03852_ sky130_fd_sc_hd__or3_1
X_11080_ _04822_ _04812_ VGND VGND VPWR VPWR _04823_ sky130_fd_sc_hd__and2b_1
XFILLER_150_869 VGND VGND VPWR VPWR sky130_fd_sc_hd__decap_6
X_10031_ _03781_ _03782_ _03754_ VGND VGND VPWR VPWR _03783_ sky130_fd_sc_hd__a21o_1
XTAP_TAPCELL_ROW_8_467 VGND VPWR sky130_fd_sc_hd__tapvpwrvgnd_1
XTAP_TAPCELL_ROW_8_456 VGND VPWR sky130_fd_sc_hd__tapvpwrvgnd_1
XFILLER_103_785 VPWR VGND VPWR VGND sky130_ef_sc_hd__decap_12
XFILLER_88_474 VGND VGND VPWR VPWR sky130_fd_sc_hd__fill_2
XFILLER_0_389 VGND VGND VPWR VPWR sky130_fd_sc_hd__decap_3
XPHY_EDGE_ROW_126_Left_282 VGND VGND VPWR VPWR sky130_fd_sc_hd__decap_3
XFILLER_124_63 VGND VGND VPWR VPWR sky130_fd_sc_hd__decap_4
XFILLER_102_295 VPWR VGND VPWR VGND sky130_ef_sc_hd__decap_12
XFILLER_76_658 VGND VGND VPWR VPWR sky130_fd_sc_hd__decap_8
XFILLER_48_349 VPWR VGND VPWR VGND sky130_ef_sc_hd__decap_12
XFILLER_48_327 VGND VGND VPWR VPWR sky130_fd_sc_hd__decap_3
XFILLER_91_628 VGND VGND VPWR VPWR sky130_fd_sc_hd__fill_1
XFILLER_91_617 VGND VGND VPWR VPWR sky130_fd_sc_hd__decap_4
XFILLER_57_850 VGND VGND VPWR VPWR sky130_fd_sc_hd__decap_3
XFILLER_29_541 VGND VGND VPWR VPWR sky130_fd_sc_hd__fill_2
X_13721_ clknet_leaf_7_clk _00731_ VGND VGND VPWR VPWR u_interface.u_gelu_fp32.s1_data\[21\]
+ sky130_fd_sc_hd__dfxtp_1
XFILLER_90_138 VGND VGND VPWR VPWR sky130_fd_sc_hd__fill_2
XFILLER_90_127 VGND VGND VPWR VPWR sky130_fd_sc_hd__decap_8
XFILLER_44_533 VPWR VGND VPWR VGND sky130_ef_sc_hd__decap_12
X_11982_ _05714_ _05715_ VGND VGND VPWR VPWR _05716_ sky130_fd_sc_hd__nor2_1
X_10933_ net215 _03657_ _03654_ VGND VGND VPWR VPWR _04677_ sky130_fd_sc_hd__a21o_1
X_13652_ clknet_leaf_13_clk _00662_ VGND VGND VPWR VPWR u_interface.u_gelu_fp32.u_fp32_to_q16.s1_is_zero
+ sky130_fd_sc_hd__dfxtp_1
XTAP_TAPCELL_ROW_84_1681 VGND VPWR sky130_fd_sc_hd__tapvpwrvgnd_1
X_10864_ _04497_ _04500_ VGND VGND VPWR VPWR _04609_ sky130_fd_sc_hd__and2b_1
XFILLER_16_268 VGND VGND VPWR VPWR sky130_fd_sc_hd__decap_6
XTAP_TAPCELL_ROW_27_764 VGND VPWR sky130_fd_sc_hd__tapvpwrvgnd_1
XTAP_TAPCELL_ROW_27_775 VGND VPWR sky130_fd_sc_hd__tapvpwrvgnd_1
X_13583_ clknet_leaf_68_clk _00593_ VGND VGND VPWR VPWR u_interface.fifo_data\[4\]\[30\]
+ sky130_fd_sc_hd__dfxtp_1
X_10795_ _04415_ _04417_ _04538_ _04539_ VGND VGND VPWR VPWR _04541_ sky130_fd_sc_hd__a211o_1
X_12603_ u_interface.u_gelu_fp32.u_q16_to_fp32.s1_mag\[15\] net211 _06304_ _06305_
+ u_interface.u_gelu_fp32.u_q16_to_fp32.s1_mag\[31\] VGND VGND VPWR VPWR _06306_ sky130_fd_sc_hd__a221o_1
XPHY_EDGE_ROW_135_Left_291 VGND VGND VPWR VPWR sky130_fd_sc_hd__decap_3
X_12534_ _06184_ _06234_ _06233_ VGND VGND VPWR VPWR _06258_ sky130_fd_sc_hd__o21a_1
XFILLER_129_159 VGND VGND VPWR VPWR sky130_fd_sc_hd__decap_8
XFILLER_126_811 VGND VGND VPWR VPWR sky130_fd_sc_hd__fill_1
XFILLER_8_489 VPWR VGND VPWR VGND sky130_ef_sc_hd__decap_12
XFILLER_8_467 VGND VGND VPWR VPWR sky130_fd_sc_hd__decap_8
X_12465_ _06188_ _06189_ VGND VGND VPWR VPWR _06191_ sky130_fd_sc_hd__xnor2_1
XFILLER_137_181 VPWR VGND VPWR VGND sky130_ef_sc_hd__decap_12
X_11416_ _05154_ _05155_ VGND VGND VPWR VPWR _05156_ sky130_fd_sc_hd__xnor2_1
X_12396_ net772 _06122_ _06123_ VGND VGND VPWR VPWR _00839_ sky130_fd_sc_hd__and3_1
X_14135_ clknet_leaf_30_clk _01061_ VGND VGND VPWR VPWR u_interface.fifo_count\[2\]
+ sky130_fd_sc_hd__dfxtp_1
XFILLER_125_365 VGND VGND VPWR VPWR sky130_fd_sc_hd__fill_1
XTAP_TAPCELL_ROW_115_2180 VGND VPWR sky130_fd_sc_hd__tapvpwrvgnd_1
X_11347_ net611 u_interface.u_gelu_fp32.u_synth_top.s2_dx\[29\] _04988_ _04987_ VGND
+ VGND VPWR VPWR _05088_ sky130_fd_sc_hd__a31o_1
XFILLER_3_161 VGND VGND VPWR VPWR sky130_fd_sc_hd__decap_6
X_14066_ clknet_leaf_33_clk _00992_ VGND VGND VPWR VPWR u_interface.u_gelu_fp32.u_q16_to_fp32.s1_valid
+ sky130_fd_sc_hd__dfxtp_1
XFILLER_113_549 VGND VGND VPWR VPWR sky130_fd_sc_hd__decap_8
X_11278_ _04899_ _04901_ _05017_ VGND VGND VPWR VPWR _05020_ sky130_fd_sc_hd__and3_1
X_10229_ _03763_ net277 VGND VGND VPWR VPWR _03979_ sky130_fd_sc_hd__nand2_2
X_13017_ net170 net165 net161 net160 net151 VGND VGND VPWR VPWR _00844_ sky130_fd_sc_hd__o2111a_1
Xhold1 u_interface.u_gelu_fp32.u_synth_top.s1_x\[3\] VGND VGND VPWR VPWR net866 sky130_fd_sc_hd__dlygate4sd3_1
XFILLER_94_433 VPWR VGND VPWR VGND sky130_ef_sc_hd__decap_12
XFILLER_39_349 VPWR VGND VPWR VGND sky130_ef_sc_hd__decap_12
X_13919_ clknet_leaf_6_clk net897 VGND VGND VPWR VPWR u_interface.u_gelu_fp32.u_synth_top.s1_x\[23\]
+ sky130_fd_sc_hd__dfxtp_1
X_07440_ _01573_ _01574_ net556 VGND VGND VPWR VPWR _01575_ sky130_fd_sc_hd__mux2_1
XFILLER_50_503 VPWR VGND VPWR VGND sky130_ef_sc_hd__decap_12
XPHY_EDGE_ROW_8_Right_8 VGND VGND VPWR VPWR sky130_fd_sc_hd__decap_3
XFILLER_35_577 VPWR VGND VPWR VGND sky130_ef_sc_hd__decap_12
X_07371_ net1403 net377 net238 VGND VGND VPWR VPWR _00401_ sky130_fd_sc_hd__mux2_1
XFILLER_22_249 VGND VGND VPWR VPWR sky130_fd_sc_hd__decap_3
X_09110_ _02783_ _02798_ _02797_ VGND VGND VPWR VPWR _02869_ sky130_fd_sc_hd__a21oi_1
XFILLER_15_290 VGND VGND VPWR VPWR sky130_fd_sc_hd__decap_3
X_09041_ _02781_ _02782_ _02799_ VGND VGND VPWR VPWR _02800_ sky130_fd_sc_hd__nor3_1
XTAP_TAPCELL_ROW_135_2501 VGND VPWR sky130_fd_sc_hd__tapvpwrvgnd_1
XFILLER_31_783 VGND VGND VPWR VPWR sky130_fd_sc_hd__fill_1
XFILLER_116_321 VGND VGND VPWR VPWR sky130_fd_sc_hd__decap_8
Xhold401 u_interface.fifo_data\[8\]\[12\] VGND VGND VPWR VPWR net1266 sky130_fd_sc_hd__dlygate4sd3_1
Xhold445 u_interface.fifo_data\[13\]\[10\] VGND VGND VPWR VPWR net1310 sky130_fd_sc_hd__dlygate4sd3_1
XFILLER_144_641 VGND VGND VPWR VPWR sky130_fd_sc_hd__decap_3
XFILLER_143_140 VGND VGND VPWR VPWR sky130_fd_sc_hd__fill_1
XFILLER_116_365 VGND VGND VPWR VPWR sky130_fd_sc_hd__fill_2
Xhold412 u_interface.fifo_data\[2\]\[4\] VGND VGND VPWR VPWR net1277 sky130_fd_sc_hd__dlygate4sd3_1
Xhold434 u_interface.fifo_data\[6\]\[20\] VGND VGND VPWR VPWR net1299 sky130_fd_sc_hd__dlygate4sd3_1
Xhold423 u_interface.fifo_data\[8\]\[0\] VGND VGND VPWR VPWR net1288 sky130_fd_sc_hd__dlygate4sd3_1
Xhold456 u_interface.fifo_data\[15\]\[14\] VGND VGND VPWR VPWR net1321 sky130_fd_sc_hd__dlygate4sd3_1
Xhold478 u_interface.fifo_data\[3\]\[17\] VGND VGND VPWR VPWR net1343 sky130_fd_sc_hd__dlygate4sd3_1
Xmax_cap175 _03466_ VGND VGND VPWR VPWR net175 sky130_fd_sc_hd__buf_1
XFILLER_89_238 VGND VGND VPWR VPWR sky130_fd_sc_hd__decap_6
Xhold467 u_interface.fifo_data\[8\]\[15\] VGND VGND VPWR VPWR net1332 sky130_fd_sc_hd__dlygate4sd3_1
Xmax_cap186 _06307_ VGND VGND VPWR VPWR net186 sky130_fd_sc_hd__clkbuf_2
X_09943_ _03694_ _03695_ _03693_ VGND VGND VPWR VPWR _03696_ sky130_fd_sc_hd__a21o_1
Xhold489 u_interface.fifo_data\[8\]\[5\] VGND VGND VPWR VPWR net1354 sky130_fd_sc_hd__dlygate4sd3_1
XPHY_EDGE_ROW_39_Right_39 VGND VGND VPWR VPWR sky130_fd_sc_hd__decap_3
X_09874_ _03626_ _03627_ VGND VGND VPWR VPWR _03628_ sky130_fd_sc_hd__nor2_1
XTAP_TAPCELL_ROW_5_415 VGND VPWR sky130_fd_sc_hd__tapvpwrvgnd_1
XFILLER_38_27 VGND VGND VPWR VPWR sky130_fd_sc_hd__fill_1
X_08825_ net663 net511 VGND VGND VPWR VPWR _02584_ sky130_fd_sc_hd__nand2_1
XFILLER_100_744 VPWR VGND VPWR VGND sky130_ef_sc_hd__decap_12
XFILLER_100_722 VGND VGND VPWR VPWR sky130_fd_sc_hd__decap_4
XFILLER_97_293 VPWR VGND VPWR VGND sky130_ef_sc_hd__decap_12
XFILLER_85_444 VGND VGND VPWR VPWR sky130_fd_sc_hd__decap_4
XFILLER_57_135 VPWR VGND VPWR VGND sky130_ef_sc_hd__decap_12
XFILLER_57_113 VGND VGND VPWR VPWR sky130_fd_sc_hd__fill_2
XTAP_TAPCELL_ROW_51_1157 VGND VPWR sky130_fd_sc_hd__tapvpwrvgnd_1
XTAP_TAPCELL_ROW_51_1146 VGND VPWR sky130_fd_sc_hd__tapvpwrvgnd_1
XTAP_TAPCELL_ROW_146_2674 VGND VPWR sky130_fd_sc_hd__tapvpwrvgnd_1
XFILLER_85_477 VPWR VGND VPWR VGND sky130_ef_sc_hd__decap_12
XFILLER_85_466 VGND VGND VPWR VPWR sky130_fd_sc_hd__decap_6
XFILLER_73_606 VGND VGND VPWR VPWR sky130_fd_sc_hd__fill_1
XFILLER_39_850 VGND VGND VPWR VPWR sky130_fd_sc_hd__decap_4
X_08756_ _02490_ _02508_ _02507_ VGND VGND VPWR VPWR _02515_ sky130_fd_sc_hd__a21o_1
XFILLER_26_522 VGND VGND VPWR VPWR sky130_fd_sc_hd__fill_2
XFILLER_39_894 VGND VGND VPWR VPWR sky130_fd_sc_hd__fill_2
X_08687_ net690 net511 _02443_ _02444_ VGND VGND VPWR VPWR _02446_ sky130_fd_sc_hd__and4_1
X_07707_ u_interface.u_gelu_fp32.u_synth_top.s1_hits\[12\] _00504_ VGND VGND VPWR
+ VPWR _01767_ sky130_fd_sc_hd__or2_1
XFILLER_54_15 VPWR VGND VPWR VGND sky130_ef_sc_hd__decap_12
X_07638_ u_interface.u_gelu_fp32.u_q16_to_fp32.s2_mag\[8\] u_interface.u_gelu_fp32.u_q16_to_fp32.s2_mag\[7\]
+ net338 VGND VGND VPWR VPWR _01726_ sky130_fd_sc_hd__mux2_1
XFILLER_13_205 VPWR VGND VPWR VGND sky130_ef_sc_hd__decap_12
XTAP_TAPCELL_ROW_24_712 VGND VPWR sky130_fd_sc_hd__tapvpwrvgnd_1
X_07569_ _01654_ _01652_ net549 VGND VGND VPWR VPWR _01681_ sky130_fd_sc_hd__mux2_1
XFILLER_81_694 VGND VGND VPWR VPWR sky130_fd_sc_hd__decap_6
XPHY_EDGE_ROW_48_Right_48 VGND VGND VPWR VPWR sky130_fd_sc_hd__decap_3
XTAP_TAPCELL_ROW_24_723 VGND VPWR sky130_fd_sc_hd__tapvpwrvgnd_1
X_09308_ net584 net485 _03033_ _03034_ VGND VGND VPWR VPWR _03067_ sky130_fd_sc_hd__a22o_1
XFILLER_110_54 VGND VGND VPWR VPWR sky130_fd_sc_hd__fill_1
XFILLER_70_58 VGND VGND VPWR VPWR sky130_fd_sc_hd__fill_1
X_10580_ _03979_ _04324_ _04325_ VGND VGND VPWR VPWR _04327_ sky130_fd_sc_hd__nand3_2
X_09239_ _02995_ _02996_ _02994_ VGND VGND VPWR VPWR _02998_ sky130_fd_sc_hd__a21o_1
XFILLER_139_468 VGND VGND VPWR VPWR sky130_fd_sc_hd__fill_1
XFILLER_127_608 VGND VGND VPWR VPWR sky130_fd_sc_hd__fill_1
XFILLER_108_811 VGND VGND VPWR VPWR sky130_fd_sc_hd__fill_1
XFILLER_6_905 VPWR VGND VPWR VGND sky130_ef_sc_hd__decap_12
XFILLER_154_449 VGND VGND VPWR VPWR sky130_fd_sc_hd__fill_2
X_12250_ _05948_ _05979_ VGND VGND VPWR VPWR _05980_ sky130_fd_sc_hd__xnor2_1
XFILLER_119_85 VGND VGND VPWR VPWR sky130_fd_sc_hd__fill_1
X_11201_ _04941_ _04942_ VGND VGND VPWR VPWR _04943_ sky130_fd_sc_hd__nor2_1
X_12181_ _05910_ _05911_ VGND VGND VPWR VPWR _05912_ sky130_fd_sc_hd__and2b_1
X_11132_ net595 net396 _04760_ _04759_ VGND VGND VPWR VPWR _04875_ sky130_fd_sc_hd__a31o_1
XPHY_EDGE_ROW_57_Right_57 VGND VGND VPWR VPWR sky130_fd_sc_hd__decap_3
XFILLER_135_40 VGND VGND VPWR VPWR sky130_fd_sc_hd__fill_2
XFILLER_134_195 VGND VGND VPWR VPWR sky130_fd_sc_hd__fill_1
XFILLER_122_335 VGND VGND VPWR VPWR sky130_fd_sc_hd__decap_4
XFILLER_150_699 VGND VGND VPWR VPWR sky130_fd_sc_hd__fill_1
XFILLER_89_761 VGND VGND VPWR VPWR sky130_fd_sc_hd__fill_1
X_11063_ _04801_ _04805_ VGND VGND VPWR VPWR _04806_ sky130_fd_sc_hd__xnor2_1
XFILLER_0_153 VPWR VGND VPWR VGND sky130_ef_sc_hd__decap_12
XFILLER_1_665 VGND VGND VPWR VPWR sky130_fd_sc_hd__decap_6
X_10014_ _03637_ _03762_ _03764_ VGND VGND VPWR VPWR _03766_ sky130_fd_sc_hd__nand3_1
XFILLER_0_197 VPWR VGND VPWR VGND sky130_ef_sc_hd__decap_12
XFILLER_76_477 VPWR VGND VPWR VGND sky130_ef_sc_hd__decap_12
XTAP_TAPCELL_ROW_86_1710 VGND VPWR sky130_fd_sc_hd__tapvpwrvgnd_1
XFILLER_151_83 VPWR VGND VPWR VGND sky130_ef_sc_hd__decap_12
XFILLER_91_447 VGND VGND VPWR VPWR sky130_fd_sc_hd__fill_1
X_11965_ _05698_ _05697_ VGND VGND VPWR VPWR _05699_ sky130_fd_sc_hd__and2b_1
XFILLER_29_393 VGND VGND VPWR VPWR sky130_fd_sc_hd__decap_3
X_13704_ clknet_leaf_19_clk _00714_ VGND VGND VPWR VPWR u_interface.u_gelu_fp32.s1_data\[4\]
+ sky130_fd_sc_hd__dfxtp_1
X_10916_ _04659_ _04660_ _04557_ VGND VGND VPWR VPWR _04661_ sky130_fd_sc_hd__o21a_1
XPHY_EDGE_ROW_66_Right_66 VGND VGND VPWR VPWR sky130_fd_sc_hd__decap_3
XFILLER_45_897 VGND VGND VPWR VPWR sky130_fd_sc_hd__fill_1
X_13635_ clknet_leaf_49_clk _00645_ VGND VGND VPWR VPWR u_interface.fifo_data\[13\]\[18\]
+ sky130_fd_sc_hd__dfxtp_1
XFILLER_60_867 VGND VGND VPWR VPWR sky130_fd_sc_hd__fill_1
X_11896_ _05629_ _05630_ VGND VGND VPWR VPWR _05631_ sky130_fd_sc_hd__xor2_1
X_10847_ _04577_ _04588_ _04589_ VGND VGND VPWR VPWR _04592_ sky130_fd_sc_hd__nand3_1
X_13566_ clknet_leaf_34_clk _00576_ VGND VGND VPWR VPWR u_interface.fifo_data\[4\]\[13\]
+ sky130_fd_sc_hd__dfxtp_1
X_10778_ _04522_ _04523_ _04519_ VGND VGND VPWR VPWR _04524_ sky130_fd_sc_hd__a21o_1
XFILLER_9_721 VGND VGND VPWR VPWR sky130_fd_sc_hd__decap_6
XFILLER_13_783 VGND VGND VPWR VPWR sky130_fd_sc_hd__fill_1
X_13497_ clknet_leaf_3_clk _00507_ VGND VGND VPWR VPWR u_interface.u_gelu_fp32.u_synth_top.s2_m\[14\]
+ sky130_fd_sc_hd__dfxtp_1
XFILLER_9_765 VPWR VGND VPWR VGND sky130_ef_sc_hd__decap_12
XFILLER_8_253 VGND VGND VPWR VPWR sky130_fd_sc_hd__decap_8
X_12517_ _06240_ _06241_ VGND VGND VPWR VPWR _06242_ sky130_fd_sc_hd__and2_1
XFILLER_145_449 VGND VGND VPWR VPWR sky130_fd_sc_hd__decap_3
XFILLER_138_490 VGND VGND VPWR VPWR sky130_fd_sc_hd__decap_6
X_12448_ _06060_ _06062_ _06121_ VGND VGND VPWR VPWR _06175_ sky130_fd_sc_hd__or3_1
XTAP_TAPCELL_ROW_130_2420 VGND VPWR sky130_fd_sc_hd__tapvpwrvgnd_1
XTAP_TAPCELL_ROW_113_2139 VGND VPWR sky130_fd_sc_hd__tapvpwrvgnd_1
XFILLER_99_503 VGND VGND VPWR VPWR sky130_fd_sc_hd__fill_1
XTAP_TAPCELL_ROW_97_1894 VGND VPWR sky130_fd_sc_hd__tapvpwrvgnd_1
XTAP_TAPCELL_ROW_97_1883 VGND VPWR sky130_fd_sc_hd__tapvpwrvgnd_1
XPHY_EDGE_ROW_75_Right_75 VGND VGND VPWR VPWR sky130_fd_sc_hd__decap_3
XTAP_TAPCELL_ROW_10_494 VGND VPWR sky130_fd_sc_hd__tapvpwrvgnd_1
X_12379_ _06105_ _06106_ VGND VGND VPWR VPWR _06107_ sky130_fd_sc_hd__xnor2_1
X_14118_ clknet_leaf_33_clk _01044_ VGND VGND VPWR VPWR u_interface.meta_tlast_pipe\[11\]
+ sky130_fd_sc_hd__dfxtp_1
XFILLER_114_869 VGND VGND VPWR VPWR sky130_fd_sc_hd__decap_3
XFILLER_113_346 VPWR VGND VPWR VGND sky130_ef_sc_hd__decap_12
XFILLER_113_335 VGND VGND VPWR VPWR sky130_fd_sc_hd__fill_1
X_14049_ clknet_leaf_17_clk _00975_ VGND VGND VPWR VPWR u_interface.u_gelu_fp32.u_fp32_to_q16.s1_mant\[11\]
+ sky130_fd_sc_hd__dfxtp_1
XFILLER_140_154 VGND VGND VPWR VPWR sky130_fd_sc_hd__decap_8
X_06940_ u_interface.u_gelu_fp32.u_synth_top.s1_x\[25\] net273 VGND VGND VPWR VPWR
+ _01473_ sky130_fd_sc_hd__xnor2_1
XFILLER_79_293 VGND VGND VPWR VPWR sky130_fd_sc_hd__decap_6
X_06871_ u_interface.fifo_data\[12\]\[30\] u_interface.fifo_data\[13\]\[30\] u_interface.fifo_data\[14\]\[30\]
+ u_interface.fifo_data\[15\]\[30\] net760 net743 VGND VGND VPWR VPWR _01416_ sky130_fd_sc_hd__mux4_1
XFILLER_39_102 VGND VGND VPWR VPWR sky130_fd_sc_hd__decap_3
X_08610_ net154 _02388_ net801 VGND VGND VPWR VPWR _00788_ sky130_fd_sc_hd__a21oi_1
XFILLER_67_455 VGND VGND VPWR VPWR sky130_fd_sc_hd__fill_1
XTAP_TAPCELL_ROW_128_2382 VGND VPWR sky130_fd_sc_hd__tapvpwrvgnd_1
X_09590_ net462 net620 VGND VGND VPWR VPWR _03346_ sky130_fd_sc_hd__nand2_1
XPHY_EDGE_ROW_84_Right_84 VGND VGND VPWR VPWR sky130_fd_sc_hd__decap_3
XFILLER_82_436 VGND VGND VPWR VPWR sky130_fd_sc_hd__decap_6
X_08541_ _02291_ _02331_ VGND VGND VPWR VPWR _02332_ sky130_fd_sc_hd__xnor2_1
X_08472_ u_interface.u_gelu_fp32.u_synth_top.s3_mult\[37\] u_interface.u_gelu_fp32.u_synth_top.s3_mult\[36\]
+ net527 VGND VGND VPWR VPWR _02263_ sky130_fd_sc_hd__o21ai_1
XFILLER_36_886 VGND VGND VPWR VPWR sky130_fd_sc_hd__decap_8
XTAP_TAPCELL_ROW_141_2593 VGND VPWR sky130_fd_sc_hd__tapvpwrvgnd_1
X_07423_ _01558_ VGND VGND VPWR VPWR _01559_ sky130_fd_sc_hd__inv_2
XFILLER_24_29 VPWR VGND VPWR VGND sky130_ef_sc_hd__decap_12
XFILLER_51_878 VGND VGND VPWR VPWR sky130_fd_sc_hd__fill_2
XFILLER_11_709 VPWR VGND VPWR VGND sky130_ef_sc_hd__decap_12
XFILLER_149_744 VGND VGND VPWR VPWR sky130_fd_sc_hd__decap_3
X_07354_ net346 net1437 net243 VGND VGND VPWR VPWR _00384_ sky130_fd_sc_hd__mux2_1
XFILLER_50_377 VGND VGND VPWR VPWR sky130_fd_sc_hd__fill_1
XFILLER_136_405 VGND VGND VPWR VPWR sky130_fd_sc_hd__decap_8
X_07285_ net1133 net357 net247 VGND VGND VPWR VPWR _00315_ sky130_fd_sc_hd__mux2_1
XFILLER_31_591 VPWR VGND VPWR VGND sky130_ef_sc_hd__decap_12
X_09024_ net663 net670 net516 net520 VGND VGND VPWR VPWR _02783_ sky130_fd_sc_hd__and4_1
XPHY_EDGE_ROW_93_Right_93 VGND VGND VPWR VPWR sky130_fd_sc_hd__decap_3
Xhold220 u_interface.fifo_data\[0\]\[1\] VGND VGND VPWR VPWR net1085 sky130_fd_sc_hd__dlygate4sd3_1
Xhold242 u_interface.fifo_data\[12\]\[22\] VGND VGND VPWR VPWR net1107 sky130_fd_sc_hd__dlygate4sd3_1
Xhold253 u_interface.fifo_data\[2\]\[16\] VGND VGND VPWR VPWR net1118 sky130_fd_sc_hd__dlygate4sd3_1
Xhold231 u_interface.fifo_data\[14\]\[24\] VGND VGND VPWR VPWR net1096 sky130_fd_sc_hd__dlygate4sd3_1
XTAP_TAPCELL_ROW_148_2703 VGND VPWR sky130_fd_sc_hd__tapvpwrvgnd_1
XFILLER_105_858 VGND VGND VPWR VPWR sky130_fd_sc_hd__decap_6
Xfanout700 u_interface.u_gelu_fp32.u_synth_top.s2_m\[14\] VGND VGND VPWR VPWR net700
+ sky130_fd_sc_hd__clkbuf_4
Xhold264 u_interface.fifo_data\[1\]\[18\] VGND VGND VPWR VPWR net1129 sky130_fd_sc_hd__dlygate4sd3_1
Xhold275 u_interface.fifo_data\[13\]\[18\] VGND VGND VPWR VPWR net1140 sky130_fd_sc_hd__dlygate4sd3_1
XFILLER_49_15 VPWR VGND VPWR VGND sky130_ef_sc_hd__decap_12
Xhold286 u_interface.fifo_data\[15\]\[6\] VGND VGND VPWR VPWR net1151 sky130_fd_sc_hd__dlygate4sd3_1
XFILLER_132_699 VGND VGND VPWR VPWR sky130_fd_sc_hd__fill_1
Xfanout733 net737 VGND VGND VPWR VPWR net733 sky130_fd_sc_hd__buf_4
X_09926_ _03675_ _03678_ VGND VGND VPWR VPWR _03679_ sky130_fd_sc_hd__xnor2_1
Xhold297 u_interface.fifo_data\[2\]\[27\] VGND VGND VPWR VPWR net1162 sky130_fd_sc_hd__dlygate4sd3_1
Xfanout722 net724 VGND VGND VPWR VPWR net722 sky130_fd_sc_hd__buf_2
Xfanout711 net712 VGND VGND VPWR VPWR net711 sky130_fd_sc_hd__buf_2
Xfanout766 net771 VGND VGND VPWR VPWR net766 sky130_fd_sc_hd__buf_4
Xfanout744 net745 VGND VGND VPWR VPWR net744 sky130_fd_sc_hd__buf_2
Xfanout755 net756 VGND VGND VPWR VPWR net755 sky130_fd_sc_hd__buf_4
Xfanout777 net779 VGND VGND VPWR VPWR net777 sky130_fd_sc_hd__clkbuf_2
Xfanout788 net790 VGND VGND VPWR VPWR net788 sky130_fd_sc_hd__clkbuf_2
X_09857_ _03458_ _03460_ _03608_ _03609_ VGND VGND VPWR VPWR _03611_ sky130_fd_sc_hd__o211ai_1
XFILLER_100_563 VPWR VGND VPWR VGND sky130_ef_sc_hd__decap_12
XFILLER_100_541 VGND VGND VPWR VPWR sky130_fd_sc_hd__fill_1
Xfanout799 net800 VGND VGND VPWR VPWR net799 sky130_fd_sc_hd__buf_2
XFILLER_19_809 VPWR VGND VPWR VGND sky130_ef_sc_hd__decap_12
XTAP_TAPCELL_ROW_29_804 VGND VPWR sky130_fd_sc_hd__tapvpwrvgnd_1
X_08808_ net613 net621 net487 net493 VGND VGND VPWR VPWR _02567_ sky130_fd_sc_hd__and4_1
XFILLER_105_87 VPWR VGND VPWR VGND sky130_ef_sc_hd__decap_12
X_09788_ _03486_ _03489_ VGND VGND VPWR VPWR _03542_ sky130_fd_sc_hd__nand2_1
XFILLER_58_499 VGND VGND VPWR VPWR sky130_fd_sc_hd__decap_6
XFILLER_58_477 VPWR VGND VPWR VGND sky130_ef_sc_hd__decap_12
X_08739_ _02492_ _02495_ _02496_ VGND VGND VPWR VPWR _02498_ sky130_fd_sc_hd__nand3_2
XFILLER_73_447 VGND VGND VPWR VPWR sky130_fd_sc_hd__fill_1
XFILLER_45_149 VGND VGND VPWR VPWR sky130_fd_sc_hd__decap_6
XFILLER_27_853 VPWR VGND VPWR VGND sky130_ef_sc_hd__decap_12
X_11750_ _05486_ _05485_ VGND VGND VPWR VPWR _00830_ sky130_fd_sc_hd__and2b_1
XFILLER_27_897 VPWR VGND VPWR VGND sky130_ef_sc_hd__decap_12
X_10701_ _04326_ _04327_ _04446_ VGND VGND VPWR VPWR _04447_ sky130_fd_sc_hd__a21o_1
XFILLER_53_160 VGND VGND VPWR VPWR sky130_fd_sc_hd__fill_1
XFILLER_81_57 VGND VGND VPWR VPWR sky130_fd_sc_hd__fill_1
XTAP_TAPCELL_ROW_64_1359 VGND VPWR sky130_fd_sc_hd__tapvpwrvgnd_1
XFILLER_14_569 VPWR VGND VPWR VGND sky130_ef_sc_hd__decap_12
X_11681_ net719 net429 net424 net711 VGND VGND VPWR VPWR _05418_ sky130_fd_sc_hd__a22o_1
XFILLER_41_355 VPWR VGND VPWR VGND sky130_ef_sc_hd__decap_12
XFILLER_42_878 VGND VGND VPWR VPWR sky130_fd_sc_hd__fill_2
X_13420_ clknet_leaf_18_clk _00430_ VGND VGND VPWR VPWR u_interface.u_gelu_fp32.u_fp32_to_q16.s3_frac\[0\]
+ sky130_fd_sc_hd__dfxtp_1
X_10632_ net644 net436 VGND VGND VPWR VPWR _04379_ sky130_fd_sc_hd__and2_1
XFILLER_22_580 VGND VGND VPWR VPWR sky130_fd_sc_hd__decap_8
XFILLER_155_714 VGND VGND VPWR VPWR sky130_fd_sc_hd__decap_3
X_13351_ clknet_leaf_38_clk _00361_ VGND VGND VPWR VPWR u_interface.fifo_data\[10\]\[28\]
+ sky130_fd_sc_hd__dfxtp_1
X_10563_ _04309_ _04310_ VGND VGND VPWR VPWR _04311_ sky130_fd_sc_hd__nor2_1
X_12302_ _06029_ _06030_ VGND VGND VPWR VPWR _06031_ sky130_fd_sc_hd__or2_1
XFILLER_6_713 VPWR VGND VPWR VGND sky130_ef_sc_hd__decap_12
X_13282_ clknet_leaf_47_clk _00292_ VGND VGND VPWR VPWR u_interface.fifo_data\[0\]\[24\]
+ sky130_fd_sc_hd__dfxtp_1
X_10494_ net453 net669 net678 net457 VGND VGND VPWR VPWR _04242_ sky130_fd_sc_hd__a22o_1
XFILLER_6_757 VPWR VGND VPWR VGND sky130_ef_sc_hd__decap_12
XFILLER_5_223 VGND VGND VPWR VPWR sky130_fd_sc_hd__fill_1
XFILLER_135_482 VPWR VGND VPWR VGND sky130_ef_sc_hd__decap_12
X_12233_ net709 net395 VGND VGND VPWR VPWR _05963_ sky130_fd_sc_hd__nand2_1
XFILLER_30_83 VGND VGND VPWR VPWR sky130_fd_sc_hd__fill_1
X_12164_ net693 net391 VGND VGND VPWR VPWR _05895_ sky130_fd_sc_hd__nand2_1
XFILLER_150_474 VGND VGND VPWR VPWR sky130_fd_sc_hd__fill_2
XFILLER_150_452 VGND VGND VPWR VPWR sky130_fd_sc_hd__fill_2
XFILLER_123_666 VGND VGND VPWR VPWR sky130_fd_sc_hd__decap_6
XFILLER_111_839 VGND VGND VPWR VPWR sky130_fd_sc_hd__fill_1
X_11115_ _04852_ _04857_ VGND VGND VPWR VPWR _04858_ sky130_fd_sc_hd__nand2_1
X_12095_ _05825_ _05826_ VGND VGND VPWR VPWR _05827_ sky130_fd_sc_hd__xnor2_1
XFILLER_77_742 VGND VGND VPWR VPWR sky130_fd_sc_hd__fill_1
X_11046_ _04673_ _04787_ VGND VGND VPWR VPWR _04790_ sky130_fd_sc_hd__xnor2_1
XFILLER_1_473 VPWR VGND VPWR VGND sky130_ef_sc_hd__decap_12
XFILLER_92_701 VGND VGND VPWR VPWR sky130_fd_sc_hd__fill_1
XFILLER_49_488 VGND VGND VPWR VPWR sky130_fd_sc_hd__fill_1
XFILLER_37_617 VPWR VGND VPWR VGND sky130_ef_sc_hd__decap_12
X_12997_ net995 net356 net223 VGND VGND VPWR VPWR _01080_ sky130_fd_sc_hd__mux2_1
XFILLER_51_108 VGND VGND VPWR VPWR sky130_fd_sc_hd__decap_4
XFILLER_17_396 VPWR VGND VPWR VGND sky130_ef_sc_hd__decap_12
X_11948_ _05680_ _05681_ VGND VGND VPWR VPWR _05682_ sky130_fd_sc_hd__xnor2_1
XFILLER_60_642 VGND VGND VPWR VPWR sky130_fd_sc_hd__fill_2
X_11879_ _05604_ _05613_ VGND VGND VPWR VPWR _05614_ sky130_fd_sc_hd__xnor2_1
XFILLER_33_889 VGND VGND VPWR VPWR sky130_fd_sc_hd__decap_6
X_13618_ clknet_leaf_53_clk _00628_ VGND VGND VPWR VPWR u_interface.fifo_data\[13\]\[1\]
+ sky130_fd_sc_hd__dfxtp_1
XTAP_TAPCELL_ROW_99_1912 VGND VPWR sky130_fd_sc_hd__tapvpwrvgnd_1
XTAP_TAPCELL_ROW_15_575 VGND VPWR sky130_fd_sc_hd__tapvpwrvgnd_1
X_13549_ clknet_leaf_39_clk _00559_ VGND VGND VPWR VPWR u_interface.fifo_data\[5\]\[28\]
+ sky130_fd_sc_hd__dfxtp_1
XTAP_TAPCELL_ROW_99_1923 VGND VPWR sky130_fd_sc_hd__tapvpwrvgnd_1
XFILLER_145_202 VGND VGND VPWR VPWR sky130_fd_sc_hd__fill_1
XFILLER_72_3 VPWR VGND VPWR VGND sky130_ef_sc_hd__decap_12
XFILLER_9_573 VPWR VGND VPWR VGND sky130_ef_sc_hd__decap_12
X_07070_ net1223 net342 net207 VGND VGND VPWR VPWR _00110_ sky130_fd_sc_hd__mux2_1
XFILLER_142_920 VGND VGND VPWR VPWR sky130_fd_sc_hd__fill_1
XFILLER_141_430 VGND VGND VPWR VPWR sky130_fd_sc_hd__decap_4
XFILLER_87_528 VGND VGND VPWR VPWR sky130_fd_sc_hd__decap_8
XFILLER_141_485 VGND VGND VPWR VPWR sky130_fd_sc_hd__decap_6
X_07972_ net543 _01684_ net279 _01599_ net811 VGND VGND VPWR VPWR _01848_ sky130_fd_sc_hd__a221o_1
XFILLER_113_176 VPWR VGND VPWR VGND sky130_ef_sc_hd__decap_12
X_09711_ _03464_ _03465_ _03362_ VGND VGND VPWR VPWR _03466_ sky130_fd_sc_hd__nor3b_1
XFILLER_101_349 VGND VGND VPWR VPWR sky130_fd_sc_hd__fill_2
X_06923_ u_interface.u_gelu_fp32.u_synth_top.s1_x\[22\] net274 VGND VGND VPWR VPWR
+ _01459_ sky130_fd_sc_hd__or2_1
XFILLER_67_241 VGND VGND VPWR VPWR sky130_fd_sc_hd__decap_4
X_06854_ u_interface.fifo_data\[8\]\[28\] u_interface.fifo_data\[9\]\[28\] u_interface.fifo_data\[10\]\[28\]
+ u_interface.fifo_data\[11\]\[28\] net769 net752 VGND VGND VPWR VPWR _01401_ sky130_fd_sc_hd__mux4_1
XTAP_TAPCELL_ROW_143_2622 VGND VPWR sky130_fd_sc_hd__tapvpwrvgnd_1
X_09642_ _03396_ _03397_ _03380_ VGND VGND VPWR VPWR _03398_ sky130_fd_sc_hd__o21ai_1
X_06785_ u_interface.fifo_data\[0\]\[19\] u_interface.fifo_data\[1\]\[19\] u_interface.fifo_data\[2\]\[19\]
+ u_interface.fifo_data\[3\]\[19\] net770 net753 VGND VGND VPWR VPWR _01341_ sky130_fd_sc_hd__mux4_1
X_09573_ net483 net672 VGND VGND VPWR VPWR _03329_ sky130_fd_sc_hd__nand2_1
XFILLER_82_233 VPWR VGND VPWR VGND sky130_ef_sc_hd__decap_12
XFILLER_55_447 VGND VGND VPWR VPWR sky130_fd_sc_hd__fill_1
XFILLER_70_406 VGND VGND VPWR VPWR sky130_fd_sc_hd__fill_1
XFILLER_43_609 VGND VGND VPWR VPWR sky130_fd_sc_hd__decap_6
X_08524_ _02296_ _02307_ _02310_ VGND VGND VPWR VPWR _02315_ sky130_fd_sc_hd__o21ai_4
XFILLER_35_39 VPWR VGND VPWR VGND sky130_ef_sc_hd__decap_12
XFILLER_36_661 VGND VGND VPWR VPWR sky130_fd_sc_hd__fill_1
X_08455_ net527 u_interface.u_gelu_fp32.u_synth_top.s3_mult\[34\] VGND VGND VPWR VPWR
+ _02246_ sky130_fd_sc_hd__nand2_1
XFILLER_50_141 VPWR VGND VPWR VGND sky130_ef_sc_hd__decap_12
XTAP_TAPCELL_ROW_46_1067 VGND VPWR sky130_fd_sc_hd__tapvpwrvgnd_1
XFILLER_24_867 VGND VGND VPWR VPWR sky130_fd_sc_hd__fill_1
X_07406_ net542 net774 VGND VGND VPWR VPWR _01542_ sky130_fd_sc_hd__and2_1
X_08386_ u_interface.u_gelu_fp32.u_synth_top.s3_mult\[31\] u_interface.u_gelu_fp32.u_synth_top.s3_b\[15\]
+ VGND VGND VPWR VPWR _02177_ sky130_fd_sc_hd__and2_1
XFILLER_51_27 VGND VGND VPWR VPWR sky130_fd_sc_hd__decap_4
XTAP_TAPCELL_ROW_46_1078 VGND VPWR sky130_fd_sc_hd__tapvpwrvgnd_1
XFILLER_11_517 VPWR VGND VPWR VGND sky130_ef_sc_hd__decap_12
XFILLER_23_377 VGND VGND VPWR VPWR sky130_fd_sc_hd__decap_4
XTAP_TAPCELL_ROW_34_873 VGND VPWR sky130_fd_sc_hd__tapvpwrvgnd_1
XTAP_TAPCELL_ROW_34_884 VGND VPWR sky130_fd_sc_hd__tapvpwrvgnd_1
X_07337_ net381 net1555 net241 VGND VGND VPWR VPWR _00367_ sky130_fd_sc_hd__mux2_1
X_07268_ net108 net150 VGND VGND VPWR VPWR _01535_ sky130_fd_sc_hd__and2_1
XTAP_TAPCELL_ROW_154_2795 VGND VPWR sky130_fd_sc_hd__tapvpwrvgnd_1
XFILLER_151_216 VGND VGND VPWR VPWR sky130_fd_sc_hd__decap_8
X_09007_ _02735_ _02736_ _02751_ VGND VGND VPWR VPWR _02766_ sky130_fd_sc_hd__o21ai_1
XFILLER_124_419 VGND VGND VPWR VPWR sky130_fd_sc_hd__fill_1
X_07199_ net371 net1591 net259 VGND VGND VPWR VPWR _00239_ sky130_fd_sc_hd__mux2_1
XFILLER_105_600 VPWR VGND VPWR VGND sky130_ef_sc_hd__decap_12
XFILLER_3_727 VGND VGND VPWR VPWR sky130_fd_sc_hd__fill_1
XFILLER_105_666 VGND VGND VPWR VPWR sky130_fd_sc_hd__decap_6
Xfanout541 u_interface.u_gelu_fp32.u_fp32_to_q16.s3_sign VGND VGND VPWR VPWR net541
+ sky130_fd_sc_hd__clkbuf_4
XFILLER_120_625 VGND VGND VPWR VPWR sky130_fd_sc_hd__decap_3
XFILLER_76_24 VGND VGND VPWR VPWR sky130_fd_sc_hd__decap_4
Xfanout530 net531 VGND VGND VPWR VPWR net530 sky130_fd_sc_hd__buf_2
Xfanout552 net553 VGND VGND VPWR VPWR net552 sky130_fd_sc_hd__buf_2
Xfanout574 u_interface.core_data_out\[25\] VGND VGND VPWR VPWR net574 sky130_fd_sc_hd__buf_1
X_09909_ _03656_ _03661_ VGND VGND VPWR VPWR _03662_ sky130_fd_sc_hd__xnor2_1
Xfanout563 u_interface.core_data_out\[30\] VGND VGND VPWR VPWR net563 sky130_fd_sc_hd__clkbuf_2
X_12920_ _01099_ _06445_ VGND VGND VPWR VPWR _06447_ sky130_fd_sc_hd__or2_1
Xfanout585 u_interface.u_gelu_fp32.u_synth_top.s2_m\[0\] VGND VGND VPWR VPWR net585
+ sky130_fd_sc_hd__buf_2
XFILLER_100_371 VGND VGND VPWR VPWR sky130_fd_sc_hd__fill_1
Xfanout596 u_interface.u_gelu_fp32.u_synth_top.s2_m\[2\] VGND VGND VPWR VPWR net596
+ sky130_fd_sc_hd__buf_1
XFILLER_19_617 VPWR VGND VPWR VGND sky130_ef_sc_hd__decap_12
X_12851_ net69 net1710 VGND VGND VPWR VPWR _06432_ sky130_fd_sc_hd__nand2b_1
XFILLER_73_211 VGND VGND VPWR VPWR sky130_fd_sc_hd__fill_1
XFILLER_46_436 VGND VGND VPWR VPWR sky130_fd_sc_hd__fill_2
XFILLER_18_149 VGND VGND VPWR VPWR sky130_fd_sc_hd__fill_2
XFILLER_74_778 VPWR VGND VPWR VGND sky130_ef_sc_hd__decap_12
XFILLER_62_918 VGND VGND VPWR VPWR sky130_fd_sc_hd__decap_3
X_11802_ _05443_ _05452_ _05451_ VGND VGND VPWR VPWR _05538_ sky130_fd_sc_hd__a21boi_1
XFILLER_92_78 VGND VGND VPWR VPWR sky130_fd_sc_hd__decap_6
X_12782_ _01783_ _06407_ VGND VGND VPWR VPWR _00951_ sky130_fd_sc_hd__nor2_1
X_11733_ _05468_ _05469_ VGND VGND VPWR VPWR _05470_ sky130_fd_sc_hd__nor2_1
XFILLER_15_889 VGND VGND VPWR VPWR sky130_fd_sc_hd__decap_6
XFILLER_30_837 VPWR VGND VPWR VGND sky130_ef_sc_hd__decap_12
X_11664_ _05320_ _05327_ _05326_ VGND VGND VPWR VPWR _05401_ sky130_fd_sc_hd__a21bo_1
X_13403_ clknet_leaf_32_clk _00413_ VGND VGND VPWR VPWR u_interface.fifo_data\[6\]\[16\]
+ sky130_fd_sc_hd__dfxtp_1
X_10615_ _04239_ _04245_ _04246_ VGND VGND VPWR VPWR _04362_ sky130_fd_sc_hd__a21bo_1
XTAP_TAPCELL_ROW_12_523 VGND VPWR sky130_fd_sc_hd__tapvpwrvgnd_1
XTAP_TAPCELL_ROW_12_534 VGND VPWR sky130_fd_sc_hd__tapvpwrvgnd_1
X_11595_ net719 net435 VGND VGND VPWR VPWR _05333_ sky130_fd_sc_hd__nand2_1
X_13334_ clknet_leaf_52_clk _00344_ VGND VGND VPWR VPWR u_interface.fifo_data\[10\]\[11\]
+ sky130_fd_sc_hd__dfxtp_1
X_10546_ _04276_ _04277_ _04293_ VGND VGND VPWR VPWR _04294_ sky130_fd_sc_hd__a21o_1
X_13265_ clknet_leaf_45_clk _00275_ VGND VGND VPWR VPWR u_interface.fifo_data\[0\]\[7\]
+ sky130_fd_sc_hd__dfxtp_1
XTAP_TAPCELL_ROW_94_1842 VGND VPWR sky130_fd_sc_hd__tapvpwrvgnd_1
X_10477_ _04109_ _04224_ net722 VGND VGND VPWR VPWR _04225_ sky130_fd_sc_hd__and3b_1
XFILLER_6_587 VGND VGND VPWR VPWR sky130_fd_sc_hd__fill_1
X_12216_ net198 _05945_ VGND VGND VPWR VPWR _05946_ sky130_fd_sc_hd__and2_1
XFILLER_123_441 VGND VGND VPWR VPWR sky130_fd_sc_hd__decap_6
X_13196_ clknet_leaf_75_clk _00206_ VGND VGND VPWR VPWR u_interface.fifo_data\[12\]\[6\]
+ sky130_fd_sc_hd__dfxtp_1
XFILLER_2_793 VPWR VGND VPWR VGND sky130_ef_sc_hd__decap_12
X_12147_ _05815_ _05818_ _05819_ VGND VGND VPWR VPWR _05878_ sky130_fd_sc_hd__a21oi_1
XFILLER_1_281 VPWR VGND VPWR VGND sky130_ef_sc_hd__decap_12
X_12078_ _05808_ _05809_ VGND VGND VPWR VPWR _05810_ sky130_fd_sc_hd__nor2_1
XFILLER_110_179 VPWR VGND VPWR VGND sky130_ef_sc_hd__decap_12
X_11029_ _04771_ _04772_ VGND VGND VPWR VPWR _04773_ sky130_fd_sc_hd__and2b_1
XFILLER_2_65 VPWR VGND VPWR VGND sky130_ef_sc_hd__decap_12
XTAP_TAPCELL_ROW_125_2341 VGND VPWR sky130_fd_sc_hd__tapvpwrvgnd_1
XTAP_TAPCELL_ROW_125_2330 VGND VPWR sky130_fd_sc_hd__tapvpwrvgnd_1
XFILLER_53_918 VGND VGND VPWR VPWR sky130_fd_sc_hd__decap_3
X_06570_ net537 u_interface.u_gelu_fp32.s1_data\[14\] VGND VGND VPWR VPWR _01162_
+ sky130_fd_sc_hd__nand2_1
XFILLER_64_299 VGND VGND VPWR VPWR sky130_fd_sc_hd__fill_1
XFILLER_33_653 VPWR VGND VPWR VGND sky130_ef_sc_hd__decap_12
XTAP_TAPCELL_ROW_103_1982 VGND VPWR sky130_fd_sc_hd__tapvpwrvgnd_1
X_08240_ net289 _02066_ VGND VGND VPWR VPWR _00740_ sky130_fd_sc_hd__nor2_1
XFILLER_33_697 VPWR VGND VPWR VGND sky130_ef_sc_hd__decap_12
X_08171_ u_interface.u_gelu_fp32.u_fp32_to_q16.s3_mag\[20\] _01886_ VGND VGND VPWR
+ VPWR _02008_ sky130_fd_sc_hd__nor2_1
XANTENNA_15 _01519_ VGND VGND VPWR VPWR sky130_fd_sc_hd__diode_2
XTAP_TAPCELL_ROW_31_832 VGND VPWR sky130_fd_sc_hd__tapvpwrvgnd_1
X_07122_ net1163 net324 net235 VGND VGND VPWR VPWR _00162_ sky130_fd_sc_hd__mux2_1
XFILLER_20_358 VGND VGND VPWR VPWR sky130_fd_sc_hd__decap_3
XFILLER_20_369 VGND VGND VPWR VPWR sky130_fd_sc_hd__fill_1
XFILLER_118_224 VPWR VGND VPWR VGND sky130_ef_sc_hd__decap_12
X_07053_ net1433 net376 net207 VGND VGND VPWR VPWR _00093_ sky130_fd_sc_hd__mux2_1
XFILLER_133_249 VGND VGND VPWR VPWR sky130_fd_sc_hd__decap_8
Xoutput111 net111 VGND VGND VPWR VPWR m_axis_tdata[11] sky130_fd_sc_hd__buf_2
Xoutput133 net133 VGND VGND VPWR VPWR m_axis_tdata[31] sky130_fd_sc_hd__buf_2
Xoutput122 net122 VGND VGND VPWR VPWR m_axis_tdata[21] sky130_fd_sc_hd__buf_2
Xoutput144 net144 VGND VGND VPWR VPWR s_axil_arready sky130_fd_sc_hd__buf_2
XFILLER_101_113 VGND VGND VPWR VPWR sky130_fd_sc_hd__decap_4
X_07955_ u_interface.u_gelu_fp32.u_fp32_to_q16.s2_shift\[4\] net303 VGND VGND VPWR
+ VPWR _01839_ sky130_fd_sc_hd__and2_1
XFILLER_101_157 VGND VGND VPWR VPWR sky130_fd_sc_hd__fill_2
X_06906_ _01445_ _01446_ VGND VGND VPWR VPWR _00034_ sky130_fd_sc_hd__xnor2_1
XFILLER_56_701 VGND VGND VPWR VPWR sky130_fd_sc_hd__decap_3
X_09625_ _03286_ _03294_ _03295_ VGND VGND VPWR VPWR _03381_ sky130_fd_sc_hd__a21o_1
X_07886_ net1044 net345 net265 VGND VGND VPWR VPWR _00647_ sky130_fd_sc_hd__mux2_1
XFILLER_55_222 VGND VGND VPWR VPWR sky130_fd_sc_hd__fill_2
XFILLER_46_27 VGND VGND VPWR VPWR sky130_fd_sc_hd__fill_1
XFILLER_28_447 VGND VGND VPWR VPWR sky130_fd_sc_hd__fill_2
XTAP_TAPCELL_ROW_39_954 VGND VPWR sky130_fd_sc_hd__tapvpwrvgnd_1
X_06837_ u_interface.fifo_data\[8\]\[26\] u_interface.fifo_data\[9\]\[26\] u_interface.fifo_data\[10\]\[26\]
+ u_interface.fifo_data\[11\]\[26\] net770 net753 VGND VGND VPWR VPWR _01386_ sky130_fd_sc_hd__mux4_1
XTAP_TAPCELL_ROW_48_1107 VGND VPWR sky130_fd_sc_hd__tapvpwrvgnd_1
XTAP_TAPCELL_ROW_39_965 VGND VPWR sky130_fd_sc_hd__tapvpwrvgnd_1
X_06768_ net733 _01323_ net728 VGND VGND VPWR VPWR _01326_ sky130_fd_sc_hd__o21a_1
X_09556_ _03226_ _03309_ _03310_ VGND VGND VPWR VPWR _03313_ sky130_fd_sc_hd__nand3_1
X_09487_ _03139_ _03147_ _03148_ VGND VGND VPWR VPWR _03244_ sky130_fd_sc_hd__a21o_1
XFILLER_102_77 VGND VGND VPWR VPWR sky130_fd_sc_hd__decap_6
XFILLER_62_15 VPWR VGND VPWR VGND sky130_ef_sc_hd__decap_12
X_06699_ _01264_ _01265_ net729 VGND VGND VPWR VPWR _01266_ sky130_fd_sc_hd__mux2_1
X_08507_ net521 u_interface.u_gelu_fp32.u_synth_top.s3_mult\[53\] VGND VGND VPWR VPWR
+ _02298_ sky130_fd_sc_hd__or2_1
XFILLER_141_6 VGND VGND VPWR VPWR sky130_fd_sc_hd__fill_1
X_08438_ _02192_ _02227_ VGND VGND VPWR VPWR _02229_ sky130_fd_sc_hd__nor2_1
XFILLER_62_48 VGND VGND VPWR VPWR sky130_fd_sc_hd__fill_1
XTAP_TAPCELL_ROW_61_1318 VGND VPWR sky130_fd_sc_hd__tapvpwrvgnd_1
XTAP_TAPCELL_ROW_61_1307 VGND VPWR sky130_fd_sc_hd__tapvpwrvgnd_1
XFILLER_51_483 VGND VGND VPWR VPWR sky130_fd_sc_hd__decap_3
XFILLER_11_314 VPWR VGND VPWR VGND sky130_ef_sc_hd__decap_12
XFILLER_12_837 VPWR VGND VPWR VGND sky130_ef_sc_hd__decap_12
XFILLER_149_382 VGND VGND VPWR VPWR sky130_fd_sc_hd__fill_1
XFILLER_137_511 VGND VGND VPWR VPWR sky130_fd_sc_hd__decap_8
XFILLER_109_202 VPWR VGND VPWR VGND sky130_ef_sc_hd__decap_12
X_08369_ _02156_ _02157_ _02159_ VGND VGND VPWR VPWR _02160_ sky130_fd_sc_hd__and3b_1
XFILLER_149_393 VPWR VGND VPWR VGND sky130_ef_sc_hd__decap_12
XFILLER_109_257 VPWR VGND VPWR VGND sky130_ef_sc_hd__decap_12
X_10400_ _04148_ _04147_ VGND VGND VPWR VPWR _04149_ sky130_fd_sc_hd__and2b_1
X_11380_ _05116_ _05117_ _05119_ net794 VGND VGND VPWR VPWR _05121_ sky130_fd_sc_hd__a31o_1
XFILLER_20_881 VPWR VGND VPWR VGND sky130_ef_sc_hd__decap_12
X_10331_ _04077_ _04080_ VGND VGND VPWR VPWR _04081_ sky130_fd_sc_hd__nand2_1
XFILLER_124_238 VPWR VGND VPWR VGND sky130_ef_sc_hd__decap_12
XFILLER_106_920 VGND VGND VPWR VPWR sky130_fd_sc_hd__fill_1
X_10262_ _04008_ _04009_ _04010_ VGND VGND VPWR VPWR _04012_ sky130_fd_sc_hd__a21o_1
XTAP_TAPCELL_ROW_76_1550 VGND VPWR sky130_fd_sc_hd__tapvpwrvgnd_1
X_13050_ clknet_leaf_74_clk _00060_ VGND VGND VPWR VPWR u_interface.fifo_data\[14\]\[3\]
+ sky130_fd_sc_hd__dfxtp_1
XFILLER_2_3 VPWR VGND VPWR VGND sky130_ef_sc_hd__decap_12
X_12001_ _05732_ _05733_ VGND VGND VPWR VPWR _05734_ sky130_fd_sc_hd__nor2_1
X_10193_ _03925_ _03943_ VGND VGND VPWR VPWR _03944_ sky130_fd_sc_hd__and2_1
XFILLER_78_369 VPWR VGND VPWR VGND sky130_ef_sc_hd__decap_12
Xfanout371 u_interface.core_data_out\[7\] VGND VGND VPWR VPWR net371 sky130_fd_sc_hd__buf_1
XFILLER_120_488 VPWR VGND VPWR VGND sky130_ef_sc_hd__decap_12
XFILLER_120_466 VGND VGND VPWR VPWR sky130_fd_sc_hd__fill_2
Xfanout382 net383 VGND VGND VPWR VPWR net382 sky130_fd_sc_hd__clkbuf_2
X_13952_ clknet_leaf_55_clk _00878_ VGND VGND VPWR VPWR u_interface.u_gelu_fp32.u_q16_to_fp32.s2_exp\[4\]
+ sky130_fd_sc_hd__dfxtp_1
Xfanout360 u_interface.core_data_out\[12\] VGND VGND VPWR VPWR net360 sky130_fd_sc_hd__clkbuf_2
Xfanout393 net396 VGND VGND VPWR VPWR net393 sky130_fd_sc_hd__buf_2
X_12903_ u_interface.core_valid_out u_interface.fifo_wr_ptr\[0\] net827 VGND VGND
+ VPWR VPWR _06435_ sky130_fd_sc_hd__a21oi_1
XFILLER_74_531 VGND VGND VPWR VPWR sky130_fd_sc_hd__fill_1
X_13883_ clknet_leaf_5_clk _00036_ VGND VGND VPWR VPWR u_interface.u_gelu_fp32.u_synth_top.s2_dx\[19\]
+ sky130_fd_sc_hd__dfxtp_1
XFILLER_47_789 VGND VGND VPWR VPWR sky130_fd_sc_hd__fill_1
XFILLER_46_244 VGND VGND VPWR VPWR sky130_fd_sc_hd__decap_8
XTAP_TAPCELL_ROW_17_604 VGND VPWR sky130_fd_sc_hd__tapvpwrvgnd_1
X_12834_ net785 net951 VGND VGND VPWR VPWR _00992_ sky130_fd_sc_hd__and2_1
XFILLER_61_225 VGND VGND VPWR VPWR sky130_fd_sc_hd__fill_2
XFILLER_46_277 VPWR VGND VPWR VGND sky130_ef_sc_hd__decap_12
XTAP_TAPCELL_ROW_17_615 VGND VPWR sky130_fd_sc_hd__tapvpwrvgnd_1
X_12765_ u_interface.u_gelu_fp32.u_q16_to_fp32.s3_norm_mag\[11\] _01776_ net297 VGND
+ VGND VPWR VPWR _06399_ sky130_fd_sc_hd__o21ai_1
XFILLER_15_653 VPWR VGND VPWR VGND sky130_ef_sc_hd__decap_12
XTAP_TAPCELL_ROW_120_2260 VGND VPWR sky130_fd_sc_hd__tapvpwrvgnd_1
XFILLER_70_781 VGND VGND VPWR VPWR sky130_fd_sc_hd__decap_4
XFILLER_14_141 VPWR VGND VPWR VGND sky130_ef_sc_hd__decap_12
XFILLER_15_697 VPWR VGND VPWR VGND sky130_ef_sc_hd__decap_12
X_11716_ _05443_ _05452_ VGND VGND VPWR VPWR _05453_ sky130_fd_sc_hd__xnor2_1
XFILLER_30_601 VPWR VGND VPWR VGND sky130_ef_sc_hd__decap_12
X_12696_ _01736_ _01749_ _06354_ _01697_ VGND VGND VPWR VPWR _06355_ sky130_fd_sc_hd__o22a_1
XFILLER_30_645 VPWR VGND VPWR VGND sky130_ef_sc_hd__decap_12
Xinput13 s_axil_araddr[19] VGND VGND VPWR VPWR net13 sky130_fd_sc_hd__clkbuf_1
X_11647_ _05235_ _05289_ _05290_ VGND VGND VPWR VPWR _05385_ sky130_fd_sc_hd__a21o_1
Xinput46 s_axil_awaddr[19] VGND VGND VPWR VPWR net46 sky130_fd_sc_hd__clkbuf_1
Xinput35 s_axil_arvalid VGND VGND VPWR VPWR net35 sky130_fd_sc_hd__clkbuf_1
Xinput24 s_axil_araddr[29] VGND VGND VPWR VPWR net24 sky130_fd_sc_hd__buf_1
XFILLER_128_533 VGND VGND VPWR VPWR sky130_fd_sc_hd__decap_8
X_11578_ _05222_ _05231_ _05234_ VGND VGND VPWR VPWR _05316_ sky130_fd_sc_hd__o21ai_1
XFILLER_7_841 VPWR VGND VPWR VGND sky130_ef_sc_hd__decap_12
Xinput57 s_axil_awaddr[29] VGND VGND VPWR VPWR net57 sky130_fd_sc_hd__clkbuf_2
Xinput68 s_axil_awvalid VGND VGND VPWR VPWR net68 sky130_fd_sc_hd__clkbuf_1
Xinput79 s_axis_tdata[14] VGND VGND VPWR VPWR net79 sky130_fd_sc_hd__clkbuf_1
X_13317_ clknet_leaf_40_clk _00327_ VGND VGND VPWR VPWR u_interface.fifo_data\[8\]\[26\]
+ sky130_fd_sc_hd__dfxtp_1
Xhold808 u_interface.u_gelu_fp32.u_q16_to_fp32.s2_mag\[4\] VGND VGND VPWR VPWR net1673
+ sky130_fd_sc_hd__dlygate4sd3_1
Xhold819 u_interface.u_gelu_fp32.u_q16_to_fp32.s1_mag\[9\] VGND VGND VPWR VPWR net1684
+ sky130_fd_sc_hd__dlygate4sd3_1
X_10529_ _04258_ _04274_ _04275_ VGND VGND VPWR VPWR _04277_ sky130_fd_sc_hd__nand3_2
XFILLER_109_780 VGND VGND VPWR VPWR sky130_fd_sc_hd__decap_4
XFILLER_143_569 VGND VGND VPWR VPWR sky130_fd_sc_hd__fill_2
X_13248_ clknet_leaf_40_clk _00258_ VGND VGND VPWR VPWR u_interface.fifo_data\[11\]\[26\]
+ sky130_fd_sc_hd__dfxtp_1
XFILLER_130_219 VGND VGND VPWR VPWR sky130_fd_sc_hd__fill_1
XFILLER_35_3 VPWR VGND VPWR VGND sky130_ef_sc_hd__decap_12
X_13179_ clknet_leaf_76_clk _00189_ VGND VGND VPWR VPWR u_interface.fifo_data\[9\]\[21\]
+ sky130_fd_sc_hd__dfxtp_1
XFILLER_96_188 VGND VGND VPWR VPWR sky130_fd_sc_hd__decap_3
X_07740_ u_interface.u_gelu_fp32.u_q16_to_fp32.s3_norm_mag\[21\] u_interface.u_gelu_fp32.u_q16_to_fp32.s3_norm_mag\[20\]
+ _01783_ VGND VGND VPWR VPWR _01784_ sky130_fd_sc_hd__and3_1
X_07671_ net807 u_interface.u_gelu_fp32.u_q16_to_fp32.s3_norm_mag\[15\] net281 _01751_
+ VGND VGND VPWR VPWR _01752_ sky130_fd_sc_hd__a22o_1
X_06622_ net735 _01197_ VGND VGND VPWR VPWR _01198_ sky130_fd_sc_hd__or2_1
X_09410_ _03166_ _03167_ VGND VGND VPWR VPWR _03168_ sky130_fd_sc_hd__and2_1
XFILLER_65_586 VGND VGND VPWR VPWR sky130_fd_sc_hd__decap_6
XFILLER_53_726 VGND VGND VPWR VPWR sky130_fd_sc_hd__fill_2
XTAP_TAPCELL_ROW_36_913 VGND VPWR sky130_fd_sc_hd__tapvpwrvgnd_1
XFILLER_37_288 VPWR VGND VPWR VGND sky130_ef_sc_hd__decap_12
X_09341_ net593 net513 _03099_ VGND VGND VPWR VPWR _03100_ sky130_fd_sc_hd__and3_1
X_06553_ net537 _01148_ VGND VGND VPWR VPWR _01149_ sky130_fd_sc_hd__nand2_1
XFILLER_18_491 VPWR VGND VPWR VGND sky130_ef_sc_hd__decap_12
XFILLER_21_601 VPWR VGND VPWR VGND sky130_ef_sc_hd__decap_12
X_09272_ _03027_ _03028_ _03030_ VGND VGND VPWR VPWR _03031_ sky130_fd_sc_hd__nand3_1
XTAP_TAPCELL_ROW_43_1026 VGND VPWR sky130_fd_sc_hd__tapvpwrvgnd_1
XFILLER_32_18 VGND VGND VPWR VPWR sky130_fd_sc_hd__decap_8
XFILLER_32_29 VPWR VGND VPWR VGND sky130_ef_sc_hd__decap_12
XFILLER_148_29 VPWR VGND VPWR VGND sky130_ef_sc_hd__decap_12
XTAP_TAPCELL_ROW_138_2543 VGND VPWR sky130_fd_sc_hd__tapvpwrvgnd_1
X_08223_ _01892_ _02051_ VGND VGND VPWR VPWR _02052_ sky130_fd_sc_hd__nand2b_1
XFILLER_20_133 VGND VGND VPWR VPWR sky130_fd_sc_hd__decap_6
XFILLER_119_555 VGND VGND VPWR VPWR sky130_fd_sc_hd__decap_4
X_08154_ _01987_ _01988_ VGND VGND VPWR VPWR _01994_ sky130_fd_sc_hd__nand2_1
XTAP_TAPCELL_ROW_151_2754 VGND VPWR sky130_fd_sc_hd__tapvpwrvgnd_1
XFILLER_147_897 VGND VGND VPWR VPWR sky130_fd_sc_hd__decap_4
XFILLER_146_352 VPWR VGND VPWR VGND sky130_ef_sc_hd__decap_12
XFILLER_134_514 VGND VGND VPWR VPWR sky130_fd_sc_hd__fill_2
X_08085_ u_interface.u_gelu_fp32.u_fp32_to_q16.s3_mag\[6\] _01876_ VGND VGND VPWR
+ VPWR _01936_ sky130_fd_sc_hd__xnor2_1
X_07105_ net1377 net575 net228 VGND VGND VPWR VPWR _00145_ sky130_fd_sc_hd__mux2_1
X_07036_ net1196 net347 net272 VGND VGND VPWR VPWR _00076_ sky130_fd_sc_hd__mux2_1
XFILLER_119_599 VPWR VGND VPWR VGND sky130_ef_sc_hd__decap_12
XFILLER_115_794 VGND VGND VPWR VPWR sky130_fd_sc_hd__decap_3
XFILLER_102_400 VGND VGND VPWR VPWR sky130_fd_sc_hd__fill_1
XFILLER_0_505 VPWR VGND VPWR VGND sky130_ef_sc_hd__decap_12
XFILLER_102_433 VPWR VGND VPWR VGND sky130_ef_sc_hd__decap_12
XFILLER_88_645 VGND VGND VPWR VPWR sky130_fd_sc_hd__decap_4
XFILLER_57_15 VPWR VGND VPWR VGND sky130_ef_sc_hd__decap_12
X_08987_ _02737_ _02745_ VGND VGND VPWR VPWR _02746_ sky130_fd_sc_hd__or2_1
XFILLER_87_166 VGND VGND VPWR VPWR sky130_fd_sc_hd__fill_2
XTAP_TAPCELL_ROW_54_1199 VGND VPWR sky130_fd_sc_hd__tapvpwrvgnd_1
X_07938_ _01810_ _01816_ _01829_ _01825_ net776 VGND VGND VPWR VPWR _01830_ sky130_fd_sc_hd__o311a_1
XFILLER_68_380 VGND VGND VPWR VPWR sky130_fd_sc_hd__fill_1
XFILLER_56_520 VPWR VGND VPWR VGND sky130_ef_sc_hd__decap_12
XFILLER_113_32 VGND VGND VPWR VPWR sky130_fd_sc_hd__decap_8
XTAP_TAPCELL_ROW_3_387 VGND VPWR sky130_fd_sc_hd__tapvpwrvgnd_1
XTAP_TAPCELL_ROW_3_376 VGND VPWR sky130_fd_sc_hd__tapvpwrvgnd_1
X_07869_ net1342 net378 net265 VGND VGND VPWR VPWR _00630_ sky130_fd_sc_hd__mux2_1
X_09608_ _03362_ _03363_ _03303_ VGND VGND VPWR VPWR _03364_ sky130_fd_sc_hd__o21a_1
X_10880_ _04618_ _04623_ VGND VGND VPWR VPWR _04625_ sky130_fd_sc_hd__xnor2_1
XFILLER_28_277 VPWR VGND VPWR VGND sky130_ef_sc_hd__decap_12
X_09539_ _03293_ _03295_ VGND VGND VPWR VPWR _03296_ sky130_fd_sc_hd__nor2_1
XFILLER_73_69 VPWR VGND VPWR VGND sky130_ef_sc_hd__decap_12
XFILLER_43_247 VGND VGND VPWR VPWR sky130_fd_sc_hd__decap_3
XFILLER_12_601 VPWR VGND VPWR VGND sky130_ef_sc_hd__decap_12
XFILLER_24_461 VGND VGND VPWR VPWR sky130_fd_sc_hd__decap_8
XFILLER_11_111 VGND VGND VPWR VPWR sky130_fd_sc_hd__fill_1
XFILLER_12_645 VPWR VGND VPWR VGND sky130_ef_sc_hd__decap_12
X_12550_ net191 _06273_ _06271_ VGND VGND VPWR VPWR _06274_ sky130_fd_sc_hd__a21o_1
X_11501_ _05046_ _05239_ VGND VGND VPWR VPWR _05240_ sky130_fd_sc_hd__xnor2_1
X_12481_ _06205_ _06206_ VGND VGND VPWR VPWR _06207_ sky130_fd_sc_hd__nor2_1
XFILLER_11_199 VGND VGND VPWR VPWR sky130_fd_sc_hd__fill_1
XFILLER_7_137 VPWR VGND VPWR VGND sky130_ef_sc_hd__decap_12
XTAP_TAPCELL_ROW_22_684 VGND VPWR sky130_fd_sc_hd__tapvpwrvgnd_1
XTAP_TAPCELL_ROW_22_695 VGND VPWR sky130_fd_sc_hd__tapvpwrvgnd_1
X_11432_ net650 net406 VGND VGND VPWR VPWR _05172_ sky130_fd_sc_hd__nand2_1
XFILLER_137_374 VPWR VGND VPWR VGND sky130_ef_sc_hd__decap_12
XFILLER_125_503 VGND VGND VPWR VPWR sky130_fd_sc_hd__fill_1
X_14151_ clknet_leaf_51_clk _01077_ VGND VGND VPWR VPWR u_interface.fifo_data\[1\]\[11\]
+ sky130_fd_sc_hd__dfxtp_1
XFILLER_4_811 VGND VGND VPWR VPWR sky130_fd_sc_hd__fill_1
XFILLER_152_333 VPWR VGND VPWR VGND sky130_ef_sc_hd__decap_12
XFILLER_138_62 VGND VGND VPWR VPWR sky130_fd_sc_hd__decap_6
X_13102_ clknet_leaf_44_clk _00112_ VGND VGND VPWR VPWR u_interface.fifo_data\[15\]\[23\]
+ sky130_fd_sc_hd__dfxtp_1
X_11363_ _05103_ _05102_ VGND VGND VPWR VPWR _05104_ sky130_fd_sc_hd__nand2b_1
X_14082_ clknet_leaf_17_clk net1456 VGND VGND VPWR VPWR u_interface.u_gelu_fp32.u_fp32_to_q16.s2_norm_mag\[19\]
+ sky130_fd_sc_hd__dfxtp_1
XFILLER_140_506 VPWR VGND VPWR VGND sky130_ef_sc_hd__decap_12
XFILLER_125_558 VGND VGND VPWR VPWR sky130_fd_sc_hd__fill_2
X_10314_ _04033_ _04034_ _04061_ _04062_ VGND VGND VPWR VPWR _04064_ sky130_fd_sc_hd__nor4_1
X_11294_ _05031_ _05034_ VGND VGND VPWR VPWR _05035_ sky130_fd_sc_hd__xor2_1
XFILLER_152_399 VGND VGND VPWR VPWR sky130_fd_sc_hd__fill_2
X_13033_ clknet_leaf_38_clk _00043_ VGND VGND VPWR VPWR u_interface.fifo_tuser\[12\]
+ sky130_fd_sc_hd__dfxtp_1
X_10245_ _03976_ _03992_ _03993_ VGND VGND VPWR VPWR _03995_ sky130_fd_sc_hd__nand3_2
XFILLER_154_72 VGND VGND VPWR VPWR sky130_fd_sc_hd__fill_2
XFILLER_105_293 VGND VGND VPWR VPWR sky130_fd_sc_hd__decap_6
X_10176_ net619 net627 net446 net441 VGND VGND VPWR VPWR _03927_ sky130_fd_sc_hd__and4_1
XFILLER_66_306 VGND VGND VPWR VPWR sky130_fd_sc_hd__fill_2
XFILLER_94_637 VGND VGND VPWR VPWR sky130_fd_sc_hd__fill_2
Xfanout190 _03757_ VGND VGND VPWR VPWR net190 sky130_fd_sc_hd__buf_1
XFILLER_59_391 VGND VGND VPWR VPWR sky130_fd_sc_hd__fill_1
XTAP_TAPCELL_ROW_105_2019 VGND VPWR sky130_fd_sc_hd__tapvpwrvgnd_1
X_13935_ clknet_leaf_10_clk _00020_ VGND VGND VPWR VPWR u_interface.u_gelu_fp32.u_synth_top.s1_hits\[7\]
+ sky130_fd_sc_hd__dfxtp_1
XTAP_TAPCELL_ROW_105_2008 VGND VPWR sky130_fd_sc_hd__tapvpwrvgnd_1
XFILLER_93_158 VGND VGND VPWR VPWR sky130_fd_sc_hd__decap_4
XTAP_TAPCELL_ROW_89_1763 VGND VPWR sky130_fd_sc_hd__tapvpwrvgnd_1
XTAP_TAPCELL_ROW_89_1752 VGND VPWR sky130_fd_sc_hd__tapvpwrvgnd_1
XFILLER_47_92 VGND VGND VPWR VPWR sky130_fd_sc_hd__fill_2
X_13866_ clknet_leaf_22_clk net868 VGND VGND VPWR VPWR u_interface.u_gelu_fp32.u_synth_top.s2_dx\[2\]
+ sky130_fd_sc_hd__dfxtp_2
XFILLER_35_726 VGND VGND VPWR VPWR sky130_fd_sc_hd__fill_2
X_12817_ net778 net76 VGND VGND VPWR VPWR _00975_ sky130_fd_sc_hd__and2_1
XFILLER_90_876 VGND VGND VPWR VPWR sky130_fd_sc_hd__fill_1
XFILLER_35_759 VGND VGND VPWR VPWR sky130_fd_sc_hd__fill_2
XFILLER_62_589 VGND VGND VPWR VPWR sky130_fd_sc_hd__fill_2
XFILLER_15_461 VPWR VGND VPWR VGND sky130_ef_sc_hd__decap_12
X_13797_ clknet_leaf_80_clk _00807_ VGND VGND VPWR VPWR u_interface.u_gelu_fp32.s2_data\[31\]
+ sky130_fd_sc_hd__dfxtp_1
XTAP_TAPCELL_ROW_100_1930 VGND VPWR sky130_fd_sc_hd__tapvpwrvgnd_1
X_12748_ net1516 u_interface.u_gelu_fp32.u_q16_to_fp32.s3_exp\[0\] net823 VGND VGND
+ VPWR VPWR _00930_ sky130_fd_sc_hd__mux2_1
XFILLER_148_628 VGND VGND VPWR VPWR sky130_fd_sc_hd__fill_2
XTAP_TAPCELL_ROW_100_1941 VGND VPWR sky130_fd_sc_hd__tapvpwrvgnd_1
X_12679_ u_interface.u_gelu_fp32.u_q16_to_fp32.s2_mag\[16\] u_interface.u_gelu_fp32.u_q16_to_fp32.s2_mag\[15\]
+ net337 VGND VGND VPWR VPWR _06341_ sky130_fd_sc_hd__mux2_1
XFILLER_8_53 VPWR VGND VPWR VGND sky130_ef_sc_hd__decap_12
XTAP_TAPCELL_ROW_41_993 VGND VPWR sky130_fd_sc_hd__tapvpwrvgnd_1
XFILLER_129_897 VGND VGND VPWR VPWR sky130_fd_sc_hd__decap_3
XFILLER_8_97 VPWR VGND VPWR VGND sky130_ef_sc_hd__decap_12
XFILLER_143_322 VGND VGND VPWR VPWR sky130_fd_sc_hd__decap_4
XTAP_TAPCELL_ROW_133_2462 VGND VPWR sky130_fd_sc_hd__tapvpwrvgnd_1
Xhold627 u_interface.fifo_data\[6\]\[25\] VGND VGND VPWR VPWR net1492 sky130_fd_sc_hd__dlygate4sd3_1
Xhold605 u_interface.fifo_data\[12\]\[0\] VGND VGND VPWR VPWR net1470 sky130_fd_sc_hd__dlygate4sd3_1
Xhold616 u_interface.fifo_data\[6\]\[5\] VGND VGND VPWR VPWR net1481 sky130_fd_sc_hd__dlygate4sd3_1
XFILLER_7_671 VGND VGND VPWR VPWR sky130_fd_sc_hd__fill_1
XFILLER_144_867 VGND VGND VPWR VPWR sky130_fd_sc_hd__fill_1
Xhold638 u_interface.fifo_data\[11\]\[1\] VGND VGND VPWR VPWR net1503 sky130_fd_sc_hd__dlygate4sd3_1
XFILLER_89_409 VGND VGND VPWR VPWR sky130_fd_sc_hd__fill_1
Xhold649 u_interface.fifo_data\[2\]\[0\] VGND VGND VPWR VPWR net1514 sky130_fd_sc_hd__dlygate4sd3_1
X_08910_ net670 net504 net679 net509 _02446_ VGND VGND VPWR VPWR _02669_ sky130_fd_sc_hd__a41o_1
X_09890_ _03636_ _03640_ _03641_ VGND VGND VPWR VPWR _03643_ sky130_fd_sc_hd__nand3_2
X_08841_ net585 net462 VGND VGND VPWR VPWR _02600_ sky130_fd_sc_hd__nand2_1
XFILLER_85_615 VGND VGND VPWR VPWR sky130_fd_sc_hd__fill_1
XFILLER_69_166 VGND VGND VPWR VPWR sky130_fd_sc_hd__fill_2
XFILLER_57_317 VPWR VGND VPWR VGND sky130_ef_sc_hd__decap_12
X_08772_ _02527_ _02530_ VGND VGND VPWR VPWR _02531_ sky130_fd_sc_hd__xnor2_1
XFILLER_85_648 VGND VGND VPWR VPWR sky130_fd_sc_hd__decap_8
X_07723_ u_interface.u_gelu_fp32.u_synth_top.s1_hits\[9\] u_interface.u_gelu_fp32.u_synth_top.s1_hits\[17\]
+ u_interface.u_gelu_fp32.u_synth_top.s1_hits\[1\] _01435_ VGND VGND VPWR VPWR _01772_
+ sky130_fd_sc_hd__or4_1
XFILLER_72_309 VGND VGND VPWR VPWR sky130_fd_sc_hd__decap_6
X_07654_ net331 _01712_ _01713_ u_interface.u_gelu_fp32.u_q16_to_fp32.s2_clz\[3\]
+ VGND VGND VPWR VPWR _01738_ sky130_fd_sc_hd__o211a_1
XFILLER_53_512 VGND VGND VPWR VPWR sky130_fd_sc_hd__fill_2
XTAP_TAPCELL_ROW_0_313 VGND VPWR sky130_fd_sc_hd__tapvpwrvgnd_1
XTAP_TAPCELL_ROW_0_324 VGND VPWR sky130_fd_sc_hd__tapvpwrvgnd_1
XTAP_TAPCELL_ROW_0_335 VGND VPWR sky130_fd_sc_hd__tapvpwrvgnd_1
XFILLER_26_737 VPWR VGND VPWR VGND sky130_ef_sc_hd__decap_12
X_06605_ u_interface.u_gelu_fp32.u_synth_top.s1_hits\[7\] u_interface.u_gelu_fp32.u_synth_top.s1_hits\[9\]
+ u_interface.u_gelu_fp32.u_synth_top.s1_hits\[6\] VGND VGND VPWR VPWR _01183_ sky130_fd_sc_hd__or3_1
XFILLER_25_225 VGND VGND VPWR VPWR sky130_fd_sc_hd__decap_8
X_07585_ net310 _01653_ VGND VGND VPWR VPWR _01689_ sky130_fd_sc_hd__and2_1
X_09324_ _03080_ _03082_ _03078_ VGND VGND VPWR VPWR _03083_ sky130_fd_sc_hd__a21o_1
X_06536_ u_interface.u_gelu_fp32.s1_data\[21\] u_interface.u_gelu_fp32.s1_data\[20\]
+ u_interface.u_gelu_fp32.s1_data\[19\] u_interface.u_gelu_fp32.s1_data\[18\] VGND
+ VGND VPWR VPWR _01133_ sky130_fd_sc_hd__or4_1
XFILLER_21_431 VPWR VGND VPWR VGND sky130_ef_sc_hd__decap_12
XFILLER_43_39 VPWR VGND VPWR VGND sky130_ef_sc_hd__decap_12
XFILLER_139_617 VPWR VGND VPWR VGND sky130_ef_sc_hd__decap_12
X_09255_ net591 net597 net501 net506 VGND VGND VPWR VPWR _03014_ sky130_fd_sc_hd__and4_1
X_08206_ net315 _02036_ _02035_ VGND VGND VPWR VPWR _02038_ sky130_fd_sc_hd__o21ai_1
X_09186_ _02941_ _02942_ _02944_ VGND VGND VPWR VPWR _02945_ sky130_fd_sc_hd__nand3_1
XFILLER_107_503 VGND VGND VPWR VPWR sky130_fd_sc_hd__fill_1
XFILLER_135_856 VGND VGND VPWR VPWR sky130_fd_sc_hd__fill_1
XFILLER_135_834 VGND VGND VPWR VPWR sky130_fd_sc_hd__decap_6
X_08137_ net541 _01978_ _01977_ VGND VGND VPWR VPWR _01980_ sky130_fd_sc_hd__a21o_1
X_08068_ u_interface.u_gelu_fp32.u_fp32_to_q16.s3_mag\[3\] _01874_ VGND VGND VPWR
+ VPWR _01922_ sky130_fd_sc_hd__xnor2_1
XTAP_TAPCELL_ROW_56_1239 VGND VPWR sky130_fd_sc_hd__tapvpwrvgnd_1
XTAP_TAPCELL_ROW_56_1228 VGND VPWR sky130_fd_sc_hd__tapvpwrvgnd_1
XFILLER_134_377 VGND VGND VPWR VPWR sky130_fd_sc_hd__fill_2
XFILLER_122_539 VGND VGND VPWR VPWR sky130_fd_sc_hd__fill_1
X_07019_ net1104 net380 net269 VGND VGND VPWR VPWR _00059_ sky130_fd_sc_hd__mux2_1
XFILLER_108_98 VGND VGND VPWR VPWR sky130_fd_sc_hd__decap_6
XFILLER_103_742 VGND VGND VPWR VPWR sky130_fd_sc_hd__fill_1
X_10030_ _03755_ _03779_ _03780_ VGND VGND VPWR VPWR _03782_ sky130_fd_sc_hd__nand3_2
XTAP_TAPCELL_ROW_8_468 VGND VPWR sky130_fd_sc_hd__tapvpwrvgnd_1
XTAP_TAPCELL_ROW_8_457 VGND VPWR sky130_fd_sc_hd__tapvpwrvgnd_1
XFILLER_48_317 VGND VGND VPWR VPWR sky130_fd_sc_hd__decap_3
XFILLER_103_797 VGND VGND VPWR VPWR sky130_fd_sc_hd__decap_6
XFILLER_75_125 VGND VGND VPWR VPWR sky130_fd_sc_hd__fill_1
XFILLER_91_607 VGND VGND VPWR VPWR sky130_fd_sc_hd__decap_8
XFILLER_75_169 VGND VGND VPWR VPWR sky130_fd_sc_hd__fill_1
X_11981_ _05629_ _05630_ _05632_ VGND VGND VPWR VPWR _05715_ sky130_fd_sc_hd__a21oi_1
X_13720_ clknet_leaf_7_clk _00730_ VGND VGND VPWR VPWR u_interface.u_gelu_fp32.s1_data\[20\]
+ sky130_fd_sc_hd__dfxtp_1
X_10932_ _04594_ _04596_ VGND VGND VPWR VPWR _04676_ sky130_fd_sc_hd__or2_1
XFILLER_56_372 VPWR VGND VPWR VGND sky130_ef_sc_hd__decap_12
XFILLER_140_41 VGND VGND VPWR VPWR sky130_fd_sc_hd__fill_2
XFILLER_44_545 VGND VGND VPWR VPWR sky130_fd_sc_hd__decap_3
XFILLER_17_51 VGND VGND VPWR VPWR sky130_fd_sc_hd__decap_4
X_13651_ clknet_leaf_27_clk _00661_ VGND VGND VPWR VPWR u_interface.u_gelu_fp32.u_synth_top.v_pipe\[2\]
+ sky130_fd_sc_hd__dfxtp_1
X_10863_ _04604_ _04607_ VGND VGND VPWR VPWR _04608_ sky130_fd_sc_hd__xnor2_1
XTAP_TAPCELL_ROW_27_765 VGND VPWR sky130_fd_sc_hd__tapvpwrvgnd_1
X_13582_ clknet_leaf_45_clk _00592_ VGND VGND VPWR VPWR u_interface.fifo_data\[4\]\[29\]
+ sky130_fd_sc_hd__dfxtp_1
XTAP_TAPCELL_ROW_84_1682 VGND VPWR sky130_fd_sc_hd__tapvpwrvgnd_1
X_10794_ _04538_ _04539_ _04415_ _04417_ VGND VGND VPWR VPWR _04540_ sky130_fd_sc_hd__o211ai_2
X_12602_ u_interface.u_gelu_fp32.u_q16_to_fp32.s1_mag\[7\] net211 u_interface.u_gelu_fp32.u_q16_to_fp32.s1_mag\[23\]
+ VGND VGND VPWR VPWR _06305_ sky130_fd_sc_hd__a21o_1
X_12533_ _06184_ _06256_ VGND VGND VPWR VPWR _06257_ sky130_fd_sc_hd__xnor2_1
XFILLER_24_291 VGND VGND VPWR VPWR sky130_fd_sc_hd__decap_3
XFILLER_8_446 VGND VGND VPWR VPWR sky130_fd_sc_hd__decap_4
X_12464_ _06188_ _06189_ VGND VGND VPWR VPWR _06190_ sky130_fd_sc_hd__nor2_1
XFILLER_137_160 VGND VGND VPWR VPWR sky130_fd_sc_hd__decap_8
X_11415_ _05051_ _05054_ VGND VGND VPWR VPWR _05155_ sky130_fd_sc_hd__nand2_1
X_12395_ _06058_ _06064_ _06121_ VGND VGND VPWR VPWR _06123_ sky130_fd_sc_hd__o21bai_1
X_14134_ clknet_leaf_32_clk _01060_ VGND VGND VPWR VPWR u_interface.fifo_count\[1\]
+ sky130_fd_sc_hd__dfxtp_1
XFILLER_137_193 VGND VGND VPWR VPWR sky130_fd_sc_hd__decap_6
XFILLER_126_878 VGND VGND VPWR VPWR sky130_fd_sc_hd__decap_4
XTAP_TAPCELL_ROW_115_2181 VGND VPWR sky130_fd_sc_hd__tapvpwrvgnd_1
XTAP_TAPCELL_ROW_115_2170 VGND VPWR sky130_fd_sc_hd__tapvpwrvgnd_1
X_11346_ _05082_ _05086_ VGND VGND VPWR VPWR _05087_ sky130_fd_sc_hd__xnor2_1
XFILLER_140_303 VGND VGND VPWR VPWR sky130_fd_sc_hd__decap_4
X_14065_ clknet_leaf_55_clk _00991_ VGND VGND VPWR VPWR u_interface.u_gelu_fp32.u_q16_to_fp32.s2_clz\[4\]
+ sky130_fd_sc_hd__dfxtp_1
X_11277_ _04899_ _04901_ _05017_ VGND VGND VPWR VPWR _05019_ sky130_fd_sc_hd__a21o_1
X_13016_ _06498_ VGND VGND VPWR VPWR _01098_ sky130_fd_sc_hd__inv_2
X_10228_ _03892_ _03900_ _03901_ VGND VGND VPWR VPWR _03978_ sky130_fd_sc_hd__a21o_1
Xhold2 u_interface.u_gelu_fp32.u_synth_top.s1_x\[4\] VGND VGND VPWR VPWR net867 sky130_fd_sc_hd__dlygate4sd3_1
XFILLER_94_445 VPWR VGND VPWR VGND sky130_ef_sc_hd__decap_12
X_10159_ _03908_ _03909_ _03905_ VGND VGND VPWR VPWR _03910_ sky130_fd_sc_hd__a21o_1
XFILLER_66_158 VPWR VGND VPWR VGND sky130_ef_sc_hd__decap_12
XFILLER_54_309 VPWR VGND VPWR VGND sky130_ef_sc_hd__decap_12
XFILLER_35_501 VGND VGND VPWR VPWR sky130_fd_sc_hd__decap_3
X_13918_ clknet_leaf_6_clk net908 VGND VGND VPWR VPWR u_interface.u_gelu_fp32.u_synth_top.s1_x\[22\]
+ sky130_fd_sc_hd__dfxtp_1
XFILLER_35_545 VGND VGND VPWR VPWR sky130_fd_sc_hd__decap_4
X_13849_ clknet_leaf_57_clk _00859_ VGND VGND VPWR VPWR u_interface.u_gelu_fp32.u_synth_top.s3_b\[5\]
+ sky130_fd_sc_hd__dfxtp_1
XFILLER_50_515 VPWR VGND VPWR VGND sky130_ef_sc_hd__decap_12
XFILLER_23_729 VPWR VGND VPWR VGND sky130_ef_sc_hd__decap_12
XFILLER_35_589 VPWR VGND VPWR VGND sky130_ef_sc_hd__decap_12
XFILLER_62_397 VGND VGND VPWR VPWR sky130_fd_sc_hd__fill_1
X_07370_ net1329 net379 net237 VGND VGND VPWR VPWR _00400_ sky130_fd_sc_hd__mux2_1
XFILLER_16_781 VPWR VGND VPWR VGND sky130_ef_sc_hd__decap_12
X_09040_ _02783_ _02798_ VGND VGND VPWR VPWR _02799_ sky130_fd_sc_hd__xnor2_1
XTAP_TAPCELL_ROW_135_2502 VGND VPWR sky130_fd_sc_hd__tapvpwrvgnd_1
XFILLER_30_261 VGND VGND VPWR VPWR sky130_fd_sc_hd__fill_1
Xhold402 u_interface.fifo_data\[13\]\[28\] VGND VGND VPWR VPWR net1267 sky130_fd_sc_hd__dlygate4sd3_1
XFILLER_144_620 VGND VGND VPWR VPWR sky130_fd_sc_hd__fill_1
XFILLER_116_300 VGND VGND VPWR VPWR sky130_fd_sc_hd__fill_2
Xhold424 u_interface.fifo_data\[4\]\[1\] VGND VGND VPWR VPWR net1289 sky130_fd_sc_hd__dlygate4sd3_1
Xhold413 u_interface.fifo_data\[10\]\[25\] VGND VGND VPWR VPWR net1278 sky130_fd_sc_hd__dlygate4sd3_1
Xhold435 u_interface.fifo_data\[12\]\[30\] VGND VGND VPWR VPWR net1300 sky130_fd_sc_hd__dlygate4sd3_1
Xhold468 u_interface.u_gelu_fp32.u_fp32_to_q16.s1_mant\[14\] VGND VGND VPWR VPWR net1333
+ sky130_fd_sc_hd__dlygate4sd3_1
Xmax_cap176 _03365_ VGND VGND VPWR VPWR net176 sky130_fd_sc_hd__buf_1
X_09942_ net465 net656 net662 net469 VGND VGND VPWR VPWR _03695_ sky130_fd_sc_hd__a22o_1
Xhold446 u_interface.fifo_data\[6\]\[27\] VGND VGND VPWR VPWR net1311 sky130_fd_sc_hd__dlygate4sd3_1
Xhold457 u_interface.fifo_data\[10\]\[27\] VGND VGND VPWR VPWR net1322 sky130_fd_sc_hd__dlygate4sd3_1
Xmax_cap187 _04484_ VGND VGND VPWR VPWR net187 sky130_fd_sc_hd__buf_1
Xhold479 u_interface.fifo_data\[10\]\[5\] VGND VGND VPWR VPWR net1344 sky130_fd_sc_hd__dlygate4sd3_1
X_09873_ _03479_ _03481_ _03624_ _03625_ VGND VGND VPWR VPWR _03627_ sky130_fd_sc_hd__a211oi_1
XTAP_TAPCELL_ROW_5_416 VGND VPWR sky130_fd_sc_hd__tapvpwrvgnd_1
X_08824_ net646 net654 net503 net509 VGND VGND VPWR VPWR _02583_ sky130_fd_sc_hd__and4_1
XTAP_TAPCELL_ROW_51_1158 VGND VPWR sky130_fd_sc_hd__tapvpwrvgnd_1
XTAP_TAPCELL_ROW_51_1147 VGND VPWR sky130_fd_sc_hd__tapvpwrvgnd_1
XTAP_TAPCELL_ROW_146_2675 VGND VPWR sky130_fd_sc_hd__tapvpwrvgnd_1
XTAP_TAPCELL_ROW_146_2664 VGND VPWR sky130_fd_sc_hd__tapvpwrvgnd_1
X_08755_ _02510_ _02513_ VGND VGND VPWR VPWR _02514_ sky130_fd_sc_hd__nand2b_1
XFILLER_85_456 VGND VGND VPWR VPWR sky130_fd_sc_hd__decap_4
XFILLER_57_169 VGND VGND VPWR VPWR sky130_fd_sc_hd__fill_2
XFILLER_57_147 VGND VGND VPWR VPWR sky130_fd_sc_hd__decap_3
X_07706_ _01435_ _01765_ _01766_ _01442_ VGND VGND VPWR VPWR _00505_ sky130_fd_sc_hd__or4b_1
XFILLER_85_489 VPWR VGND VPWR VGND sky130_ef_sc_hd__decap_12
X_08686_ net689 net511 _02443_ _02444_ VGND VGND VPWR VPWR _02445_ sky130_fd_sc_hd__a22oi_1
XFILLER_54_854 VGND VGND VPWR VPWR sky130_fd_sc_hd__decap_6
XFILLER_54_27 VGND VGND VPWR VPWR sky130_fd_sc_hd__fill_1
X_07637_ net803 net1787 net281 _01725_ VGND VGND VPWR VPWR _00477_ sky130_fd_sc_hd__a22o_1
XFILLER_26_589 VPWR VGND VPWR VGND sky130_ef_sc_hd__decap_12
X_07568_ net810 net1762 net303 _01680_ VGND VGND VPWR VPWR _00453_ sky130_fd_sc_hd__a22o_1
XFILLER_80_172 VGND VGND VPWR VPWR sky130_fd_sc_hd__decap_6
XTAP_TAPCELL_ROW_66_1390 VGND VPWR sky130_fd_sc_hd__tapvpwrvgnd_1
XFILLER_13_217 VGND VGND VPWR VPWR sky130_fd_sc_hd__decap_6
XTAP_TAPCELL_ROW_24_713 VGND VPWR sky130_fd_sc_hd__tapvpwrvgnd_1
XTAP_TAPCELL_ROW_24_724 VGND VPWR sky130_fd_sc_hd__tapvpwrvgnd_1
X_09307_ _03063_ _03065_ VGND VGND VPWR VPWR _03066_ sky130_fd_sc_hd__nand2_1
X_06519_ u_interface.fifo_count\[3\] u_interface.in_flight_count\[3\] u_interface.in_flight_count\[2\]
+ u_interface.fifo_count\[2\] VGND VGND VPWR VPWR _01119_ sky130_fd_sc_hd__a22o_1
XFILLER_70_15 VPWR VGND VPWR VGND sky130_ef_sc_hd__decap_12
X_07499_ _01628_ _01630_ net547 VGND VGND VPWR VPWR _01631_ sky130_fd_sc_hd__mux2_1
XFILLER_110_99 VGND VGND VPWR VPWR sky130_fd_sc_hd__decap_3
X_09238_ _02994_ _02996_ VGND VGND VPWR VPWR _02997_ sky130_fd_sc_hd__and2b_1
XFILLER_6_917 VGND VGND VPWR VPWR sky130_fd_sc_hd__decap_4
X_09169_ net604 net613 net501 net506 VGND VGND VPWR VPWR _02928_ sky130_fd_sc_hd__and4_1
XFILLER_5_405 VGND VGND VPWR VPWR sky130_fd_sc_hd__fill_2
XFILLER_134_141 VGND VGND VPWR VPWR sky130_fd_sc_hd__decap_4
X_11200_ _04847_ _04849_ _04940_ VGND VGND VPWR VPWR _04942_ sky130_fd_sc_hd__a21oi_2
XFILLER_5_449 VPWR VGND VPWR VGND sky130_ef_sc_hd__decap_12
X_12180_ _05814_ _05844_ _05843_ VGND VGND VPWR VPWR _05911_ sky130_fd_sc_hd__a21bo_1
XFILLER_150_612 VGND VGND VPWR VPWR sky130_fd_sc_hd__fill_1
XFILLER_102_3 VGND VGND VPWR VPWR sky130_fd_sc_hd__decap_8
X_11131_ _04869_ _04873_ VGND VGND VPWR VPWR _04874_ sky130_fd_sc_hd__xnor2_1
XFILLER_150_645 VGND VGND VPWR VPWR sky130_fd_sc_hd__fill_2
XFILLER_131_870 VPWR VGND VPWR VGND sky130_ef_sc_hd__decap_12
XFILLER_76_401 VGND VGND VPWR VPWR sky130_fd_sc_hd__decap_4
X_11062_ _04688_ _04802_ _04804_ _04803_ VGND VGND VPWR VPWR _04805_ sky130_fd_sc_hd__a31o_1
X_10013_ _03762_ _03764_ _03637_ VGND VGND VPWR VPWR _03765_ sky130_fd_sc_hd__a21o_1
XFILLER_88_272 VGND VGND VPWR VPWR sky130_fd_sc_hd__decap_8
XFILLER_48_125 VGND VGND VPWR VPWR sky130_fd_sc_hd__fill_1
XFILLER_0_165 VGND VGND VPWR VPWR sky130_fd_sc_hd__decap_3
XFILLER_36_309 VGND VGND VPWR VPWR sky130_fd_sc_hd__decap_8
XFILLER_91_426 VGND VGND VPWR VPWR sky130_fd_sc_hd__decap_8
XTAP_TAPCELL_ROW_86_1711 VGND VPWR sky130_fd_sc_hd__tapvpwrvgnd_1
XFILLER_76_489 VPWR VGND VPWR VGND sky130_ef_sc_hd__decap_12
XFILLER_28_83 VGND VGND VPWR VPWR sky130_fd_sc_hd__fill_1
XFILLER_151_95 VGND VGND VPWR VPWR sky130_fd_sc_hd__fill_1
XFILLER_72_640 VGND VGND VPWR VPWR sky130_fd_sc_hd__decap_4
X_11964_ _05596_ _05597_ _05616_ _05615_ _05614_ VGND VGND VPWR VPWR _05698_ sky130_fd_sc_hd__o32a_1
X_13703_ clknet_leaf_19_clk _00713_ VGND VGND VPWR VPWR u_interface.u_gelu_fp32.s1_data\[3\]
+ sky130_fd_sc_hd__dfxtp_1
X_10915_ _04458_ _04460_ _04657_ _04658_ VGND VGND VPWR VPWR _04660_ sky130_fd_sc_hd__a211oi_1
X_11895_ _05492_ _05551_ _05550_ VGND VGND VPWR VPWR _05630_ sky130_fd_sc_hd__o21ai_1
X_13634_ clknet_leaf_53_clk _00644_ VGND VGND VPWR VPWR u_interface.fifo_data\[13\]\[17\]
+ sky130_fd_sc_hd__dfxtp_1
X_10846_ _04577_ _04588_ _04589_ VGND VGND VPWR VPWR _04591_ sky130_fd_sc_hd__and3_1
XFILLER_32_537 VGND VGND VPWR VPWR sky130_fd_sc_hd__fill_1
X_13565_ clknet_leaf_66_clk _00575_ VGND VGND VPWR VPWR u_interface.fifo_data\[4\]\[12\]
+ sky130_fd_sc_hd__dfxtp_1
X_10777_ net626 net422 _04520_ _04521_ VGND VGND VPWR VPWR _04523_ sky130_fd_sc_hd__nand4_2
XFILLER_12_261 VGND VGND VPWR VPWR sky130_fd_sc_hd__decap_3
XTAP_TAPCELL_ROW_117_2210 VGND VPWR sky130_fd_sc_hd__tapvpwrvgnd_1
X_13496_ clknet_leaf_3_clk net1754 VGND VGND VPWR VPWR u_interface.u_gelu_fp32.u_synth_top.s2_m\[15\]
+ sky130_fd_sc_hd__dfxtp_1
XFILLER_9_777 VGND VGND VPWR VPWR sky130_fd_sc_hd__decap_6
X_12516_ _06180_ _06207_ _06206_ VGND VGND VPWR VPWR _06241_ sky130_fd_sc_hd__a21oi_1
X_12447_ _05935_ _06173_ VGND VGND VPWR VPWR _06174_ sky130_fd_sc_hd__or2_1
XTAP_TAPCELL_ROW_130_2410 VGND VPWR sky130_fd_sc_hd__tapvpwrvgnd_1
XFILLER_126_642 VGND VGND VPWR VPWR sky130_fd_sc_hd__fill_2
XTAP_TAPCELL_ROW_97_1895 VGND VPWR sky130_fd_sc_hd__tapvpwrvgnd_1
XTAP_TAPCELL_ROW_97_1884 VGND VPWR sky130_fd_sc_hd__tapvpwrvgnd_1
XTAP_TAPCELL_ROW_10_495 VGND VPWR sky130_fd_sc_hd__tapvpwrvgnd_1
XFILLER_153_461 VPWR VGND VPWR VGND sky130_ef_sc_hd__decap_12
XTAP_TAPCELL_ROW_130_2421 VGND VPWR sky130_fd_sc_hd__tapvpwrvgnd_1
X_14117_ clknet_leaf_27_clk _01043_ VGND VGND VPWR VPWR u_interface.meta_tlast_pipe\[10\]
+ sky130_fd_sc_hd__dfxtp_1
X_12378_ _06010_ _06041_ _06040_ VGND VGND VPWR VPWR _06106_ sky130_fd_sc_hd__a21oi_1
XFILLER_141_645 VGND VGND VPWR VPWR sky130_fd_sc_hd__decap_3
X_11329_ _05066_ _05069_ VGND VGND VPWR VPWR _05070_ sky130_fd_sc_hd__xnor2_1
X_14048_ clknet_leaf_17_clk _00974_ VGND VGND VPWR VPWR u_interface.u_gelu_fp32.u_fp32_to_q16.s1_mant\[10\]
+ sky130_fd_sc_hd__dfxtp_1
XFILLER_113_358 VGND VGND VPWR VPWR sky130_fd_sc_hd__decap_3
X_06870_ net732 _01414_ VGND VGND VPWR VPWR _01415_ sky130_fd_sc_hd__or2_1
XFILLER_67_412 VPWR VGND VPWR VGND sky130_ef_sc_hd__decap_12
XFILLER_94_253 VGND VGND VPWR VPWR sky130_fd_sc_hd__fill_1
XTAP_TAPCELL_ROW_128_2383 VGND VPWR sky130_fd_sc_hd__tapvpwrvgnd_1
XFILLER_54_117 VGND VGND VPWR VPWR sky130_fd_sc_hd__fill_1
XFILLER_36_821 VPWR VGND VPWR VGND sky130_ef_sc_hd__decap_12
XFILLER_39_169 VGND VGND VPWR VPWR sky130_fd_sc_hd__decap_3
XFILLER_82_459 VGND VGND VPWR VPWR sky130_fd_sc_hd__fill_2
XFILLER_54_139 VGND VGND VPWR VPWR sky130_fd_sc_hd__fill_1
X_08540_ _02294_ _02330_ _02292_ VGND VGND VPWR VPWR _02331_ sky130_fd_sc_hd__o21ai_1
X_08471_ _02250_ _02252_ _02257_ _02261_ VGND VGND VPWR VPWR _02262_ sky130_fd_sc_hd__a211o_1
XTAP_TAPCELL_ROW_141_2594 VGND VPWR sky130_fd_sc_hd__tapvpwrvgnd_1
X_07422_ _01553_ _01557_ net550 VGND VGND VPWR VPWR _01558_ sky130_fd_sc_hd__mux2_1
XFILLER_62_194 VGND VGND VPWR VPWR sky130_fd_sc_hd__fill_2
XFILLER_50_345 VGND VGND VPWR VPWR sky130_fd_sc_hd__fill_1
XFILLER_23_559 VGND VGND VPWR VPWR sky130_fd_sc_hd__fill_1
X_07353_ net349 net1222 net244 VGND VGND VPWR VPWR _00383_ sky130_fd_sc_hd__mux2_1
XFILLER_148_266 VGND VGND VPWR VPWR sky130_fd_sc_hd__fill_1
XFILLER_148_244 VGND VGND VPWR VPWR sky130_fd_sc_hd__decap_8
X_07284_ net1007 net359 net247 VGND VGND VPWR VPWR _00314_ sky130_fd_sc_hd__mux2_1
X_09023_ _02733_ _02767_ _02780_ VGND VGND VPWR VPWR _02782_ sky130_fd_sc_hd__o21a_1
XFILLER_40_29 VGND VGND VPWR VPWR sky130_fd_sc_hd__fill_1
Xhold210 u_interface.fifo_data\[1\]\[7\] VGND VGND VPWR VPWR net1075 sky130_fd_sc_hd__dlygate4sd3_1
XFILLER_3_909 VPWR VGND VPWR VGND sky130_ef_sc_hd__decap_12
Xhold221 u_interface.fifo_data\[6\]\[19\] VGND VGND VPWR VPWR net1086 sky130_fd_sc_hd__dlygate4sd3_1
XFILLER_116_141 VPWR VGND VPWR VGND sky130_ef_sc_hd__decap_12
Xhold243 u_interface.fifo_data\[4\]\[24\] VGND VGND VPWR VPWR net1108 sky130_fd_sc_hd__dlygate4sd3_1
XFILLER_2_419 VGND VGND VPWR VPWR sky130_fd_sc_hd__fill_1
Xhold232 u_interface.fifo_data\[9\]\[8\] VGND VGND VPWR VPWR net1097 sky130_fd_sc_hd__dlygate4sd3_1
Xhold265 u_interface.fifo_data\[13\]\[16\] VGND VGND VPWR VPWR net1130 sky130_fd_sc_hd__dlygate4sd3_1
XTAP_TAPCELL_ROW_148_2704 VGND VPWR sky130_fd_sc_hd__tapvpwrvgnd_1
Xhold287 u_interface.fifo_data\[9\]\[23\] VGND VGND VPWR VPWR net1152 sky130_fd_sc_hd__dlygate4sd3_1
Xhold276 u_interface.fifo_data\[8\]\[11\] VGND VGND VPWR VPWR net1141 sky130_fd_sc_hd__dlygate4sd3_1
Xhold254 u_interface.fifo_data\[14\]\[30\] VGND VGND VPWR VPWR net1119 sky130_fd_sc_hd__dlygate4sd3_1
XFILLER_49_27 VPWR VGND VPWR VGND sky130_ef_sc_hd__decap_12
Xhold298 u_interface.fifo_tlast\[5\] VGND VGND VPWR VPWR net1163 sky130_fd_sc_hd__dlygate4sd3_1
Xfanout723 net724 VGND VGND VPWR VPWR net723 sky130_fd_sc_hd__buf_2
X_09925_ _03676_ _03677_ VGND VGND VPWR VPWR _03678_ sky130_fd_sc_hd__and2b_1
Xfanout712 net716 VGND VGND VPWR VPWR net712 sky130_fd_sc_hd__buf_2
Xfanout701 net702 VGND VGND VPWR VPWR net701 sky130_fd_sc_hd__buf_2
Xfanout767 net771 VGND VGND VPWR VPWR net767 sky130_fd_sc_hd__buf_4
Xfanout734 net737 VGND VGND VPWR VPWR net734 sky130_fd_sc_hd__buf_2
X_09856_ _03458_ _03460_ _03608_ _03609_ VGND VGND VPWR VPWR _03610_ sky130_fd_sc_hd__o211a_1
Xfanout745 _00001_ VGND VGND VPWR VPWR net745 sky130_fd_sc_hd__clkbuf_2
XFILLER_86_721 VGND VGND VPWR VPWR sky130_fd_sc_hd__decap_4
Xfanout756 net759 VGND VGND VPWR VPWR net756 sky130_fd_sc_hd__buf_4
XFILLER_58_401 VPWR VGND VPWR VGND sky130_ef_sc_hd__decap_12
Xfanout789 net790 VGND VGND VPWR VPWR net789 sky130_fd_sc_hd__buf_1
Xfanout778 net779 VGND VGND VPWR VPWR net778 sky130_fd_sc_hd__clkbuf_2
X_08807_ _02513_ _02564_ _02565_ VGND VGND VPWR VPWR _02566_ sky130_fd_sc_hd__nand3_1
XFILLER_105_55 VGND VGND VPWR VPWR sky130_fd_sc_hd__fill_1
XFILLER_85_220 VGND VGND VPWR VPWR sky130_fd_sc_hd__decap_4
XFILLER_65_15 VPWR VGND VPWR VGND sky130_ef_sc_hd__decap_12
X_06999_ _01501_ _01515_ VGND VGND VPWR VPWR _01517_ sky130_fd_sc_hd__nor2_2
XFILLER_105_99 VPWR VGND VPWR VGND sky130_ef_sc_hd__decap_12
X_09787_ _03434_ _03442_ _03443_ VGND VGND VPWR VPWR _03541_ sky130_fd_sc_hd__a21o_1
XFILLER_100_575 VGND VGND VPWR VPWR sky130_fd_sc_hd__decap_8
XFILLER_65_48 VGND VGND VPWR VPWR sky130_fd_sc_hd__decap_8
XFILLER_58_489 VGND VGND VPWR VPWR sky130_fd_sc_hd__decap_3
XFILLER_18_309 VGND VGND VPWR VPWR sky130_fd_sc_hd__fill_2
XFILLER_27_821 VPWR VGND VPWR VGND sky130_ef_sc_hd__decap_12
XTAP_TAPCELL_ROW_29_805 VGND VPWR sky130_fd_sc_hd__tapvpwrvgnd_1
X_08738_ _02495_ _02496_ _02492_ VGND VGND VPWR VPWR _02497_ sky130_fd_sc_hd__a21o_1
XFILLER_100_597 VPWR VGND VPWR VGND sky130_ef_sc_hd__decap_12
XTAP_TAPCELL_ROW_68_1430 VGND VPWR sky130_fd_sc_hd__tapvpwrvgnd_1
XFILLER_54_640 VGND VGND VPWR VPWR sky130_fd_sc_hd__decap_4
XFILLER_54_662 VGND VGND VPWR VPWR sky130_fd_sc_hd__decap_6
XFILLER_27_865 VPWR VGND VPWR VGND sky130_ef_sc_hd__decap_12
X_08669_ net156 _02431_ VGND VGND VPWR VPWR _02432_ sky130_fd_sc_hd__nand2_1
XFILLER_81_36 VPWR VGND VPWR VGND sky130_ef_sc_hd__decap_12
X_10700_ _04226_ _04349_ _04348_ VGND VGND VPWR VPWR _04446_ sky130_fd_sc_hd__a21o_1
XFILLER_53_183 VGND VGND VPWR VPWR sky130_fd_sc_hd__fill_2
XTAP_TAPCELL_ROW_81_1630 VGND VPWR sky130_fd_sc_hd__tapvpwrvgnd_1
XFILLER_81_69 VGND VGND VPWR VPWR sky130_fd_sc_hd__decap_6
X_11680_ net711 net719 net429 net424 VGND VGND VPWR VPWR _05417_ sky130_fd_sc_hd__nand4_1
XFILLER_41_367 VPWR VGND VPWR VGND sky130_ef_sc_hd__decap_12
X_10631_ _04374_ _04377_ VGND VGND VPWR VPWR _04378_ sky130_fd_sc_hd__xnor2_1
XFILLER_14_41 VPWR VGND VPWR VGND sky130_ef_sc_hd__decap_12
XFILLER_139_266 VGND VGND VPWR VPWR sky130_fd_sc_hd__decap_3
X_10562_ _04184_ _04186_ VGND VGND VPWR VPWR _04310_ sky130_fd_sc_hd__and2b_1
X_13350_ clknet_leaf_67_clk _00360_ VGND VGND VPWR VPWR u_interface.fifo_data\[10\]\[27\]
+ sky130_fd_sc_hd__dfxtp_1
XFILLER_14_85 VPWR VGND VPWR VGND sky130_ef_sc_hd__decap_12
XFILLER_155_748 VGND VGND VPWR VPWR sky130_fd_sc_hd__decap_4
X_13281_ clknet_leaf_44_clk _00291_ VGND VGND VPWR VPWR u_interface.fifo_data\[0\]\[23\]
+ sky130_fd_sc_hd__dfxtp_1
X_12301_ _05958_ _05967_ _05966_ VGND VGND VPWR VPWR _06030_ sky130_fd_sc_hd__a21oi_1
XFILLER_6_725 VPWR VGND VPWR VGND sky130_ef_sc_hd__decap_12
XFILLER_154_258 VPWR VGND VPWR VGND sky130_ef_sc_hd__decap_12
X_10493_ net453 u_interface.u_gelu_fp32.u_synth_top.s2_dx\[15\] net669 net678 VGND
+ VGND VPWR VPWR _04241_ sky130_fd_sc_hd__nand4_1
XFILLER_6_769 VPWR VGND VPWR VGND sky130_ef_sc_hd__decap_12
X_12232_ _05959_ _05960_ VGND VGND VPWR VPWR _05962_ sky130_fd_sc_hd__xnor2_1
XFILLER_107_163 VGND VGND VPWR VPWR sky130_fd_sc_hd__fill_2
XTAP_TAPCELL_ROW_79_1592 VGND VPWR sky130_fd_sc_hd__tapvpwrvgnd_1
XFILLER_5_279 VGND VGND VPWR VPWR sky130_fd_sc_hd__fill_1
XFILLER_135_494 VGND VGND VPWR VPWR sky130_fd_sc_hd__decap_4
X_12163_ net684 net388 VGND VGND VPWR VPWR _05894_ sky130_fd_sc_hd__and2b_1
XFILLER_96_507 VGND VGND VPWR VPWR sky130_fd_sc_hd__decap_6
X_11114_ _04853_ _04856_ VGND VGND VPWR VPWR _04857_ sky130_fd_sc_hd__xnor2_1
X_12094_ net717 net407 VGND VGND VPWR VPWR _05826_ sky130_fd_sc_hd__nand2_4
XFILLER_1_441 VGND VGND VPWR VPWR sky130_fd_sc_hd__decap_6
XFILLER_89_592 VGND VGND VPWR VPWR sky130_fd_sc_hd__fill_1
X_11045_ _04673_ _04787_ VGND VGND VPWR VPWR _04789_ sky130_fd_sc_hd__nand2_1
XFILLER_49_423 VPWR VGND VPWR VGND sky130_ef_sc_hd__decap_12
XFILLER_1_485 VPWR VGND VPWR VGND sky130_ef_sc_hd__decap_12
XFILLER_103_391 VGND VGND VPWR VPWR sky130_fd_sc_hd__fill_1
XFILLER_76_242 VGND VGND VPWR VPWR sky130_fd_sc_hd__fill_2
XFILLER_65_905 VGND VGND VPWR VPWR sky130_fd_sc_hd__decap_4
XFILLER_39_82 VPWR VGND VPWR VGND sky130_ef_sc_hd__decap_12
XFILLER_64_426 VGND VGND VPWR VPWR sky130_fd_sc_hd__fill_2
XFILLER_37_629 VPWR VGND VPWR VGND sky130_ef_sc_hd__decap_12
X_12996_ net1014 net358 net223 VGND VGND VPWR VPWR _01079_ sky130_fd_sc_hd__mux2_1
XFILLER_91_223 VGND VGND VPWR VPWR sky130_fd_sc_hd__fill_1
XFILLER_45_640 VGND VGND VPWR VPWR sky130_fd_sc_hd__decap_6
XFILLER_36_139 VGND VGND VPWR VPWR sky130_fd_sc_hd__fill_1
XFILLER_45_673 VGND VGND VPWR VPWR sky130_fd_sc_hd__fill_2
X_11947_ net701 net407 VGND VGND VPWR VPWR _05681_ sky130_fd_sc_hd__nand2_1
XFILLER_91_289 VPWR VGND VPWR VGND sky130_ef_sc_hd__decap_12
XFILLER_72_470 VGND VGND VPWR VPWR sky130_fd_sc_hd__decap_6
X_11878_ _05610_ _05611_ VGND VGND VPWR VPWR _05613_ sky130_fd_sc_hd__xor2_1
X_13617_ clknet_leaf_63_clk _00627_ VGND VGND VPWR VPWR u_interface.fifo_data\[13\]\[0\]
+ sky130_fd_sc_hd__dfxtp_1
XFILLER_60_698 VGND VGND VPWR VPWR sky130_fd_sc_hd__fill_2
X_10829_ _04572_ _04573_ VGND VGND VPWR VPWR _04574_ sky130_fd_sc_hd__nor2_1
XTAP_TAPCELL_ROW_15_576 VGND VPWR sky130_fd_sc_hd__tapvpwrvgnd_1
XFILLER_146_715 VGND VGND VPWR VPWR sky130_fd_sc_hd__fill_2
XTAP_TAPCELL_ROW_99_1924 VGND VPWR sky130_fd_sc_hd__tapvpwrvgnd_1
XTAP_TAPCELL_ROW_99_1913 VGND VPWR sky130_fd_sc_hd__tapvpwrvgnd_1
X_13548_ clknet_leaf_67_clk _00558_ VGND VGND VPWR VPWR u_interface.fifo_data\[5\]\[27\]
+ sky130_fd_sc_hd__dfxtp_1
XFILLER_9_541 VPWR VGND VPWR VGND sky130_ef_sc_hd__decap_12
XFILLER_118_417 VGND VGND VPWR VPWR sky130_fd_sc_hd__decap_3
XFILLER_9_585 VPWR VGND VPWR VGND sky130_ef_sc_hd__decap_12
X_13479_ clknet_leaf_4_clk _00489_ VGND VGND VPWR VPWR u_interface.u_gelu_fp32.u_synth_top.s2_b\[14\]
+ sky130_fd_sc_hd__dfxtp_1
XFILLER_65_3 VPWR VGND VPWR VGND sky130_ef_sc_hd__decap_12
XFILLER_114_601 VPWR VGND VPWR VGND sky130_ef_sc_hd__decap_12
XFILLER_154_792 VPWR VGND VPWR VGND sky130_ef_sc_hd__decap_12
XFILLER_114_645 VGND VGND VPWR VPWR sky130_fd_sc_hd__fill_1
XFILLER_113_100 VPWR VGND VPWR VGND sky130_ef_sc_hd__decap_12
XFILLER_141_442 VGND VGND VPWR VPWR sky130_fd_sc_hd__fill_1
X_07971_ net1255 _01847_ net780 VGND VGND VPWR VPWR _00690_ sky130_fd_sc_hd__mux2_1
XFILLER_114_667 VGND VGND VPWR VPWR sky130_fd_sc_hd__decap_4
XFILLER_113_188 VPWR VGND VPWR VGND sky130_ef_sc_hd__decap_12
XFILLER_113_166 VGND VGND VPWR VPWR sky130_fd_sc_hd__fill_2
X_09710_ _03462_ _03463_ _03429_ VGND VGND VPWR VPWR _03465_ sky130_fd_sc_hd__a21oi_1
X_06922_ _01457_ _01458_ VGND VGND VPWR VPWR _00038_ sky130_fd_sc_hd__xnor2_1
XFILLER_67_220 VGND VGND VPWR VPWR sky130_fd_sc_hd__fill_1
X_06853_ u_interface.fifo_data\[12\]\[28\] u_interface.fifo_data\[13\]\[28\] u_interface.fifo_data\[14\]\[28\]
+ u_interface.fifo_data\[15\]\[28\] net769 net752 VGND VGND VPWR VPWR _01400_ sky130_fd_sc_hd__mux4_1
XTAP_TAPCELL_ROW_143_2623 VGND VPWR sky130_fd_sc_hd__tapvpwrvgnd_1
X_09641_ _03257_ _03259_ _03394_ _03395_ VGND VGND VPWR VPWR _03397_ sky130_fd_sc_hd__a211oi_1
XFILLER_82_201 VGND VGND VPWR VPWR sky130_fd_sc_hd__decap_6
XFILLER_55_415 VGND VGND VPWR VPWR sky130_fd_sc_hd__decap_4
XPHY_EDGE_ROW_153_Left_309 VGND VGND VPWR VPWR sky130_fd_sc_hd__decap_3
X_06784_ net323 _01337_ net728 VGND VGND VPWR VPWR _01340_ sky130_fd_sc_hd__o21a_1
X_09572_ _03324_ _03327_ VGND VGND VPWR VPWR _03328_ sky130_fd_sc_hd__xnor2_1
XFILLER_83_779 VGND VGND VPWR VPWR sky130_fd_sc_hd__decap_4
XFILLER_82_256 VPWR VGND VPWR VGND sky130_ef_sc_hd__decap_12
XFILLER_82_245 VGND VGND VPWR VPWR sky130_fd_sc_hd__fill_2
XFILLER_24_813 VPWR VGND VPWR VGND sky130_ef_sc_hd__decap_12
X_08523_ _02155_ _02312_ VGND VGND VPWR VPWR _02314_ sky130_fd_sc_hd__nor2_1
XFILLER_35_150 VPWR VGND VPWR VGND sky130_ef_sc_hd__decap_12
X_08454_ net527 u_interface.u_gelu_fp32.u_synth_top.s3_mult\[34\] VGND VGND VPWR VPWR
+ _02245_ sky130_fd_sc_hd__and2_1
XFILLER_50_131 VGND VGND VPWR VPWR sky130_fd_sc_hd__decap_8
XTAP_TAPCELL_ROW_46_1068 VGND VPWR sky130_fd_sc_hd__tapvpwrvgnd_1
X_07405_ net813 net1679 net302 _01541_ VGND VGND VPWR VPWR _00429_ sky130_fd_sc_hd__a22o_1
X_08385_ _02174_ _02175_ VGND VGND VPWR VPWR _02176_ sky130_fd_sc_hd__nand2_1
XFILLER_50_153 VPWR VGND VPWR VGND sky130_ef_sc_hd__decap_12
XTAP_TAPCELL_ROW_46_1079 VGND VPWR sky130_fd_sc_hd__tapvpwrvgnd_1
XFILLER_11_529 VPWR VGND VPWR VGND sky130_ef_sc_hd__decap_12
XTAP_TAPCELL_ROW_34_874 VGND VPWR sky130_fd_sc_hd__tapvpwrvgnd_1
XTAP_TAPCELL_ROW_34_885 VGND VPWR sky130_fd_sc_hd__tapvpwrvgnd_1
X_07336_ net382 net1576 net244 VGND VGND VPWR VPWR _00366_ sky130_fd_sc_hd__mux2_1
XFILLER_50_197 VPWR VGND VPWR VGND sky130_ef_sc_hd__decap_12
XFILLER_137_726 VGND VGND VPWR VPWR sky130_fd_sc_hd__fill_2
XTAP_TAPCELL_ROW_154_2796 VGND VPWR sky130_fd_sc_hd__tapvpwrvgnd_1
X_09006_ _02480_ _02485_ VGND VGND VPWR VPWR _02765_ sky130_fd_sc_hd__xnor2_1
X_07267_ net1139 net561 net249 VGND VGND VPWR VPWR _00299_ sky130_fd_sc_hd__mux2_1
XFILLER_136_269 VGND VGND VPWR VPWR sky130_fd_sc_hd__fill_1
XFILLER_124_409 VGND VGND VPWR VPWR sky130_fd_sc_hd__decap_3
XFILLER_117_461 VGND VGND VPWR VPWR sky130_fd_sc_hd__fill_1
XFILLER_105_612 VGND VGND VPWR VPWR sky130_fd_sc_hd__decap_4
X_07198_ net372 net1512 net257 VGND VGND VPWR VPWR _00238_ sky130_fd_sc_hd__mux2_1
XFILLER_104_122 VPWR VGND VPWR VGND sky130_ef_sc_hd__decap_12
XFILLER_116_32 VPWR VGND VPWR VGND sky130_ef_sc_hd__decap_12
Xfanout520 u_interface.u_gelu_fp32.u_synth_top.s2_dx\[0\] VGND VGND VPWR VPWR net520
+ sky130_fd_sc_hd__clkbuf_2
Xfanout542 u_interface.u_gelu_fp32.u_fp32_to_q16.s2_shift\[5\] VGND VGND VPWR VPWR
+ net542 sky130_fd_sc_hd__buf_2
XFILLER_132_486 VPWR VGND VPWR VGND sky130_ef_sc_hd__decap_12
XFILLER_132_475 VGND VGND VPWR VPWR sky130_fd_sc_hd__fill_1
Xfanout531 net534 VGND VGND VPWR VPWR net531 sky130_fd_sc_hd__buf_2
Xfanout553 u_interface.u_gelu_fp32.u_fp32_to_q16.s2_shift\[2\] VGND VGND VPWR VPWR
+ net553 sky130_fd_sc_hd__clkbuf_2
Xfanout575 u_interface.core_data_out\[24\] VGND VGND VPWR VPWR net575 sky130_fd_sc_hd__clkbuf_2
XFILLER_86_540 VGND VGND VPWR VPWR sky130_fd_sc_hd__decap_8
Xfanout564 u_interface.core_data_out\[30\] VGND VGND VPWR VPWR net564 sky130_fd_sc_hd__buf_1
X_09908_ _03172_ _03659_ _03660_ VGND VGND VPWR VPWR _03661_ sky130_fd_sc_hd__a21oi_1
Xfanout597 net599 VGND VGND VPWR VPWR net597 sky130_fd_sc_hd__buf_2
XFILLER_101_895 VGND VGND VPWR VPWR sky130_fd_sc_hd__fill_1
X_09839_ _03590_ _03592_ VGND VGND VPWR VPWR _03593_ sky130_fd_sc_hd__nor2_1
Xfanout586 net588 VGND VGND VPWR VPWR net586 sky130_fd_sc_hd__buf_2
XFILLER_58_253 VPWR VGND VPWR VGND sky130_ef_sc_hd__decap_12
XFILLER_19_629 VPWR VGND VPWR VGND sky130_ef_sc_hd__decap_12
X_12850_ net71 _06423_ _06430_ _06431_ net790 VGND VGND VPWR VPWR _00995_ sky130_fd_sc_hd__o311a_1
XFILLER_74_757 VPWR VGND VPWR VGND sky130_ef_sc_hd__decap_12
XFILLER_73_223 VGND VGND VPWR VPWR sky130_fd_sc_hd__fill_1
XFILLER_18_139 VGND VGND VPWR VPWR sky130_fd_sc_hd__fill_1
X_11801_ _05527_ _05536_ VGND VGND VPWR VPWR _05537_ sky130_fd_sc_hd__xnor2_1
X_12781_ u_interface.u_gelu_fp32.u_q16_to_fp32.s3_norm_mag\[19\] _01782_ net295 VGND
+ VGND VPWR VPWR _06407_ sky130_fd_sc_hd__o21ai_1
XFILLER_27_673 VPWR VGND VPWR VGND sky130_ef_sc_hd__decap_12
X_11732_ _05319_ _05387_ _05386_ VGND VGND VPWR VPWR _05469_ sky130_fd_sc_hd__a21boi_1
XFILLER_25_51 VGND VGND VPWR VPWR sky130_fd_sc_hd__decap_4
XFILLER_30_805 VGND VGND VPWR VPWR sky130_fd_sc_hd__decap_6
XFILLER_42_654 VGND VGND VPWR VPWR sky130_fd_sc_hd__fill_2
XPHY_EDGE_ROW_153_Right_153 VGND VGND VPWR VPWR sky130_fd_sc_hd__decap_3
X_11663_ net185 _05318_ _05317_ VGND VGND VPWR VPWR _05400_ sky130_fd_sc_hd__a21bo_1
XFILLER_41_164 VGND VGND VPWR VPWR sky130_fd_sc_hd__decap_4
X_13402_ clknet_leaf_50_clk _00412_ VGND VGND VPWR VPWR u_interface.fifo_data\[6\]\[15\]
+ sky130_fd_sc_hd__dfxtp_1
X_10614_ _04352_ _04358_ _04359_ VGND VGND VPWR VPWR _04361_ sky130_fd_sc_hd__nand3_1
XTAP_TAPCELL_ROW_12_524 VGND VPWR sky130_fd_sc_hd__tapvpwrvgnd_1
XTAP_TAPCELL_ROW_12_535 VGND VPWR sky130_fd_sc_hd__tapvpwrvgnd_1
XFILLER_30_849 VPWR VGND VPWR VGND sky130_ef_sc_hd__decap_12
XFILLER_41_197 VPWR VGND VPWR VGND sky130_ef_sc_hd__decap_12
X_13333_ clknet_leaf_38_clk _00343_ VGND VGND VPWR VPWR u_interface.fifo_data\[10\]\[10\]
+ sky130_fd_sc_hd__dfxtp_1
X_11594_ net711 net429 net424 net703 VGND VGND VPWR VPWR _05332_ sky130_fd_sc_hd__a22oi_2
XFILLER_127_247 VGND VGND VPWR VPWR sky130_fd_sc_hd__fill_1
XFILLER_127_225 VPWR VGND VPWR VGND sky130_ef_sc_hd__decap_12
X_10545_ _04151_ _04291_ VGND VGND VPWR VPWR _04293_ sky130_fd_sc_hd__xor2_1
XFILLER_6_533 VPWR VGND VPWR VGND sky130_ef_sc_hd__decap_12
XFILLER_115_409 VGND VGND VPWR VPWR sky130_fd_sc_hd__fill_1
XTAP_TAPCELL_ROW_94_1843 VGND VPWR sky130_fd_sc_hd__tapvpwrvgnd_1
XTAP_TAPCELL_ROW_94_1832 VGND VPWR sky130_fd_sc_hd__tapvpwrvgnd_1
X_10476_ net474 net478 VGND VGND VPWR VPWR _04224_ sky130_fd_sc_hd__or2_1
X_13264_ clknet_leaf_72_clk _00274_ VGND VGND VPWR VPWR u_interface.fifo_data\[0\]\[6\]
+ sky130_fd_sc_hd__dfxtp_1
XFILLER_142_228 VPWR VGND VPWR VGND sky130_ef_sc_hd__decap_12
X_13195_ clknet_leaf_71_clk _00205_ VGND VGND VPWR VPWR u_interface.fifo_data\[12\]\[5\]
+ sky130_fd_sc_hd__dfxtp_1
X_12215_ net200 _05943_ VGND VGND VPWR VPWR _05945_ sky130_fd_sc_hd__xnor2_1
X_12146_ _05875_ _05876_ VGND VGND VPWR VPWR _05877_ sky130_fd_sc_hd__nor2_1
XFILLER_150_261 VPWR VGND VPWR VGND sky130_ef_sc_hd__decap_12
XFILLER_150_250 VGND VGND VPWR VPWR sky130_fd_sc_hd__fill_2
XFILLER_1_293 VPWR VGND VPWR VGND sky130_ef_sc_hd__decap_12
X_12077_ net198 _05807_ VGND VGND VPWR VPWR _05809_ sky130_fd_sc_hd__nor2_1
X_11028_ _04643_ _04645_ VGND VGND VPWR VPWR _04772_ sky130_fd_sc_hd__nand2_1
XFILLER_49_264 VGND VGND VPWR VPWR sky130_fd_sc_hd__fill_2
XFILLER_2_77 VGND VGND VPWR VPWR sky130_fd_sc_hd__decap_6
XTAP_TAPCELL_ROW_125_2342 VGND VPWR sky130_fd_sc_hd__tapvpwrvgnd_1
XTAP_TAPCELL_ROW_125_2331 VGND VPWR sky130_fd_sc_hd__tapvpwrvgnd_1
XFILLER_92_554 VGND VGND VPWR VPWR sky130_fd_sc_hd__fill_1
X_12979_ _06494_ _06495_ net1747 VGND VGND VPWR VPWR _06496_ sky130_fd_sc_hd__a21oi_1
XFILLER_80_727 VGND VGND VPWR VPWR sky130_fd_sc_hd__decap_8
XFILLER_17_161 VGND VGND VPWR VPWR sky130_fd_sc_hd__fill_1
XFILLER_24_109 VPWR VGND VPWR VGND sky130_ef_sc_hd__decap_12
XFILLER_33_665 VGND VGND VPWR VPWR sky130_fd_sc_hd__decap_6
XPHY_EDGE_ROW_120_Right_120 VGND VGND VPWR VPWR sky130_fd_sc_hd__decap_3
XTAP_TAPCELL_ROW_103_1983 VGND VPWR sky130_fd_sc_hd__tapvpwrvgnd_1
X_08170_ net289 _02007_ VGND VGND VPWR VPWR _00729_ sky130_fd_sc_hd__nor2_1
XFILLER_60_484 VGND VGND VPWR VPWR sky130_fd_sc_hd__fill_1
XANTENNA_16 net388 VGND VGND VPWR VPWR sky130_fd_sc_hd__diode_2
XFILLER_20_337 VGND VGND VPWR VPWR sky130_fd_sc_hd__decap_6
XTAP_TAPCELL_ROW_31_833 VGND VPWR sky130_fd_sc_hd__tapvpwrvgnd_1
XFILLER_146_501 VPWR VGND VPWR VGND sky130_ef_sc_hd__decap_12
X_07121_ net968 net324 net239 VGND VGND VPWR VPWR _00161_ sky130_fd_sc_hd__mux2_1
XFILLER_118_236 VPWR VGND VPWR VGND sky130_ef_sc_hd__decap_12
XFILLER_9_393 VPWR VGND VPWR VGND sky130_ef_sc_hd__decap_12
X_07052_ net1094 net378 net207 VGND VGND VPWR VPWR _00092_ sky130_fd_sc_hd__mux2_1
Xoutput123 net123 VGND VGND VPWR VPWR m_axis_tdata[22] sky130_fd_sc_hd__buf_2
Xoutput112 net112 VGND VGND VPWR VPWR m_axis_tdata[12] sky130_fd_sc_hd__buf_2
Xoutput134 net134 VGND VGND VPWR VPWR m_axis_tdata[3] sky130_fd_sc_hd__buf_2
Xoutput145 net145 VGND VGND VPWR VPWR s_axil_awready sky130_fd_sc_hd__buf_2
XFILLER_142_751 VGND VGND VPWR VPWR sky130_fd_sc_hd__decap_4
XFILLER_114_497 VGND VGND VPWR VPWR sky130_fd_sc_hd__fill_2
XFILLER_101_103 VGND VGND VPWR VPWR sky130_fd_sc_hd__decap_6
XFILLER_99_175 VGND VGND VPWR VPWR sky130_fd_sc_hd__decap_6
XFILLER_87_304 VGND VGND VPWR VPWR sky130_fd_sc_hd__decap_6
X_07954_ net542 net308 VGND VGND VPWR VPWR _01838_ sky130_fd_sc_hd__nor2_1
XFILLER_99_197 VGND VGND VPWR VPWR sky130_fd_sc_hd__fill_1
XFILLER_68_540 VGND VGND VPWR VPWR sky130_fd_sc_hd__fill_1
X_07885_ net1261 net347 net268 VGND VGND VPWR VPWR _00646_ sky130_fd_sc_hd__mux2_1
XFILLER_101_169 VGND VGND VPWR VPWR sky130_fd_sc_hd__decap_6
X_06905_ _01437_ _01440_ _01438_ VGND VGND VPWR VPWR _01446_ sky130_fd_sc_hd__o21bai_1
XFILLER_68_573 VGND VGND VPWR VPWR sky130_fd_sc_hd__decap_3
XFILLER_56_724 VGND VGND VPWR VPWR sky130_fd_sc_hd__fill_1
X_09624_ _03172_ _03379_ VGND VGND VPWR VPWR _03380_ sky130_fd_sc_hd__xnor2_1
X_06836_ _01381_ _01382_ _01385_ net317 VGND VGND VPWR VPWR net126 sky130_fd_sc_hd__a22o_1
XFILLER_56_746 VGND VGND VPWR VPWR sky130_fd_sc_hd__fill_1
XFILLER_28_426 VGND VGND VPWR VPWR sky130_fd_sc_hd__decap_8
XTAP_TAPCELL_ROW_48_1108 VGND VPWR sky130_fd_sc_hd__tapvpwrvgnd_1
XTAP_TAPCELL_ROW_39_955 VGND VPWR sky130_fd_sc_hd__tapvpwrvgnd_1
XTAP_TAPCELL_ROW_39_966 VGND VPWR sky130_fd_sc_hd__tapvpwrvgnd_1
X_09555_ _03226_ _03309_ _03310_ VGND VGND VPWR VPWR _03312_ sky130_fd_sc_hd__and3_1
X_06767_ net322 _01324_ VGND VGND VPWR VPWR _01325_ sky130_fd_sc_hd__or2_1
XFILLER_102_34 VPWR VGND VPWR VGND sky130_ef_sc_hd__decap_12
XFILLER_71_749 VGND VGND VPWR VPWR sky130_fd_sc_hd__fill_1
X_09486_ _03173_ _03241_ VGND VGND VPWR VPWR _03243_ sky130_fd_sc_hd__xnor2_1
XFILLER_62_27 VGND VGND VPWR VPWR sky130_fd_sc_hd__fill_1
X_06698_ u_interface.fifo_data\[4\]\[8\] u_interface.fifo_data\[5\]\[8\] u_interface.fifo_data\[6\]\[8\]
+ u_interface.fifo_data\[7\]\[8\] net758 net741 VGND VGND VPWR VPWR _01265_ sky130_fd_sc_hd__mux4_1
X_08506_ net523 u_interface.u_gelu_fp32.u_synth_top.s3_mult\[53\] VGND VGND VPWR VPWR
+ _02297_ sky130_fd_sc_hd__nand2_1
X_08437_ _02224_ _02226_ _02194_ _02195_ VGND VGND VPWR VPWR _02228_ sky130_fd_sc_hd__o211a_1
XTAP_TAPCELL_ROW_61_1319 VGND VPWR sky130_fd_sc_hd__tapvpwrvgnd_1
XTAP_TAPCELL_ROW_61_1308 VGND VPWR sky130_fd_sc_hd__tapvpwrvgnd_1
XFILLER_12_805 VGND VGND VPWR VPWR sky130_fd_sc_hd__decap_6
XFILLER_11_337 VPWR VGND VPWR VGND sky130_ef_sc_hd__decap_12
XFILLER_11_326 VGND VGND VPWR VPWR sky130_fd_sc_hd__decap_8
XFILLER_12_849 VPWR VGND VPWR VGND sky130_ef_sc_hd__decap_12
XFILLER_109_214 VGND VGND VPWR VPWR sky130_fd_sc_hd__fill_2
X_08368_ _02158_ VGND VGND VPWR VPWR _02159_ sky130_fd_sc_hd__inv_2
X_07319_ net1013 net352 net256 VGND VGND VPWR VPWR _00349_ sky130_fd_sc_hd__mux2_1
XFILLER_109_225 VGND VGND VPWR VPWR sky130_fd_sc_hd__decap_3
X_08299_ u_interface.u_gelu_fp32.s2_data\[14\] _02104_ VGND VGND VPWR VPWR _02107_
+ sky130_fd_sc_hd__or2_1
XFILLER_20_893 VPWR VGND VPWR VGND sky130_ef_sc_hd__decap_12
XFILLER_125_729 VGND VGND VPWR VPWR sky130_fd_sc_hd__decap_4
XFILLER_109_269 VGND VGND VPWR VPWR sky130_fd_sc_hd__decap_4
X_10330_ _04079_ VGND VGND VPWR VPWR _04080_ sky130_fd_sc_hd__inv_2
XFILLER_3_503 VGND VGND VPWR VPWR sky130_fd_sc_hd__fill_1
XFILLER_127_20 VGND VGND VPWR VPWR sky130_fd_sc_hd__decap_4
XFILLER_118_792 VGND VGND VPWR VPWR sky130_fd_sc_hd__decap_4
X_10261_ _04008_ _04009_ _04010_ VGND VGND VPWR VPWR _04011_ sky130_fd_sc_hd__a21oi_1
XTAP_TAPCELL_ROW_76_1551 VGND VPWR sky130_fd_sc_hd__tapvpwrvgnd_1
XFILLER_133_762 VPWR VGND VPWR VGND sky130_ef_sc_hd__decap_12
X_12000_ net199 _05731_ VGND VGND VPWR VPWR _05733_ sky130_fd_sc_hd__nor2_1
XFILLER_87_57 VGND VGND VPWR VPWR sky130_fd_sc_hd__decap_8
X_10192_ _03940_ _03941_ VGND VGND VPWR VPWR _03943_ sky130_fd_sc_hd__xnor2_1
XFILLER_143_30 VGND VGND VPWR VPWR sky130_fd_sc_hd__decap_8
Xfanout350 u_interface.core_data_out\[17\] VGND VGND VPWR VPWR net350 sky130_fd_sc_hd__clkbuf_2
Xfanout383 u_interface.core_data_out\[1\] VGND VGND VPWR VPWR net383 sky130_fd_sc_hd__dlymetal6s2s_1
X_13951_ clknet_leaf_55_clk _00877_ VGND VGND VPWR VPWR u_interface.u_gelu_fp32.u_q16_to_fp32.s2_exp\[3\]
+ sky130_fd_sc_hd__dfxtp_1
Xfanout361 u_interface.core_data_out\[12\] VGND VGND VPWR VPWR net361 sky130_fd_sc_hd__buf_1
Xfanout372 u_interface.core_data_out\[6\] VGND VGND VPWR VPWR net372 sky130_fd_sc_hd__clkbuf_2
X_12902_ net787 net956 VGND VGND VPWR VPWR _01044_ sky130_fd_sc_hd__and2_1
Xfanout394 net396 VGND VGND VPWR VPWR net394 sky130_fd_sc_hd__dlymetal6s2s_1
XTAP_TAPCELL_ROW_107_2050 VGND VPWR sky130_fd_sc_hd__tapvpwrvgnd_1
X_13882_ clknet_leaf_5_clk _00035_ VGND VGND VPWR VPWR u_interface.u_gelu_fp32.u_synth_top.s2_dx\[18\]
+ sky130_fd_sc_hd__dfxtp_1
XFILLER_19_459 VGND VGND VPWR VPWR sky130_fd_sc_hd__decap_4
X_12833_ net1671 net213 net781 VGND VGND VPWR VPWR _00991_ sky130_fd_sc_hd__mux2_1
XFILLER_46_289 VGND VGND VPWR VPWR sky130_fd_sc_hd__decap_4
XTAP_TAPCELL_ROW_17_605 VGND VPWR sky130_fd_sc_hd__tapvpwrvgnd_1
X_12764_ _01776_ _06398_ VGND VGND VPWR VPWR _00942_ sky130_fd_sc_hd__nor2_1
XFILLER_61_259 VPWR VGND VPWR VGND sky130_ef_sc_hd__decap_12
XTAP_TAPCELL_ROW_120_2261 VGND VPWR sky130_fd_sc_hd__tapvpwrvgnd_1
XTAP_TAPCELL_ROW_120_2250 VGND VPWR sky130_fd_sc_hd__tapvpwrvgnd_1
XFILLER_14_153 VPWR VGND VPWR VGND sky130_ef_sc_hd__decap_12
XFILLER_15_665 VGND VGND VPWR VPWR sky130_fd_sc_hd__decap_6
X_11715_ _05449_ _05450_ VGND VGND VPWR VPWR _05452_ sky130_fd_sc_hd__xor2_1
XFILLER_30_613 VPWR VGND VPWR VGND sky130_ef_sc_hd__decap_12
X_12695_ _06353_ _01750_ net329 VGND VGND VPWR VPWR _06354_ sky130_fd_sc_hd__mux2_1
XFILLER_30_657 VPWR VGND VPWR VGND sky130_ef_sc_hd__decap_12
X_11646_ _05328_ _05383_ VGND VGND VPWR VPWR _05384_ sky130_fd_sc_hd__xor2_1
Xinput36 s_axil_awaddr[0] VGND VGND VPWR VPWR net36 sky130_fd_sc_hd__clkbuf_1
Xinput25 s_axil_araddr[2] VGND VGND VPWR VPWR net25 sky130_fd_sc_hd__clkbuf_1
Xinput14 s_axil_araddr[1] VGND VGND VPWR VPWR net14 sky130_fd_sc_hd__clkbuf_1
X_11577_ net185 _05219_ _05218_ VGND VGND VPWR VPWR _05315_ sky130_fd_sc_hd__a21o_1
Xinput58 s_axil_awaddr[2] VGND VGND VPWR VPWR net58 sky130_fd_sc_hd__clkbuf_1
Xinput47 s_axil_awaddr[1] VGND VGND VPWR VPWR net47 sky130_fd_sc_hd__clkbuf_1
Xinput69 s_axil_bready VGND VGND VPWR VPWR net69 sky130_fd_sc_hd__clkbuf_1
XFILLER_128_589 VPWR VGND VPWR VGND sky130_ef_sc_hd__decap_12
XFILLER_128_578 VGND VGND VPWR VPWR sky130_fd_sc_hd__decap_6
XFILLER_116_729 VGND VGND VPWR VPWR sky130_fd_sc_hd__decap_8
X_13316_ clknet_leaf_48_clk _00326_ VGND VGND VPWR VPWR u_interface.fifo_data\[8\]\[25\]
+ sky130_fd_sc_hd__dfxtp_1
Xhold809 _00885_ VGND VGND VPWR VPWR net1674 sky130_fd_sc_hd__dlygate4sd3_1
X_10528_ _04274_ _04275_ _04258_ VGND VGND VPWR VPWR _04276_ sky130_fd_sc_hd__a21o_1
XFILLER_7_853 VPWR VGND VPWR VGND sky130_ef_sc_hd__decap_12
X_13247_ clknet_leaf_48_clk _00257_ VGND VGND VPWR VPWR u_interface.fifo_data\[11\]\[25\]
+ sky130_fd_sc_hd__dfxtp_1
XFILLER_7_897 VPWR VGND VPWR VGND sky130_ef_sc_hd__decap_12
XFILLER_143_559 VGND VGND VPWR VPWR sky130_fd_sc_hd__fill_1
X_10459_ net277 _03869_ _04206_ VGND VGND VPWR VPWR _04207_ sky130_fd_sc_hd__a21o_1
XFILLER_97_613 VGND VGND VPWR VPWR sky130_fd_sc_hd__decap_3
X_13178_ clknet_leaf_68_clk _00188_ VGND VGND VPWR VPWR u_interface.fifo_data\[9\]\[20\]
+ sky130_fd_sc_hd__dfxtp_1
XFILLER_69_337 VGND VGND VPWR VPWR sky130_fd_sc_hd__decap_4
X_12129_ net193 _05860_ VGND VGND VPWR VPWR _05861_ sky130_fd_sc_hd__xnor2_1
XFILLER_84_307 VGND VGND VPWR VPWR sky130_fd_sc_hd__fill_1
XFILLER_28_3 VPWR VGND VPWR VGND sky130_ef_sc_hd__decap_12
XFILLER_37_201 VGND VGND VPWR VPWR sky130_fd_sc_hd__decap_4
X_07670_ _01750_ _01735_ net330 VGND VGND VPWR VPWR _01751_ sky130_fd_sc_hd__mux2_1
X_06621_ u_interface.fifo_tlast\[8\] u_interface.fifo_tlast\[9\] u_interface.fifo_tlast\[10\]
+ u_interface.fifo_tlast\[11\] net768 net751 VGND VGND VPWR VPWR _01197_ sky130_fd_sc_hd__mux4_1
XFILLER_80_524 VGND VGND VPWR VPWR sky130_fd_sc_hd__decap_8
XTAP_TAPCELL_ROW_36_914 VGND VPWR sky130_fd_sc_hd__tapvpwrvgnd_1
X_09340_ net584 net600 net512 net517 VGND VGND VPWR VPWR _03099_ sky130_fd_sc_hd__and4_1
X_06552_ u_interface.u_gelu_fp32.s1_data\[14\] net287 _01146_ net537 VGND VGND VPWR
+ VPWR _01148_ sky130_fd_sc_hd__nand4b_1
X_09271_ _02922_ _03029_ VGND VGND VPWR VPWR _03030_ sky130_fd_sc_hd__nor2_1
XFILLER_21_613 VGND VGND VPWR VPWR sky130_fd_sc_hd__decap_3
XTAP_TAPCELL_ROW_43_1016 VGND VPWR sky130_fd_sc_hd__tapvpwrvgnd_1
X_08222_ u_interface.u_gelu_fp32.u_fp32_to_q16.s3_mag\[27\] u_interface.u_gelu_fp32.u_fp32_to_q16.s3_mag\[26\]
+ _01890_ u_interface.u_gelu_fp32.u_fp32_to_q16.s3_mag\[28\] VGND VGND VPWR VPWR _02051_
+ sky130_fd_sc_hd__a31o_1
XTAP_TAPCELL_ROW_43_1027 VGND VPWR sky130_fd_sc_hd__tapvpwrvgnd_1
XTAP_TAPCELL_ROW_138_2544 VGND VPWR sky130_fd_sc_hd__tapvpwrvgnd_1
XFILLER_138_309 VGND VGND VPWR VPWR sky130_fd_sc_hd__decap_4
XFILLER_20_156 VPWR VGND VPWR VGND sky130_ef_sc_hd__decap_12
XFILLER_147_854 VGND VGND VPWR VPWR sky130_fd_sc_hd__fill_2
X_08153_ _01885_ _01992_ VGND VGND VPWR VPWR _01993_ sky130_fd_sc_hd__nor2_1
XTAP_TAPCELL_ROW_151_2744 VGND VPWR sky130_fd_sc_hd__tapvpwrvgnd_1
X_08084_ net292 _01935_ VGND VGND VPWR VPWR _00715_ sky130_fd_sc_hd__nor2_1
X_07104_ net1065 net578 net228 VGND VGND VPWR VPWR _00144_ sky130_fd_sc_hd__mux2_1
XFILLER_107_729 VGND VGND VPWR VPWR sky130_fd_sc_hd__decap_6
XTAP_TAPCELL_ROW_151_2755 VGND VPWR sky130_fd_sc_hd__tapvpwrvgnd_1
X_07035_ net1215 net348 net270 VGND VGND VPWR VPWR _00075_ sky130_fd_sc_hd__mux2_1
XFILLER_115_762 VPWR VGND VPWR VGND sky130_ef_sc_hd__decap_12
XTAP_TAPCELL_ROW_58_1270 VGND VPWR sky130_fd_sc_hd__tapvpwrvgnd_1
XFILLER_114_261 VGND VGND VPWR VPWR sky130_fd_sc_hd__decap_4
XFILLER_88_635 VGND VGND VPWR VPWR sky130_fd_sc_hd__decap_8
XFILLER_0_517 VPWR VGND VPWR VGND sky130_ef_sc_hd__decap_12
X_08986_ net670 net516 net520 net679 VGND VGND VPWR VPWR _02745_ sky130_fd_sc_hd__a22oi_1
XFILLER_102_445 VGND VGND VPWR VPWR sky130_fd_sc_hd__decap_8
XFILLER_76_808 VGND VGND VPWR VPWR sky130_fd_sc_hd__decap_4
X_07937_ u_interface.u_gelu_fp32.u_fp32_to_q16.s1_exp\[2\] _01809_ VGND VGND VPWR
+ VPWR _01829_ sky130_fd_sc_hd__nor2_1
XFILLER_75_307 VGND VGND VPWR VPWR sky130_fd_sc_hd__decap_3
XTAP_TAPCELL_ROW_71_1470 VGND VPWR sky130_fd_sc_hd__tapvpwrvgnd_1
XFILLER_57_27 VPWR VGND VPWR VGND sky130_ef_sc_hd__decap_12
XFILLER_56_565 VGND VGND VPWR VPWR sky130_fd_sc_hd__fill_1
XTAP_TAPCELL_ROW_3_377 VGND VPWR sky130_fd_sc_hd__tapvpwrvgnd_1
X_07868_ net974 net380 net265 VGND VGND VPWR VPWR _00629_ sky130_fd_sc_hd__mux2_1
X_07799_ net1264 net565 net236 VGND VGND VPWR VPWR _00560_ sky130_fd_sc_hd__mux2_1
X_06819_ _01369_ _01370_ net734 VGND VGND VPWR VPWR _01371_ sky130_fd_sc_hd__mux2_1
XFILLER_113_77 VPWR VGND VPWR VGND sky130_ef_sc_hd__decap_12
X_09607_ _03360_ _03361_ _03328_ VGND VGND VPWR VPWR _03363_ sky130_fd_sc_hd__a21oi_1
XFILLER_83_384 VGND VGND VPWR VPWR sky130_fd_sc_hd__fill_2
XFILLER_73_15 VPWR VGND VPWR VGND sky130_ef_sc_hd__decap_12
XTAP_TAPCELL_ROW_3_388 VGND VPWR sky130_fd_sc_hd__tapvpwrvgnd_1
XFILLER_28_289 VGND VGND VPWR VPWR sky130_fd_sc_hd__decap_4
X_09538_ _03290_ _03291_ _03292_ VGND VGND VPWR VPWR _03295_ sky130_fd_sc_hd__and3_1
XFILLER_12_613 VPWR VGND VPWR VGND sky130_ef_sc_hd__decap_12
XFILLER_24_440 VPWR VGND VPWR VGND sky130_ef_sc_hd__decap_12
X_09469_ _03207_ _03209_ VGND VGND VPWR VPWR _03226_ sky130_fd_sc_hd__nand2b_1
XFILLER_52_782 VGND VGND VPWR VPWR sky130_fd_sc_hd__fill_1
XFILLER_51_281 VGND VGND VPWR VPWR sky130_fd_sc_hd__decap_6
X_11500_ _05146_ _05238_ VGND VGND VPWR VPWR _05239_ sky130_fd_sc_hd__nor2_1
XFILLER_138_821 VGND VGND VPWR VPWR sky130_fd_sc_hd__decap_6
XFILLER_132_3 VGND VGND VPWR VPWR sky130_fd_sc_hd__decap_3
XFILLER_7_105 VGND VGND VPWR VPWR sky130_fd_sc_hd__decap_6
XFILLER_12_657 VPWR VGND VPWR VGND sky130_ef_sc_hd__decap_12
X_12480_ _06203_ _06204_ VGND VGND VPWR VPWR _06206_ sky130_fd_sc_hd__nor2_1
XFILLER_11_167 VGND VGND VPWR VPWR sky130_fd_sc_hd__fill_1
XFILLER_22_41 VPWR VGND VPWR VGND sky130_ef_sc_hd__decap_12
XTAP_TAPCELL_ROW_22_685 VGND VPWR sky130_fd_sc_hd__tapvpwrvgnd_1
X_11431_ _05162_ _05170_ VGND VGND VPWR VPWR _05171_ sky130_fd_sc_hd__xor2_2
X_14150_ clknet_leaf_40_clk _01076_ VGND VGND VPWR VPWR u_interface.fifo_data\[1\]\[10\]
+ sky130_fd_sc_hd__dfxtp_1
X_11362_ _04945_ _05003_ _05002_ VGND VGND VPWR VPWR _05103_ sky130_fd_sc_hd__a21oi_1
XFILLER_7_149 VPWR VGND VPWR VGND sky130_ef_sc_hd__decap_12
XFILLER_22_85 VPWR VGND VPWR VGND sky130_ef_sc_hd__decap_12
X_13101_ clknet_leaf_36_clk _00111_ VGND VGND VPWR VPWR u_interface.fifo_data\[15\]\[22\]
+ sky130_fd_sc_hd__dfxtp_1
X_10313_ _04033_ _04034_ _04061_ _04062_ VGND VGND VPWR VPWR _04063_ sky130_fd_sc_hd__o22a_1
XFILLER_152_345 VPWR VGND VPWR VGND sky130_ef_sc_hd__decap_12
X_14081_ clknet_leaf_17_clk net1384 VGND VGND VPWR VPWR u_interface.u_gelu_fp32.u_fp32_to_q16.s2_norm_mag\[18\]
+ sky130_fd_sc_hd__dfxtp_1
X_11293_ _04933_ _05032_ VGND VGND VPWR VPWR _05034_ sky130_fd_sc_hd__xnor2_1
XFILLER_4_867 VGND VGND VPWR VPWR sky130_fd_sc_hd__fill_1
X_13032_ clknet_leaf_37_clk _00042_ VGND VGND VPWR VPWR u_interface.fifo_tuser\[13\]
+ sky130_fd_sc_hd__dfxtp_1
XFILLER_106_773 VGND VGND VPWR VPWR sky130_fd_sc_hd__fill_2
X_10244_ _03992_ _03993_ _03976_ VGND VGND VPWR VPWR _03994_ sky130_fd_sc_hd__a21o_1
XFILLER_78_101 VGND VGND VPWR VPWR sky130_fd_sc_hd__decap_6
XFILLER_79_646 VGND VGND VPWR VPWR sky130_fd_sc_hd__decap_3
X_10175_ net635 net449 VGND VGND VPWR VPWR _03926_ sky130_fd_sc_hd__nand2_1
XFILLER_121_776 VGND VGND VPWR VPWR sky130_fd_sc_hd__decap_8
Xfanout180 _04921_ VGND VGND VPWR VPWR net180 sky130_fd_sc_hd__clkbuf_2
Xfanout191 net194 VGND VGND VPWR VPWR net191 sky130_fd_sc_hd__buf_2
X_13934_ clknet_leaf_3_clk _00019_ VGND VGND VPWR VPWR u_interface.u_gelu_fp32.u_synth_top.s1_hits\[6\]
+ sky130_fd_sc_hd__dfxtp_1
XTAP_TAPCELL_ROW_105_2009 VGND VPWR sky130_fd_sc_hd__tapvpwrvgnd_1
XTAP_TAPCELL_ROW_89_1764 VGND VPWR sky130_fd_sc_hd__tapvpwrvgnd_1
XTAP_TAPCELL_ROW_89_1753 VGND VPWR sky130_fd_sc_hd__tapvpwrvgnd_1
XFILLER_19_245 VGND VGND VPWR VPWR sky130_fd_sc_hd__decap_8
X_13865_ clknet_leaf_19_clk net869 VGND VGND VPWR VPWR u_interface.u_gelu_fp32.u_synth_top.s2_dx\[1\]
+ sky130_fd_sc_hd__dfxtp_1
XFILLER_74_373 VPWR VGND VPWR VGND sky130_ef_sc_hd__decap_12
XFILLER_35_738 VGND VGND VPWR VPWR sky130_fd_sc_hd__fill_1
X_12816_ net778 net75 VGND VGND VPWR VPWR _00974_ sky130_fd_sc_hd__and2_1
X_13796_ clknet_leaf_80_clk _00806_ VGND VGND VPWR VPWR u_interface.u_gelu_fp32.s2_data\[30\]
+ sky130_fd_sc_hd__dfxtp_1
X_12747_ _01747_ _06343_ _06394_ VGND VGND VPWR VPWR _00929_ sky130_fd_sc_hd__a21o_1
XFILLER_63_92 VGND VGND VPWR VPWR sky130_fd_sc_hd__decap_4
XFILLER_63_81 VGND VGND VPWR VPWR sky130_fd_sc_hd__decap_6
XFILLER_15_473 VPWR VGND VPWR VGND sky130_ef_sc_hd__decap_12
XFILLER_30_421 VGND VGND VPWR VPWR sky130_fd_sc_hd__decap_4
XFILLER_147_117 VGND VGND VPWR VPWR sky130_fd_sc_hd__fill_1
X_12678_ net785 net928 VGND VGND VPWR VPWR _00914_ sky130_fd_sc_hd__and2_1
XTAP_TAPCELL_ROW_100_1942 VGND VPWR sky130_fd_sc_hd__tapvpwrvgnd_1
XTAP_TAPCELL_ROW_100_1931 VGND VPWR sky130_fd_sc_hd__tapvpwrvgnd_1
XFILLER_8_65 VPWR VGND VPWR VGND sky130_ef_sc_hd__decap_12
X_11629_ _05364_ _05365_ VGND VGND VPWR VPWR _05367_ sky130_fd_sc_hd__xnor2_1
XTAP_TAPCELL_ROW_41_994 VGND VPWR sky130_fd_sc_hd__tapvpwrvgnd_1
XFILLER_155_183 VGND VGND VPWR VPWR sky130_fd_sc_hd__fill_1
XTAP_TAPCELL_ROW_133_2463 VGND VPWR sky130_fd_sc_hd__tapvpwrvgnd_1
Xhold606 u_interface.fifo_data\[3\]\[27\] VGND VGND VPWR VPWR net1471 sky130_fd_sc_hd__dlygate4sd3_1
Xhold617 u_interface.fifo_data\[3\]\[20\] VGND VGND VPWR VPWR net1482 sky130_fd_sc_hd__dlygate4sd3_1
XFILLER_143_345 VGND VGND VPWR VPWR sky130_fd_sc_hd__decap_3
Xhold639 u_interface.u_gelu_fp32.u_fp32_to_q16.s3_frac\[5\] VGND VGND VPWR VPWR net1504
+ sky130_fd_sc_hd__dlygate4sd3_1
Xhold628 u_interface.fifo_data\[11\]\[12\] VGND VGND VPWR VPWR net1493 sky130_fd_sc_hd__dlygate4sd3_1
XFILLER_124_570 VPWR VGND VPWR VGND sky130_ef_sc_hd__decap_12
XFILLER_69_101 VGND VGND VPWR VPWR sky130_fd_sc_hd__decap_8
X_08840_ _02578_ _02597_ _02552_ _02553_ VGND VGND VPWR VPWR _02599_ sky130_fd_sc_hd__o211ai_2
XFILLER_97_421 VGND VGND VPWR VPWR sky130_fd_sc_hd__fill_1
XFILLER_97_465 VGND VGND VPWR VPWR sky130_fd_sc_hd__decap_8
X_08771_ _02528_ _02529_ VGND VGND VPWR VPWR _02530_ sky130_fd_sc_hd__and2b_1
XFILLER_112_798 VGND VGND VPWR VPWR sky130_fd_sc_hd__decap_3
XFILLER_84_137 VGND VGND VPWR VPWR sky130_fd_sc_hd__decap_3
XFILLER_57_329 VGND VGND VPWR VPWR sky130_fd_sc_hd__decap_6
X_07722_ u_interface.u_gelu_fp32.u_synth_top.s1_hits\[17\] _01185_ _01435_ _01770_
+ VGND VGND VPWR VPWR _00516_ sky130_fd_sc_hd__or4_1
XFILLER_38_543 VGND VGND VPWR VPWR sky130_fd_sc_hd__decap_6
XFILLER_93_671 VGND VGND VPWR VPWR sky130_fd_sc_hd__fill_1
X_07653_ net808 net1725 net299 _01737_ VGND VGND VPWR VPWR _00481_ sky130_fd_sc_hd__a22o_1
XFILLER_81_822 VGND VGND VPWR VPWR sky130_fd_sc_hd__fill_2
XFILLER_65_362 VPWR VGND VPWR VGND sky130_ef_sc_hd__decap_12
XTAP_TAPCELL_ROW_0_314 VGND VPWR sky130_fd_sc_hd__tapvpwrvgnd_1
XTAP_TAPCELL_ROW_0_325 VGND VPWR sky130_fd_sc_hd__tapvpwrvgnd_1
XTAP_TAPCELL_ROW_0_336 VGND VPWR sky130_fd_sc_hd__tapvpwrvgnd_1
XFILLER_38_587 VGND VGND VPWR VPWR sky130_fd_sc_hd__fill_1
X_06604_ _01175_ _01182_ VGND VGND VPWR VPWR _00014_ sky130_fd_sc_hd__nor2_1
XFILLER_26_749 VGND VGND VPWR VPWR sky130_fd_sc_hd__decap_6
X_09323_ _03078_ _03081_ VGND VGND VPWR VPWR _03082_ sky130_fd_sc_hd__nor2_1
X_07584_ net308 net303 _01650_ net1608 net812 VGND VGND VPWR VPWR _00461_ sky130_fd_sc_hd__a32o_1
XFILLER_80_365 VGND VGND VPWR VPWR sky130_fd_sc_hd__fill_1
X_06535_ u_interface.fifo_count\[5\] u_interface.fifo_count\[4\] _01132_ VGND VGND
+ VPWR VPWR net143 sky130_fd_sc_hd__or3_1
XFILLER_80_398 VPWR VGND VPWR VGND sky130_ef_sc_hd__decap_12
XFILLER_33_281 VPWR VGND VPWR VGND sky130_ef_sc_hd__decap_12
X_09254_ _02968_ _02970_ _02969_ VGND VGND VPWR VPWR _03013_ sky130_fd_sc_hd__o21ai_1
XFILLER_139_629 VGND VGND VPWR VPWR sky130_fd_sc_hd__decap_4
XFILLER_21_443 VGND VGND VPWR VPWR sky130_fd_sc_hd__decap_4
X_09185_ _02881_ _02943_ VGND VGND VPWR VPWR _02944_ sky130_fd_sc_hd__xnor2_1
XFILLER_138_139 VGND VGND VPWR VPWR sky130_fd_sc_hd__fill_1
X_08205_ net315 _02035_ _02036_ VGND VGND VPWR VPWR _02037_ sky130_fd_sc_hd__or3_1
XFILLER_119_331 VGND VGND VPWR VPWR sky130_fd_sc_hd__decap_4
X_08136_ net541 _01977_ _01978_ VGND VGND VPWR VPWR _01979_ sky130_fd_sc_hd__nand3_1
XFILLER_5_609 VGND VGND VPWR VPWR sky130_fd_sc_hd__decap_6
XFILLER_108_11 VGND VGND VPWR VPWR sky130_fd_sc_hd__fill_1
XFILLER_107_537 VGND VGND VPWR VPWR sky130_fd_sc_hd__decap_6
X_08067_ _01909_ _01913_ _01917_ net314 VGND VGND VPWR VPWR _01921_ sky130_fd_sc_hd__a31o_1
XFILLER_104_7 VGND VGND VPWR VPWR sky130_fd_sc_hd__fill_1
XTAP_TAPCELL_ROW_56_1229 VGND VPWR sky130_fd_sc_hd__tapvpwrvgnd_1
X_07018_ net1005 net383 net272 VGND VGND VPWR VPWR _00058_ sky130_fd_sc_hd__mux2_1
XTAP_TAPCELL_ROW_73_1510 VGND VPWR sky130_fd_sc_hd__tapvpwrvgnd_1
XFILLER_68_15 VPWR VGND VPWR VGND sky130_ef_sc_hd__decap_12
XTAP_TAPCELL_ROW_8_469 VGND VPWR sky130_fd_sc_hd__tapvpwrvgnd_1
XTAP_TAPCELL_ROW_8_458 VGND VPWR sky130_fd_sc_hd__tapvpwrvgnd_1
X_08969_ _02724_ _02727_ VGND VGND VPWR VPWR _02728_ sky130_fd_sc_hd__nand2b_1
XFILLER_75_148 VGND VGND VPWR VPWR sky130_fd_sc_hd__decap_4
XFILLER_56_340 VGND VGND VPWR VPWR sky130_fd_sc_hd__decap_4
X_11980_ _05650_ _05713_ VGND VGND VPWR VPWR _05714_ sky130_fd_sc_hd__xnor2_1
X_10931_ _03758_ _04566_ _04565_ VGND VGND VPWR VPWR _04675_ sky130_fd_sc_hd__o21ai_1
XFILLER_56_362 VGND VGND VPWR VPWR sky130_fd_sc_hd__fill_2
XFILLER_44_524 VGND VGND VPWR VPWR sky130_fd_sc_hd__decap_8
XFILLER_17_727 VGND VGND VPWR VPWR sky130_fd_sc_hd__fill_1
XFILLER_56_384 VPWR VGND VPWR VGND sky130_ef_sc_hd__decap_12
X_13650_ clknet_leaf_28_clk _00660_ VGND VGND VPWR VPWR u_interface.u_gelu_fp32.u_synth_top.v_pipe\[1\]
+ sky130_fd_sc_hd__dfxtp_1
XTAP_TAPCELL_ROW_84_1672 VGND VPWR sky130_fd_sc_hd__tapvpwrvgnd_1
X_10862_ _04605_ _04606_ VGND VGND VPWR VPWR _04607_ sky130_fd_sc_hd__nor2_1
XFILLER_16_259 VGND VGND VPWR VPWR sky130_fd_sc_hd__fill_2
XTAP_TAPCELL_ROW_27_766 VGND VPWR sky130_fd_sc_hd__tapvpwrvgnd_1
X_13581_ clknet_leaf_39_clk _00591_ VGND VGND VPWR VPWR u_interface.fifo_data\[4\]\[28\]
+ sky130_fd_sc_hd__dfxtp_1
XTAP_TAPCELL_ROW_84_1683 VGND VPWR sky130_fd_sc_hd__tapvpwrvgnd_1
X_12601_ _06303_ VGND VGND VPWR VPWR _06304_ sky130_fd_sc_hd__inv_2
X_10793_ _04488_ _04489_ _04535_ _04536_ VGND VGND VPWR VPWR _04539_ sky130_fd_sc_hd__and4bb_1
XFILLER_12_421 VGND VGND VPWR VPWR sky130_fd_sc_hd__decap_4
X_12532_ _06254_ _06255_ VGND VGND VPWR VPWR _06256_ sky130_fd_sc_hd__nor2_1
XFILLER_33_51 VGND VGND VPWR VPWR sky130_fd_sc_hd__fill_1
XFILLER_149_62 VPWR VGND VPWR VGND sky130_ef_sc_hd__decap_12
X_12463_ _06019_ _06143_ _06142_ VGND VGND VPWR VPWR _06189_ sky130_fd_sc_hd__o21a_1
X_11414_ _05152_ _05153_ VGND VGND VPWR VPWR _05154_ sky130_fd_sc_hd__nand2_1
X_12394_ _06058_ _06064_ _06121_ VGND VGND VPWR VPWR _06122_ sky130_fd_sc_hd__or3b_1
X_14133_ clknet_leaf_30_clk _01059_ VGND VGND VPWR VPWR u_interface.fifo_count\[0\]
+ sky130_fd_sc_hd__dfxtp_1
XTAP_TAPCELL_ROW_115_2182 VGND VPWR sky130_fd_sc_hd__tapvpwrvgnd_1
XTAP_TAPCELL_ROW_115_2171 VGND VPWR sky130_fd_sc_hd__tapvpwrvgnd_1
X_11345_ _05083_ _05084_ VGND VGND VPWR VPWR _05086_ sky130_fd_sc_hd__xnor2_1
X_14064_ clknet_leaf_55_clk _00990_ VGND VGND VPWR VPWR u_interface.u_gelu_fp32.u_q16_to_fp32.s2_clz\[3\]
+ sky130_fd_sc_hd__dfxtp_2
X_11276_ _04899_ _04901_ _05017_ VGND VGND VPWR VPWR _05018_ sky130_fd_sc_hd__a21oi_1
XFILLER_152_197 VGND VGND VPWR VPWR sky130_fd_sc_hd__decap_4
XFILLER_106_581 VGND VGND VPWR VPWR sky130_fd_sc_hd__fill_2
X_10227_ _03872_ _03874_ VGND VGND VPWR VPWR _03977_ sky130_fd_sc_hd__nand2_1
X_13015_ net1728 _02152_ _00993_ VGND VGND VPWR VPWR _06498_ sky130_fd_sc_hd__or3b_1
Xhold3 u_interface.u_gelu_fp32.u_synth_top.s1_x\[2\] VGND VGND VPWR VPWR net868 sky130_fd_sc_hd__dlygate4sd3_1
XFILLER_121_584 VPWR VGND VPWR VGND sky130_ef_sc_hd__decap_12
X_10158_ net461 net665 _03906_ _03907_ VGND VGND VPWR VPWR _03909_ sky130_fd_sc_hd__nand4_1
XFILLER_67_638 VPWR VGND VPWR VGND sky130_ef_sc_hd__decap_12
XFILLER_0_881 VGND VGND VPWR VPWR sky130_fd_sc_hd__decap_4
XFILLER_94_457 VGND VGND VPWR VPWR sky130_fd_sc_hd__decap_8
X_10089_ _03804_ _03839_ _03840_ VGND VGND VPWR VPWR _03841_ sky130_fd_sc_hd__and3_1
X_13917_ clknet_leaf_6_clk net902 VGND VGND VPWR VPWR u_interface.u_gelu_fp32.u_synth_top.s1_x\[21\]
+ sky130_fd_sc_hd__dfxtp_1
XFILLER_62_321 VGND VGND VPWR VPWR sky130_fd_sc_hd__decap_8
X_13848_ clknet_leaf_24_clk _00858_ VGND VGND VPWR VPWR u_interface.u_gelu_fp32.u_synth_top.s3_b\[4\]
+ sky130_fd_sc_hd__dfxtp_1
XFILLER_62_343 VPWR VGND VPWR VGND sky130_ef_sc_hd__decap_12
XFILLER_95_3 VPWR VGND VPWR VGND sky130_ef_sc_hd__decap_12
X_13779_ clknet_leaf_87_clk _00789_ VGND VGND VPWR VPWR u_interface.u_gelu_fp32.s2_data\[13\]
+ sky130_fd_sc_hd__dfxtp_1
XFILLER_50_549 VGND VGND VPWR VPWR sky130_fd_sc_hd__fill_1
XFILLER_50_527 VGND VGND VPWR VPWR sky130_fd_sc_hd__decap_4
XFILLER_16_793 VPWR VGND VPWR VGND sky130_ef_sc_hd__decap_12
XFILLER_22_218 VGND VGND VPWR VPWR sky130_fd_sc_hd__decap_8
XFILLER_148_404 VGND VGND VPWR VPWR sky130_fd_sc_hd__decap_4
XFILLER_15_281 VGND VGND VPWR VPWR sky130_fd_sc_hd__decap_3
XFILLER_31_741 VPWR VGND VPWR VGND sky130_ef_sc_hd__decap_12
XFILLER_148_437 VPWR VGND VPWR VGND sky130_ef_sc_hd__decap_12
XFILLER_148_426 VGND VGND VPWR VPWR sky130_fd_sc_hd__decap_6
XTAP_TAPCELL_ROW_135_2503 VGND VPWR sky130_fd_sc_hd__tapvpwrvgnd_1
XFILLER_31_785 VPWR VGND VPWR VGND sky130_ef_sc_hd__decap_12
XFILLER_129_673 VGND VGND VPWR VPWR sky130_fd_sc_hd__fill_1
Xhold403 u_interface.fifo_data\[6\]\[16\] VGND VGND VPWR VPWR net1268 sky130_fd_sc_hd__dlygate4sd3_1
Xhold414 u_interface.fifo_data\[1\]\[26\] VGND VGND VPWR VPWR net1279 sky130_fd_sc_hd__dlygate4sd3_1
XFILLER_128_194 VGND VGND VPWR VPWR sky130_fd_sc_hd__fill_2
Xhold425 u_interface.fifo_data\[2\]\[25\] VGND VGND VPWR VPWR net1290 sky130_fd_sc_hd__dlygate4sd3_1
Xhold436 u_interface.fifo_data\[0\]\[3\] VGND VGND VPWR VPWR net1301 sky130_fd_sc_hd__dlygate4sd3_1
XFILLER_7_491 VPWR VGND VPWR VGND sky130_ef_sc_hd__decap_12
Xhold469 _01011_ VGND VGND VPWR VPWR net1334 sky130_fd_sc_hd__dlygate4sd3_1
Xhold447 u_interface.u_gelu_fp32.u_fp32_to_q16.s2_sign VGND VGND VPWR VPWR net1312
+ sky130_fd_sc_hd__dlygate4sd3_1
XFILLER_104_518 VPWR VGND VPWR VGND sky130_ef_sc_hd__decap_12
X_09941_ net465 net469 net656 net662 VGND VGND VPWR VPWR _03694_ sky130_fd_sc_hd__nand4_1
Xhold458 u_interface.fifo_data\[14\]\[4\] VGND VGND VPWR VPWR net1323 sky130_fd_sc_hd__dlygate4sd3_1
XFILLER_131_337 VGND VGND VPWR VPWR sky130_fd_sc_hd__decap_6
Xmax_cap188 _04367_ VGND VGND VPWR VPWR net188 sky130_fd_sc_hd__clkbuf_1
X_09872_ _03624_ _03625_ _03479_ _03481_ VGND VGND VPWR VPWR _03626_ sky130_fd_sc_hd__o211a_1
XFILLER_97_251 VGND VGND VPWR VPWR sky130_fd_sc_hd__fill_1
XTAP_TAPCELL_ROW_5_417 VGND VPWR sky130_fd_sc_hd__tapvpwrvgnd_1
X_08823_ _02467_ _02581_ VGND VGND VPWR VPWR _02582_ sky130_fd_sc_hd__nor2_1
XTAP_TAPCELL_ROW_51_1159 VGND VPWR sky130_fd_sc_hd__tapvpwrvgnd_1
XTAP_TAPCELL_ROW_51_1148 VGND VPWR sky130_fd_sc_hd__tapvpwrvgnd_1
XFILLER_38_29 VGND VGND VPWR VPWR sky130_fd_sc_hd__decap_8
XTAP_TAPCELL_ROW_146_2676 VGND VPWR sky130_fd_sc_hd__tapvpwrvgnd_1
XTAP_TAPCELL_ROW_146_2665 VGND VPWR sky130_fd_sc_hd__tapvpwrvgnd_1
X_08754_ _02510_ _02511_ _02512_ VGND VGND VPWR VPWR _02513_ sky130_fd_sc_hd__or3_1
XFILLER_100_768 VGND VGND VPWR VPWR sky130_fd_sc_hd__fill_1
X_07705_ u_interface.u_gelu_fp32.u_synth_top.s1_hits\[13\] net386 _01186_ VGND VGND
+ VPWR VPWR _01766_ sky130_fd_sc_hd__or3_1
X_08685_ net670 net502 net679 net508 VGND VGND VPWR VPWR _02444_ sky130_fd_sc_hd__a22o_1
XFILLER_54_844 VGND VGND VPWR VPWR sky130_fd_sc_hd__fill_2
X_07636_ _01724_ _01708_ net331 VGND VGND VPWR VPWR _01725_ sky130_fd_sc_hd__mux2_1
XFILLER_41_505 VGND VGND VPWR VPWR sky130_fd_sc_hd__decap_4
X_07567_ _01678_ _01679_ net309 VGND VGND VPWR VPWR _01680_ sky130_fd_sc_hd__mux2_1
XTAP_TAPCELL_ROW_66_1391 VGND VPWR sky130_fd_sc_hd__tapvpwrvgnd_1
XTAP_TAPCELL_ROW_24_714 VGND VPWR sky130_fd_sc_hd__tapvpwrvgnd_1
XTAP_TAPCELL_ROW_24_725 VGND VPWR sky130_fd_sc_hd__tapvpwrvgnd_1
X_09306_ _03031_ _03064_ VGND VGND VPWR VPWR _03065_ sky130_fd_sc_hd__and2_1
X_06518_ u_interface.fifo_count\[2\] u_interface.in_flight_count\[2\] u_interface.in_flight_count\[1\]
+ u_interface.fifo_count\[1\] _01117_ VGND VGND VPWR VPWR _01118_ sky130_fd_sc_hd__o221a_1
X_09237_ _02953_ _02962_ _02991_ _02993_ VGND VGND VPWR VPWR _02996_ sky130_fd_sc_hd__o211ai_1
X_07498_ _01629_ VGND VGND VPWR VPWR _01630_ sky130_fd_sc_hd__inv_2
XFILLER_70_27 VGND VGND VPWR VPWR sky130_fd_sc_hd__fill_1
X_09168_ _02886_ _02888_ _02887_ VGND VGND VPWR VPWR _02927_ sky130_fd_sc_hd__o21ai_1
X_09099_ _02854_ _02855_ _02856_ VGND VGND VPWR VPWR _02858_ sky130_fd_sc_hd__or3b_1
XFILLER_135_654 VGND VGND VPWR VPWR sky130_fd_sc_hd__fill_2
X_08119_ net168 _01964_ net163 VGND VGND VPWR VPWR _01965_ sky130_fd_sc_hd__a21oi_1
XFILLER_135_698 VGND VGND VPWR VPWR sky130_fd_sc_hd__fill_1
XFILLER_107_389 VGND VGND VPWR VPWR sky130_fd_sc_hd__decap_3
XFILLER_79_47 VGND VGND VPWR VPWR sky130_fd_sc_hd__decap_8
X_11130_ _04870_ _04871_ VGND VGND VPWR VPWR _04873_ sky130_fd_sc_hd__xnor2_1
XFILLER_134_197 VGND VGND VPWR VPWR sky130_fd_sc_hd__decap_4
XFILLER_122_348 VGND VGND VPWR VPWR sky130_fd_sc_hd__decap_3
XFILLER_122_359 VGND VGND VPWR VPWR sky130_fd_sc_hd__decap_4
X_11061_ _04686_ _04687_ VGND VGND VPWR VPWR _04804_ sky130_fd_sc_hd__or2_1
XFILLER_135_86 VGND VGND VPWR VPWR sky130_fd_sc_hd__decap_8
XFILLER_131_882 VGND VGND VPWR VPWR sky130_fd_sc_hd__decap_4
XTAP_TAPCELL_ROW_110_2090 VGND VPWR sky130_fd_sc_hd__tapvpwrvgnd_1
XFILLER_95_57 VGND VGND VPWR VPWR sky130_fd_sc_hd__fill_2
X_10012_ net486 net491 net713 net723 VGND VGND VPWR VPWR _03764_ sky130_fd_sc_hd__nand4_1
XPHY_EDGE_ROW_48_Left_204 VGND VGND VPWR VPWR sky130_fd_sc_hd__decap_3
XFILLER_151_30 VPWR VGND VPWR VGND sky130_ef_sc_hd__decap_12
XTAP_TAPCELL_ROW_86_1712 VGND VPWR sky130_fd_sc_hd__tapvpwrvgnd_1
XFILLER_57_682 VGND VGND VPWR VPWR sky130_fd_sc_hd__fill_2
XFILLER_17_513 VGND VGND VPWR VPWR sky130_fd_sc_hd__decap_8
XFILLER_91_449 VPWR VGND VPWR VGND sky130_ef_sc_hd__decap_12
Xclkbuf_leaf_83_clk clknet_3_4__leaf_clk VGND VGND VPWR VPWR clknet_leaf_83_clk sky130_fd_sc_hd__clkbuf_8
X_11963_ _05677_ _05696_ VGND VGND VPWR VPWR _05697_ sky130_fd_sc_hd__xnor2_1
X_13702_ clknet_leaf_19_clk _00712_ VGND VGND VPWR VPWR u_interface.u_gelu_fp32.s1_data\[2\]
+ sky130_fd_sc_hd__dfxtp_1
XFILLER_71_151 VGND VGND VPWR VPWR sky130_fd_sc_hd__decap_8
X_10914_ _04657_ _04658_ _04458_ _04460_ VGND VGND VPWR VPWR _04659_ sky130_fd_sc_hd__o211a_1
XFILLER_32_505 VPWR VGND VPWR VGND sky130_ef_sc_hd__decap_12
X_11894_ _05570_ _05628_ VGND VGND VPWR VPWR _05629_ sky130_fd_sc_hd__xor2_1
X_13633_ clknet_leaf_36_clk _00643_ VGND VGND VPWR VPWR u_interface.fifo_data\[13\]\[16\]
+ sky130_fd_sc_hd__dfxtp_1
XFILLER_72_685 VGND VGND VPWR VPWR sky130_fd_sc_hd__fill_1
X_10845_ _04588_ _04589_ _04577_ VGND VGND VPWR VPWR _04590_ sky130_fd_sc_hd__a21oi_1
XFILLER_13_741 VPWR VGND VPWR VGND sky130_ef_sc_hd__decap_12
XTAP_TAPCELL_ROW_117_2200 VGND VPWR sky130_fd_sc_hd__tapvpwrvgnd_1
X_13564_ clknet_leaf_52_clk _00574_ VGND VGND VPWR VPWR u_interface.fifo_data\[4\]\[11\]
+ sky130_fd_sc_hd__dfxtp_1
X_10776_ net626 net422 _04520_ _04521_ VGND VGND VPWR VPWR _04522_ sky130_fd_sc_hd__a22o_1
XFILLER_12_251 VGND VGND VPWR VPWR sky130_fd_sc_hd__fill_1
XFILLER_13_785 VPWR VGND VPWR VGND sky130_ef_sc_hd__decap_12
XTAP_TAPCELL_ROW_117_2211 VGND VPWR sky130_fd_sc_hd__tapvpwrvgnd_1
X_13495_ clknet_leaf_4_clk _00505_ VGND VGND VPWR VPWR u_interface.u_gelu_fp32.u_synth_top.s2_m\[16\]
+ sky130_fd_sc_hd__dfxtp_1
XPHY_EDGE_ROW_57_Left_213 VGND VGND VPWR VPWR sky130_fd_sc_hd__decap_3
XFILLER_12_273 VGND VGND VPWR VPWR sky130_fd_sc_hd__fill_1
X_12515_ _06222_ _06239_ VGND VGND VPWR VPWR _06240_ sky130_fd_sc_hd__xnor2_1
XFILLER_60_60 VGND VGND VPWR VPWR sky130_fd_sc_hd__fill_1
X_12446_ _06060_ _06061_ _06121_ VGND VGND VPWR VPWR _06173_ sky130_fd_sc_hd__or3_1
XTAP_TAPCELL_ROW_130_2411 VGND VPWR sky130_fd_sc_hd__tapvpwrvgnd_1
XTAP_TAPCELL_ROW_97_1885 VGND VPWR sky130_fd_sc_hd__tapvpwrvgnd_1
X_12377_ _06077_ _06104_ VGND VGND VPWR VPWR _06105_ sky130_fd_sc_hd__xnor2_1
XFILLER_153_473 VPWR VGND VPWR VGND sky130_ef_sc_hd__decap_12
XTAP_TAPCELL_ROW_130_2422 VGND VPWR sky130_fd_sc_hd__tapvpwrvgnd_1
X_14116_ clknet_leaf_27_clk _01042_ VGND VGND VPWR VPWR u_interface.meta_tlast_pipe\[9\]
+ sky130_fd_sc_hd__dfxtp_1
X_11328_ _05067_ _05068_ VGND VGND VPWR VPWR _05069_ sky130_fd_sc_hd__and2b_1
XTAP_TAPCELL_ROW_10_496 VGND VPWR sky130_fd_sc_hd__tapvpwrvgnd_1
XFILLER_5_55 VGND VGND VPWR VPWR sky130_fd_sc_hd__fill_1
XFILLER_125_175 VGND VGND VPWR VPWR sky130_fd_sc_hd__fill_1
X_14047_ clknet_leaf_17_clk _00973_ VGND VGND VPWR VPWR u_interface.u_gelu_fp32.u_fp32_to_q16.s1_mant\[9\]
+ sky130_fd_sc_hd__dfxtp_1
X_11259_ _04850_ _04884_ _04883_ VGND VGND VPWR VPWR _05001_ sky130_fd_sc_hd__a21oi_2
XFILLER_122_893 VGND VGND VPWR VPWR sky130_fd_sc_hd__decap_3
XFILLER_95_711 VGND VGND VPWR VPWR sky130_fd_sc_hd__decap_4
XFILLER_67_424 VGND VGND VPWR VPWR sky130_fd_sc_hd__decap_8
XPHY_EDGE_ROW_66_Left_222 VGND VGND VPWR VPWR sky130_fd_sc_hd__decap_3
XFILLER_121_381 VGND VGND VPWR VPWR sky130_fd_sc_hd__decap_8
XFILLER_10_3 VPWR VGND VPWR VGND sky130_ef_sc_hd__decap_12
XTAP_TAPCELL_ROW_128_2384 VGND VPWR sky130_fd_sc_hd__tapvpwrvgnd_1
XFILLER_54_107 VGND VGND VPWR VPWR sky130_fd_sc_hd__decap_3
XFILLER_36_811 VGND VGND VPWR VPWR sky130_fd_sc_hd__fill_1
XFILLER_36_833 VPWR VGND VPWR VGND sky130_ef_sc_hd__decap_12
Xclkbuf_leaf_74_clk clknet_3_5__leaf_clk VGND VGND VPWR VPWR clknet_leaf_74_clk sky130_fd_sc_hd__clkbuf_8
XFILLER_51_814 VGND VGND VPWR VPWR sky130_fd_sc_hd__decap_6
X_08470_ _02259_ _02260_ VGND VGND VPWR VPWR _02261_ sky130_fd_sc_hd__nand2_1
XFILLER_23_505 VGND VGND VPWR VPWR sky130_fd_sc_hd__decap_8
XFILLER_35_343 VPWR VGND VPWR VGND sky130_ef_sc_hd__decap_12
X_07421_ _01555_ _01556_ net557 VGND VGND VPWR VPWR _01557_ sky130_fd_sc_hd__mux2_1
XTAP_TAPCELL_ROW_141_2595 VGND VPWR sky130_fd_sc_hd__tapvpwrvgnd_1
XTAP_TAPCELL_ROW_141_2584 VGND VPWR sky130_fd_sc_hd__tapvpwrvgnd_1
X_07352_ net350 net1593 net244 VGND VGND VPWR VPWR _00382_ sky130_fd_sc_hd__mux2_1
XPHY_EDGE_ROW_75_Left_231 VGND VGND VPWR VPWR sky130_fd_sc_hd__decap_3
XFILLER_148_201 VGND VGND VPWR VPWR sky130_fd_sc_hd__fill_1
X_07283_ net1266 net361 net246 VGND VGND VPWR VPWR _00313_ sky130_fd_sc_hd__mux2_1
X_09022_ _02733_ _02767_ _02780_ VGND VGND VPWR VPWR _02781_ sky130_fd_sc_hd__nor3_2
XFILLER_117_643 VGND VGND VPWR VPWR sky130_fd_sc_hd__decap_3
Xhold200 u_interface.fifo_data\[2\]\[23\] VGND VGND VPWR VPWR net1065 sky130_fd_sc_hd__dlygate4sd3_1
Xhold211 u_interface.fifo_data\[9\]\[11\] VGND VGND VPWR VPWR net1076 sky130_fd_sc_hd__dlygate4sd3_1
XFILLER_116_164 VGND VGND VPWR VPWR sky130_fd_sc_hd__decap_6
XFILLER_116_153 VGND VGND VPWR VPWR sky130_fd_sc_hd__decap_4
Xhold244 u_interface.fifo_data\[5\]\[12\] VGND VGND VPWR VPWR net1109 sky130_fd_sc_hd__dlygate4sd3_1
Xhold233 u_interface.fifo_data\[5\]\[0\] VGND VGND VPWR VPWR net1098 sky130_fd_sc_hd__dlygate4sd3_1
Xhold222 u_interface.fifo_data\[15\]\[8\] VGND VGND VPWR VPWR net1087 sky130_fd_sc_hd__dlygate4sd3_1
Xhold266 u_interface.fifo_data\[14\]\[13\] VGND VGND VPWR VPWR net1131 sky130_fd_sc_hd__dlygate4sd3_1
XFILLER_116_197 VGND VGND VPWR VPWR sky130_fd_sc_hd__decap_3
XFILLER_116_186 VGND VGND VPWR VPWR sky130_fd_sc_hd__fill_2
Xhold255 u_interface.fifo_data\[2\]\[8\] VGND VGND VPWR VPWR net1120 sky130_fd_sc_hd__dlygate4sd3_1
Xhold277 u_interface.fifo_data\[2\]\[21\] VGND VGND VPWR VPWR net1142 sky130_fd_sc_hd__dlygate4sd3_1
XTAP_TAPCELL_ROW_148_2705 VGND VPWR sky130_fd_sc_hd__tapvpwrvgnd_1
Xfanout724 u_interface.u_gelu_fp32.u_synth_top.s2_m\[17\] VGND VGND VPWR VPWR net724
+ sky130_fd_sc_hd__buf_2
Xhold288 u_interface.fifo_data\[13\]\[4\] VGND VGND VPWR VPWR net1153 sky130_fd_sc_hd__dlygate4sd3_1
Xfanout713 net716 VGND VGND VPWR VPWR net713 sky130_fd_sc_hd__buf_2
X_09924_ net588 net432 net428 net580 VGND VGND VPWR VPWR _03677_ sky130_fd_sc_hd__a22o_1
XPHY_EDGE_ROW_84_Left_240 VGND VGND VPWR VPWR sky130_fd_sc_hd__decap_3
XFILLER_49_39 VPWR VGND VPWR VGND sky130_ef_sc_hd__decap_12
Xfanout702 net708 VGND VGND VPWR VPWR net702 sky130_fd_sc_hd__buf_2
Xhold299 u_interface.fifo_data\[8\]\[3\] VGND VGND VPWR VPWR net1164 sky130_fd_sc_hd__dlygate4sd3_1
Xfanout735 net737 VGND VGND VPWR VPWR net735 sky130_fd_sc_hd__clkbuf_4
XFILLER_131_167 VGND VGND VPWR VPWR sky130_fd_sc_hd__fill_1
Xfanout746 net754 VGND VGND VPWR VPWR net746 sky130_fd_sc_hd__clkbuf_4
X_09855_ _03594_ _03606_ _03607_ VGND VGND VPWR VPWR _03609_ sky130_fd_sc_hd__or3_1
Xfanout757 net759 VGND VGND VPWR VPWR net757 sky130_fd_sc_hd__buf_4
XFILLER_58_413 VGND VGND VPWR VPWR sky130_fd_sc_hd__decap_6
Xfanout779 net780 VGND VGND VPWR VPWR net779 sky130_fd_sc_hd__buf_2
Xfanout768 net771 VGND VGND VPWR VPWR net768 sky130_fd_sc_hd__clkbuf_4
X_08806_ _02510_ _02512_ _02511_ VGND VGND VPWR VPWR _02565_ sky130_fd_sc_hd__o21ai_1
XFILLER_86_755 VGND VGND VPWR VPWR sky130_fd_sc_hd__fill_1
XFILLER_58_457 VGND VGND VPWR VPWR sky130_fd_sc_hd__decap_4
X_06998_ net326 net1572 net243 VGND VGND VPWR VPWR _00048_ sky130_fd_sc_hd__mux2_1
XFILLER_100_587 VGND VGND VPWR VPWR sky130_fd_sc_hd__fill_1
X_09786_ _03171_ _03539_ VGND VGND VPWR VPWR _03540_ sky130_fd_sc_hd__xnor2_1
XFILLER_73_405 VGND VGND VPWR VPWR sky130_fd_sc_hd__decap_4
XFILLER_65_27 VGND VGND VPWR VPWR sky130_fd_sc_hd__decap_8
XTAP_TAPCELL_ROW_29_806 VGND VPWR sky130_fd_sc_hd__tapvpwrvgnd_1
XFILLER_39_671 VGND VGND VPWR VPWR sky130_fd_sc_hd__fill_1
XPHY_EDGE_ROW_134_Right_134 VGND VGND VPWR VPWR sky130_fd_sc_hd__decap_3
X_08737_ net654 net497 _02493_ _02494_ VGND VGND VPWR VPWR _02496_ sky130_fd_sc_hd__nand4_2
Xclkbuf_leaf_65_clk clknet_3_5__leaf_clk VGND VGND VPWR VPWR clknet_leaf_65_clk sky130_fd_sc_hd__clkbuf_8
XFILLER_73_449 VPWR VGND VPWR VGND sky130_ef_sc_hd__decap_12
XTAP_TAPCELL_ROW_68_1431 VGND VPWR sky130_fd_sc_hd__tapvpwrvgnd_1
XTAP_TAPCELL_ROW_68_1420 VGND VPWR sky130_fd_sc_hd__tapvpwrvgnd_1
XFILLER_26_321 VPWR VGND VPWR VGND sky130_ef_sc_hd__decap_12
XFILLER_27_833 VGND VGND VPWR VPWR sky130_fd_sc_hd__decap_6
XFILLER_39_682 VGND VGND VPWR VPWR sky130_fd_sc_hd__fill_2
XFILLER_39_693 VGND VGND VPWR VPWR sky130_fd_sc_hd__decap_4
XFILLER_53_140 VPWR VGND VPWR VGND sky130_ef_sc_hd__decap_12
XFILLER_27_877 VPWR VGND VPWR VGND sky130_ef_sc_hd__decap_12
X_08668_ _02279_ _02333_ VGND VGND VPWR VPWR _02431_ sky130_fd_sc_hd__xnor2_1
X_07619_ u_interface.u_gelu_fp32.u_q16_to_fp32.s2_mag\[4\] u_interface.u_gelu_fp32.u_q16_to_fp32.s2_mag\[3\]
+ net339 VGND VGND VPWR VPWR _01711_ sky130_fd_sc_hd__mux2_1
XFILLER_81_15 VPWR VGND VPWR VGND sky130_ef_sc_hd__decap_12
X_08599_ _02379_ _02380_ net158 VGND VGND VPWR VPWR _02381_ sky130_fd_sc_hd__o21ai_1
XTAP_TAPCELL_ROW_81_1631 VGND VPWR sky130_fd_sc_hd__tapvpwrvgnd_1
XFILLER_81_48 VGND VGND VPWR VPWR sky130_fd_sc_hd__fill_1
X_10630_ _04375_ _04376_ VGND VGND VPWR VPWR _04377_ sky130_fd_sc_hd__and2b_1
XFILLER_14_53 VPWR VGND VPWR VGND sky130_ef_sc_hd__decap_12
XFILLER_41_379 VPWR VGND VPWR VGND sky130_ef_sc_hd__decap_12
X_10561_ _04307_ _04308_ VGND VGND VPWR VPWR _04309_ sky130_fd_sc_hd__or2_1
XFILLER_155_727 VGND VGND VPWR VPWR sky130_fd_sc_hd__fill_1
X_13280_ clknet_leaf_35_clk _00290_ VGND VGND VPWR VPWR u_interface.fifo_data\[0\]\[22\]
+ sky130_fd_sc_hd__dfxtp_1
X_10492_ net652 net449 _04156_ _04155_ VGND VGND VPWR VPWR _04240_ sky130_fd_sc_hd__a31o_1
XFILLER_10_755 VGND VGND VPWR VPWR sky130_fd_sc_hd__fill_1
X_12300_ _05958_ _06028_ VGND VGND VPWR VPWR _06029_ sky130_fd_sc_hd__xnor2_1
XFILLER_14_97 VPWR VGND VPWR VGND sky130_ef_sc_hd__decap_12
XFILLER_6_737 VPWR VGND VPWR VGND sky130_ef_sc_hd__decap_12
X_12231_ net702 net390 _05959_ VGND VGND VPWR VPWR _05961_ sky130_fd_sc_hd__and3_1
XFILLER_5_225 VPWR VGND VPWR VGND sky130_ef_sc_hd__decap_12
XFILLER_30_41 VPWR VGND VPWR VGND sky130_ef_sc_hd__decap_12
XFILLER_146_41 VPWR VGND VPWR VGND sky130_ef_sc_hd__decap_12
XTAP_TAPCELL_ROW_112_2130 VGND VPWR sky130_fd_sc_hd__tapvpwrvgnd_1
XTAP_TAPCELL_ROW_79_1593 VGND VPWR sky130_fd_sc_hd__tapvpwrvgnd_1
XFILLER_150_421 VPWR VGND VPWR VGND sky130_ef_sc_hd__decap_12
X_12162_ net701 net396 VGND VGND VPWR VPWR _05893_ sky130_fd_sc_hd__nand2_1
XFILLER_30_85 VPWR VGND VPWR VGND sky130_ef_sc_hd__decap_12
XFILLER_146_85 VGND VGND VPWR VPWR sky130_fd_sc_hd__decap_4
X_11113_ _04854_ _04855_ VGND VGND VPWR VPWR _04856_ sky130_fd_sc_hd__and2b_1
X_12093_ _05823_ _05824_ VGND VGND VPWR VPWR _05825_ sky130_fd_sc_hd__nor2_1
XFILLER_110_307 VGND VGND VPWR VPWR sky130_fd_sc_hd__fill_1
XFILLER_103_370 VPWR VGND VPWR VGND sky130_ef_sc_hd__decap_12
X_11044_ _04673_ _04787_ VGND VGND VPWR VPWR _04788_ sky130_fd_sc_hd__nor2_1
XFILLER_49_435 VPWR VGND VPWR VGND sky130_ef_sc_hd__decap_12
XFILLER_1_497 VGND VGND VPWR VPWR sky130_fd_sc_hd__decap_6
XFILLER_18_811 VGND VGND VPWR VPWR sky130_fd_sc_hd__fill_1
XFILLER_39_94 VGND VGND VPWR VPWR sky130_fd_sc_hd__decap_8
XPHY_EDGE_ROW_101_Right_101 VGND VGND VPWR VPWR sky130_fd_sc_hd__decap_3
Xclkbuf_leaf_56_clk clknet_3_1__leaf_clk VGND VGND VPWR VPWR clknet_leaf_56_clk sky130_fd_sc_hd__clkbuf_8
X_12995_ net1115 net360 net221 VGND VGND VPWR VPWR _01078_ sky130_fd_sc_hd__mux2_1
XFILLER_91_279 VGND VGND VPWR VPWR sky130_fd_sc_hd__fill_1
X_11946_ _05678_ _05679_ VGND VGND VPWR VPWR _05680_ sky130_fd_sc_hd__nor2_1
XFILLER_60_611 VGND VGND VPWR VPWR sky130_fd_sc_hd__fill_1
X_11877_ _05610_ _05611_ VGND VGND VPWR VPWR _05612_ sky130_fd_sc_hd__nand2_1
X_10828_ net464 net468 net722 VGND VGND VPWR VPWR _04573_ sky130_fd_sc_hd__and3_1
X_13616_ clknet_leaf_76_clk _00626_ VGND VGND VPWR VPWR u_interface.fifo_data\[3\]\[31\]
+ sky130_fd_sc_hd__dfxtp_1
XTAP_TAPCELL_ROW_15_577 VGND VPWR sky130_fd_sc_hd__tapvpwrvgnd_1
XFILLER_20_519 VPWR VGND VPWR VGND sky130_ef_sc_hd__decap_12
X_13547_ clknet_leaf_40_clk _00557_ VGND VGND VPWR VPWR u_interface.fifo_data\[5\]\[26\]
+ sky130_fd_sc_hd__dfxtp_1
XTAP_TAPCELL_ROW_99_1925 VGND VPWR sky130_fd_sc_hd__tapvpwrvgnd_1
XTAP_TAPCELL_ROW_99_1914 VGND VPWR sky130_fd_sc_hd__tapvpwrvgnd_1
X_10759_ _04496_ _04502_ _04503_ VGND VGND VPWR VPWR _04505_ sky130_fd_sc_hd__nand3_1
XFILLER_9_553 VGND VGND VPWR VPWR sky130_fd_sc_hd__decap_6
XFILLER_146_738 VGND VGND VPWR VPWR sky130_fd_sc_hd__fill_2
X_13478_ clknet_leaf_4_clk _00488_ VGND VGND VPWR VPWR u_interface.u_gelu_fp32.u_synth_top.s2_b\[15\]
+ sky130_fd_sc_hd__dfxtp_1
XFILLER_9_597 VPWR VGND VPWR VGND sky130_ef_sc_hd__decap_12
XFILLER_58_3 VPWR VGND VPWR VGND sky130_ef_sc_hd__decap_12
X_12429_ _06153_ _06154_ VGND VGND VPWR VPWR _06156_ sky130_fd_sc_hd__or2_1
XFILLER_153_281 VPWR VGND VPWR VGND sky130_ef_sc_hd__decap_12
XFILLER_153_270 VGND VGND VPWR VPWR sky130_fd_sc_hd__decap_8
XFILLER_126_473 VGND VGND VPWR VPWR sky130_fd_sc_hd__decap_3
XFILLER_114_613 VPWR VGND VPWR VGND sky130_ef_sc_hd__decap_12
XFILLER_99_335 VGND VGND VPWR VPWR sky130_fd_sc_hd__fill_1
X_07970_ net543 _01683_ net279 _01568_ VGND VGND VPWR VPWR _01847_ sky130_fd_sc_hd__a22o_1
XFILLER_113_145 VGND VGND VPWR VPWR sky130_fd_sc_hd__fill_1
XFILLER_99_357 VPWR VGND VPWR VGND sky130_ef_sc_hd__decap_12
X_06921_ u_interface.u_gelu_fp32.u_synth_top.s1_x\[20\] net274 _01455_ VGND VGND VPWR
+ VPWR _01458_ sky130_fd_sc_hd__a21o_1
XFILLER_68_766 VGND VGND VPWR VPWR sky130_fd_sc_hd__decap_3
XTAP_TAPCELL_ROW_143_2624 VGND VPWR sky130_fd_sc_hd__tapvpwrvgnd_1
X_09640_ _03394_ _03395_ _03257_ _03259_ VGND VGND VPWR VPWR _03396_ sky130_fd_sc_hd__o211a_1
X_06852_ _01394_ _01396_ _01399_ net317 VGND VGND VPWR VPWR net128 sky130_fd_sc_hd__a22o_1
XFILLER_55_405 VGND VGND VPWR VPWR sky130_fd_sc_hd__decap_6
X_06783_ net735 _01338_ VGND VGND VPWR VPWR _01339_ sky130_fd_sc_hd__or2_1
X_09571_ _03325_ _03326_ VGND VGND VPWR VPWR _03327_ sky130_fd_sc_hd__and2b_1
XFILLER_67_287 VGND VGND VPWR VPWR sky130_fd_sc_hd__fill_2
Xclkbuf_leaf_47_clk clknet_3_7__leaf_clk VGND VGND VPWR VPWR clknet_leaf_47_clk sky130_fd_sc_hd__clkbuf_8
X_08522_ u_interface.u_gelu_fp32.u_synth_top.s3_mult\[61\] u_interface.u_gelu_fp32.u_synth_top.s3_mult\[60\]
+ net524 VGND VGND VPWR VPWR _02313_ sky130_fd_sc_hd__o21ai_1
XFILLER_70_419 VGND VGND VPWR VPWR sky130_fd_sc_hd__fill_1
XFILLER_63_482 VGND VGND VPWR VPWR sky130_fd_sc_hd__decap_8
X_08453_ _02242_ _02243_ VGND VGND VPWR VPWR _02244_ sky130_fd_sc_hd__nand2_1
XFILLER_24_825 VPWR VGND VPWR VGND sky130_ef_sc_hd__decap_12
XFILLER_35_162 VGND VGND VPWR VPWR sky130_fd_sc_hd__fill_2
X_07404_ net311 _01540_ VGND VGND VPWR VPWR _01541_ sky130_fd_sc_hd__and2_1
XFILLER_63_493 VGND VGND VPWR VPWR sky130_fd_sc_hd__decap_8
XFILLER_23_357 VGND VGND VPWR VPWR sky130_fd_sc_hd__fill_2
XFILLER_24_869 VPWR VGND VPWR VGND sky130_ef_sc_hd__decap_12
XFILLER_35_184 VGND VGND VPWR VPWR sky130_fd_sc_hd__decap_4
XFILLER_35_195 VPWR VGND VPWR VGND sky130_ef_sc_hd__decap_12
XFILLER_149_510 VGND VGND VPWR VPWR sky130_fd_sc_hd__fill_1
XTAP_TAPCELL_ROW_63_1350 VGND VPWR sky130_fd_sc_hd__tapvpwrvgnd_1
X_08384_ u_interface.u_gelu_fp32.u_synth_top.s3_mult\[32\] u_interface.u_gelu_fp32.u_synth_top.s3_b\[16\]
+ VGND VGND VPWR VPWR _02175_ sky130_fd_sc_hd__or2_1
XFILLER_50_165 VGND VGND VPWR VPWR sky130_fd_sc_hd__decap_6
XTAP_TAPCELL_ROW_46_1069 VGND VPWR sky130_fd_sc_hd__tapvpwrvgnd_1
XTAP_TAPCELL_ROW_34_875 VGND VPWR sky130_fd_sc_hd__tapvpwrvgnd_1
XTAP_TAPCELL_ROW_34_886 VGND VPWR sky130_fd_sc_hd__tapvpwrvgnd_1
X_07335_ net384 net1573 net241 VGND VGND VPWR VPWR _00365_ sky130_fd_sc_hd__mux2_1
X_07266_ net1203 net563 net249 VGND VGND VPWR VPWR _00298_ sky130_fd_sc_hd__mux2_1
XFILLER_31_390 VGND VGND VPWR VPWR sky130_fd_sc_hd__fill_2
XTAP_TAPCELL_ROW_154_2797 VGND VPWR sky130_fd_sc_hd__tapvpwrvgnd_1
XFILLER_136_226 VPWR VGND VPWR VGND sky130_ef_sc_hd__decap_12
X_09005_ _02469_ _02471_ _02761_ _02762_ VGND VGND VPWR VPWR _02764_ sky130_fd_sc_hd__o211ai_2
X_07197_ net374 net1546 net258 VGND VGND VPWR VPWR _00237_ sky130_fd_sc_hd__mux2_1
Xgelu_top_860 VGND VGND VPWR VPWR gelu_top_860/HI s_axil_rdata[28] sky130_fd_sc_hd__conb_1
XFILLER_132_421 VGND VGND VPWR VPWR sky130_fd_sc_hd__decap_4
XFILLER_3_729 VPWR VGND VPWR VGND sky130_ef_sc_hd__decap_12
XFILLER_116_22 VGND VGND VPWR VPWR sky130_fd_sc_hd__fill_1
XFILLER_104_134 VGND VGND VPWR VPWR sky130_fd_sc_hd__decap_6
XFILLER_78_519 VPWR VGND VPWR VGND sky130_ef_sc_hd__decap_12
Xfanout510 u_interface.u_gelu_fp32.u_synth_top.s2_dx\[2\] VGND VGND VPWR VPWR net510
+ sky130_fd_sc_hd__clkbuf_4
XFILLER_132_498 VPWR VGND VPWR VGND sky130_ef_sc_hd__decap_12
XFILLER_76_15 VGND VGND VPWR VPWR sky130_fd_sc_hd__decap_6
Xfanout532 net533 VGND VGND VPWR VPWR net532 sky130_fd_sc_hd__buf_2
X_09907_ _03172_ _03658_ VGND VGND VPWR VPWR _03660_ sky130_fd_sc_hd__nor2_1
Xfanout521 net523 VGND VGND VPWR VPWR net521 sky130_fd_sc_hd__buf_2
Xfanout554 net556 VGND VGND VPWR VPWR net554 sky130_fd_sc_hd__buf_2
Xfanout543 u_interface.u_gelu_fp32.u_fp32_to_q16.s2_shift\[5\] VGND VGND VPWR VPWR
+ net543 sky130_fd_sc_hd__clkbuf_2
Xfanout565 u_interface.core_data_out\[29\] VGND VGND VPWR VPWR net565 sky130_fd_sc_hd__clkbuf_2
XFILLER_76_37 VPWR VGND VPWR VGND sky130_ef_sc_hd__decap_12
Xfanout598 net599 VGND VGND VPWR VPWR net598 sky130_fd_sc_hd__clkbuf_2
Xfanout576 u_interface.core_data_out\[24\] VGND VGND VPWR VPWR net576 sky130_fd_sc_hd__buf_1
XFILLER_100_340 VPWR VGND VPWR VGND sky130_ef_sc_hd__decap_12
X_09838_ _03587_ _03588_ _03589_ VGND VGND VPWR VPWR _03592_ sky130_fd_sc_hd__and3_1
Xfanout587 net588 VGND VGND VPWR VPWR net587 sky130_fd_sc_hd__dlymetal6s2s_1
XFILLER_59_777 VGND VGND VPWR VPWR sky130_fd_sc_hd__decap_6
XFILLER_58_265 VPWR VGND VPWR VGND sky130_ef_sc_hd__decap_12
XFILLER_46_416 VGND VGND VPWR VPWR sky130_fd_sc_hd__decap_4
X_09769_ _03126_ _03130_ _03222_ _03523_ _02817_ VGND VGND VPWR VPWR _03524_ sky130_fd_sc_hd__a2111o_1
XFILLER_74_736 VGND VGND VPWR VPWR sky130_fd_sc_hd__fill_2
Xclkbuf_leaf_38_clk clknet_3_7__leaf_clk VGND VGND VPWR VPWR clknet_leaf_38_clk sky130_fd_sc_hd__clkbuf_8
XFILLER_74_769 VGND VGND VPWR VPWR sky130_fd_sc_hd__fill_1
X_11800_ _05533_ _05534_ VGND VGND VPWR VPWR _05536_ sky130_fd_sc_hd__xor2_1
XFILLER_27_641 VPWR VGND VPWR VGND sky130_ef_sc_hd__decap_12
X_12780_ _01782_ net296 _06406_ VGND VGND VPWR VPWR _00950_ sky130_fd_sc_hd__and3b_1
XFILLER_61_419 VGND VGND VPWR VPWR sky130_fd_sc_hd__decap_8
XFILLER_54_471 VGND VGND VPWR VPWR sky130_fd_sc_hd__decap_4
XFILLER_27_685 VPWR VGND VPWR VGND sky130_ef_sc_hd__decap_12
X_11731_ _05404_ _05467_ VGND VGND VPWR VPWR _05468_ sky130_fd_sc_hd__xnor2_1
XFILLER_42_633 VGND VGND VPWR VPWR sky130_fd_sc_hd__decap_3
X_11662_ net772 _05399_ VGND VGND VPWR VPWR _00829_ sky130_fd_sc_hd__and2_1
XFILLER_14_357 VGND VGND VPWR VPWR sky130_fd_sc_hd__fill_1
XFILLER_41_143 VGND VGND VPWR VPWR sky130_fd_sc_hd__fill_1
XFILLER_42_699 VGND VGND VPWR VPWR sky130_fd_sc_hd__fill_1
X_13401_ clknet_leaf_43_clk _00411_ VGND VGND VPWR VPWR u_interface.fifo_data\[6\]\[14\]
+ sky130_fd_sc_hd__dfxtp_1
X_10613_ _04358_ _04359_ _04352_ VGND VGND VPWR VPWR _04360_ sky130_fd_sc_hd__a21o_1
XTAP_TAPCELL_ROW_12_525 VGND VPWR sky130_fd_sc_hd__tapvpwrvgnd_1
X_11593_ net704 net711 net429 net424 VGND VGND VPWR VPWR _05331_ sky130_fd_sc_hd__and4_1
X_10544_ _04151_ _04291_ VGND VGND VPWR VPWR _04292_ sky130_fd_sc_hd__or2_1
X_13332_ clknet_leaf_62_clk _00342_ VGND VGND VPWR VPWR u_interface.fifo_data\[10\]\[9\]
+ sky130_fd_sc_hd__dfxtp_1
XFILLER_6_501 VPWR VGND VPWR VGND sky130_ef_sc_hd__decap_12
XFILLER_127_237 VGND VGND VPWR VPWR sky130_fd_sc_hd__decap_6
XFILLER_6_545 VPWR VGND VPWR VGND sky130_ef_sc_hd__decap_12
XTAP_TAPCELL_ROW_94_1833 VGND VPWR sky130_fd_sc_hd__tapvpwrvgnd_1
X_10475_ _04135_ _04137_ VGND VGND VPWR VPWR _04223_ sky130_fd_sc_hd__or2_1
X_13263_ clknet_leaf_70_clk _00273_ VGND VGND VPWR VPWR u_interface.fifo_data\[0\]\[5\]
+ sky130_fd_sc_hd__dfxtp_1
XFILLER_135_281 VGND VGND VPWR VPWR sky130_fd_sc_hd__fill_1
XTAP_TAPCELL_ROW_94_1844 VGND VPWR sky130_fd_sc_hd__tapvpwrvgnd_1
X_13194_ clknet_leaf_48_clk _00204_ VGND VGND VPWR VPWR u_interface.fifo_data\[12\]\[4\]
+ sky130_fd_sc_hd__dfxtp_1
XFILLER_6_589 VPWR VGND VPWR VGND sky130_ef_sc_hd__decap_12
X_12214_ net200 _05943_ VGND VGND VPWR VPWR _05944_ sky130_fd_sc_hd__nor2_1
X_12145_ net198 _05874_ VGND VGND VPWR VPWR _05876_ sky130_fd_sc_hd__nor2_1
XFILLER_151_785 VGND VGND VPWR VPWR sky130_fd_sc_hd__decap_6
XFILLER_150_273 VPWR VGND VPWR VGND sky130_ef_sc_hd__decap_12
XFILLER_97_839 VGND VGND VPWR VPWR sky130_fd_sc_hd__fill_1
XFILLER_1_261 VPWR VGND VPWR VGND sky130_ef_sc_hd__decap_12
XFILLER_49_221 VGND VGND VPWR VPWR sky130_fd_sc_hd__decap_3
X_12076_ net198 _05807_ VGND VGND VPWR VPWR _05808_ sky130_fd_sc_hd__and2_1
X_11027_ _04740_ _04770_ VGND VGND VPWR VPWR _04771_ sky130_fd_sc_hd__xnor2_1
XFILLER_38_917 VGND VGND VPWR VPWR sky130_fd_sc_hd__decap_4
XTAP_TAPCELL_ROW_125_2343 VGND VPWR sky130_fd_sc_hd__tapvpwrvgnd_1
XTAP_TAPCELL_ROW_125_2332 VGND VPWR sky130_fd_sc_hd__tapvpwrvgnd_1
XFILLER_92_511 VGND VGND VPWR VPWR sky130_fd_sc_hd__fill_1
XFILLER_49_276 VGND VGND VPWR VPWR sky130_fd_sc_hd__decap_4
Xclkbuf_leaf_29_clk clknet_3_3__leaf_clk VGND VGND VPWR VPWR clknet_leaf_29_clk sky130_fd_sc_hd__clkbuf_8
XFILLER_65_769 VPWR VGND VPWR VGND sky130_ef_sc_hd__decap_12
X_12978_ _06489_ _06490_ _06467_ VGND VGND VPWR VPWR _06495_ sky130_fd_sc_hd__o21bai_1
XFILLER_52_419 VGND VGND VPWR VPWR sky130_fd_sc_hd__fill_1
X_11929_ net204 _05594_ _05598_ VGND VGND VPWR VPWR _05663_ sky130_fd_sc_hd__and3_1
XFILLER_32_121 VGND VGND VPWR VPWR sky130_fd_sc_hd__decap_4
XFILLER_60_463 VPWR VGND VPWR VGND sky130_ef_sc_hd__decap_12
XTAP_TAPCELL_ROW_103_1984 VGND VPWR sky130_fd_sc_hd__tapvpwrvgnd_1
XANTENNA_17 net388 VGND VGND VPWR VPWR sky130_fd_sc_hd__diode_2
XFILLER_21_839 VGND VGND VPWR VPWR sky130_fd_sc_hd__fill_1
XTAP_TAPCELL_ROW_31_834 VGND VPWR sky130_fd_sc_hd__tapvpwrvgnd_1
XFILLER_146_513 VGND VGND VPWR VPWR sky130_fd_sc_hd__decap_3
X_07120_ net324 net1444 net243 VGND VGND VPWR VPWR _00160_ sky130_fd_sc_hd__mux2_1
XFILLER_146_557 VGND VGND VPWR VPWR sky130_fd_sc_hd__fill_1
XFILLER_118_248 VGND VGND VPWR VPWR sky130_fd_sc_hd__decap_4
X_07051_ net1257 net380 net207 VGND VGND VPWR VPWR _00091_ sky130_fd_sc_hd__mux2_1
Xoutput113 net113 VGND VGND VPWR VPWR m_axis_tdata[13] sky130_fd_sc_hd__buf_2
XFILLER_114_421 VPWR VGND VPWR VGND sky130_ef_sc_hd__decap_12
Xoutput124 net124 VGND VGND VPWR VPWR m_axis_tdata[23] sky130_fd_sc_hd__buf_2
Xoutput146 net146 VGND VGND VPWR VPWR s_axil_bvalid sky130_fd_sc_hd__buf_2
XFILLER_142_741 VGND VGND VPWR VPWR sky130_fd_sc_hd__fill_1
Xoutput135 net135 VGND VGND VPWR VPWR m_axis_tdata[4] sky130_fd_sc_hd__buf_2
XFILLER_114_487 VGND VGND VPWR VPWR sky130_fd_sc_hd__fill_2
XFILLER_99_165 VGND VGND VPWR VPWR sky130_fd_sc_hd__decap_3
XFILLER_88_839 VGND VGND VPWR VPWR sky130_fd_sc_hd__decap_3
X_07953_ net788 net943 VGND VGND VPWR VPWR _00682_ sky130_fd_sc_hd__and2_1
X_07884_ net1140 net348 net266 VGND VGND VPWR VPWR _00645_ sky130_fd_sc_hd__mux2_1
X_06904_ _01443_ _01444_ VGND VGND VPWR VPWR _01445_ sky130_fd_sc_hd__nand2_1
XFILLER_29_917 VGND VGND VPWR VPWR sky130_fd_sc_hd__fill_1
X_09623_ _03376_ _03377_ VGND VGND VPWR VPWR _03379_ sky130_fd_sc_hd__xor2_1
X_06835_ _01383_ _01384_ net731 VGND VGND VPWR VPWR _01385_ sky130_fd_sc_hd__mux2_1
XFILLER_95_393 VPWR VGND VPWR VGND sky130_ef_sc_hd__decap_12
XFILLER_68_585 VGND VGND VPWR VPWR sky130_fd_sc_hd__decap_3
XFILLER_46_29 VGND VGND VPWR VPWR sky130_fd_sc_hd__decap_8
XFILLER_83_555 VGND VGND VPWR VPWR sky130_fd_sc_hd__decap_4
XFILLER_71_706 VGND VGND VPWR VPWR sky130_fd_sc_hd__fill_2
XFILLER_55_257 VGND VGND VPWR VPWR sky130_fd_sc_hd__fill_1
XTAP_TAPCELL_ROW_48_1109 VGND VPWR sky130_fd_sc_hd__tapvpwrvgnd_1
XTAP_TAPCELL_ROW_39_956 VGND VPWR sky130_fd_sc_hd__tapvpwrvgnd_1
XTAP_TAPCELL_ROW_39_967 VGND VPWR sky130_fd_sc_hd__tapvpwrvgnd_1
X_09554_ _03309_ _03310_ _03226_ VGND VGND VPWR VPWR _03311_ sky130_fd_sc_hd__a21oi_1
X_06766_ u_interface.fifo_data\[12\]\[17\] u_interface.fifo_data\[13\]\[17\] u_interface.fifo_data\[14\]\[17\]
+ u_interface.fifo_data\[15\]\[17\] net763 net746 VGND VGND VPWR VPWR _01324_ sky130_fd_sc_hd__mux4_1
XFILLER_102_46 VGND VGND VPWR VPWR sky130_fd_sc_hd__decap_4
X_09485_ _03173_ _03241_ VGND VGND VPWR VPWR _03242_ sky130_fd_sc_hd__nand2_1
X_06697_ u_interface.fifo_data\[0\]\[8\] u_interface.fifo_data\[1\]\[8\] u_interface.fifo_data\[2\]\[8\]
+ u_interface.fifo_data\[3\]\[8\] net757 net740 VGND VGND VPWR VPWR _01264_ sky130_fd_sc_hd__mux4_1
X_08505_ _02283_ _02288_ _02295_ _02169_ VGND VGND VPWR VPWR _02296_ sky130_fd_sc_hd__a211o_1
X_08436_ _02224_ _02226_ _02195_ VGND VGND VPWR VPWR _02227_ sky130_fd_sc_hd__o21a_1
XTAP_TAPCELL_ROW_61_1309 VGND VPWR sky130_fd_sc_hd__tapvpwrvgnd_1
X_08367_ net525 u_interface.u_gelu_fp32.u_synth_top.s3_mult\[57\] VGND VGND VPWR VPWR
+ _02158_ sky130_fd_sc_hd__xnor2_1
XFILLER_24_699 VGND VGND VPWR VPWR sky130_fd_sc_hd__fill_1
X_07318_ net1204 net354 net254 VGND VGND VPWR VPWR _00348_ sky130_fd_sc_hd__mux2_1
XFILLER_11_349 VGND VGND VPWR VPWR sky130_fd_sc_hd__decap_4
XFILLER_20_861 VGND VGND VPWR VPWR sky130_fd_sc_hd__decap_6
X_08298_ _02105_ _02106_ VGND VGND VPWR VPWR _00758_ sky130_fd_sc_hd__nor2_1
X_07249_ net1077 net358 net251 VGND VGND VPWR VPWR _00281_ sky130_fd_sc_hd__mux2_1
XPHY_EDGE_ROW_12_Left_168 VGND VGND VPWR VPWR sky130_fd_sc_hd__decap_3
X_10260_ _03893_ _03895_ _03894_ VGND VGND VPWR VPWR _04010_ sky130_fd_sc_hd__a21bo_1
XTAP_TAPCELL_ROW_76_1552 VGND VPWR sky130_fd_sc_hd__tapvpwrvgnd_1
XFILLER_3_559 VGND VGND VPWR VPWR sky130_fd_sc_hd__fill_1
XFILLER_133_785 VPWR VGND VPWR VGND sky130_ef_sc_hd__decap_12
XFILLER_133_774 VGND VGND VPWR VPWR sky130_fd_sc_hd__decap_8
X_10191_ _03940_ _03941_ VGND VGND VPWR VPWR _03942_ sky130_fd_sc_hd__nand2b_1
Xfanout340 u_interface.core_data_out\[22\] VGND VGND VPWR VPWR net340 sky130_fd_sc_hd__clkbuf_2
Xfanout351 u_interface.core_data_out\[17\] VGND VGND VPWR VPWR net351 sky130_fd_sc_hd__buf_1
Xfanout362 u_interface.core_data_out\[11\] VGND VGND VPWR VPWR net362 sky130_fd_sc_hd__clkbuf_2
X_13950_ clknet_leaf_55_clk _00876_ VGND VGND VPWR VPWR u_interface.u_gelu_fp32.u_q16_to_fp32.s2_exp\[2\]
+ sky130_fd_sc_hd__dfxtp_1
Xfanout384 u_interface.core_data_out\[0\] VGND VGND VPWR VPWR net384 sky130_fd_sc_hd__clkbuf_2
Xfanout373 u_interface.core_data_out\[6\] VGND VGND VPWR VPWR net373 sky130_fd_sc_hd__buf_1
X_12901_ net787 net923 VGND VGND VPWR VPWR _01043_ sky130_fd_sc_hd__and2_1
XFILLER_101_671 VGND VGND VPWR VPWR sky130_fd_sc_hd__fill_1
XFILLER_100_170 VGND VGND VPWR VPWR sky130_fd_sc_hd__decap_8
XFILLER_86_382 VGND VGND VPWR VPWR sky130_fd_sc_hd__fill_1
Xfanout395 net396 VGND VGND VPWR VPWR net395 sky130_fd_sc_hd__buf_2
XPHY_EDGE_ROW_21_Left_177 VGND VGND VPWR VPWR sky130_fd_sc_hd__decap_3
XTAP_TAPCELL_ROW_107_2051 VGND VPWR sky130_fd_sc_hd__tapvpwrvgnd_1
XTAP_TAPCELL_ROW_107_2040 VGND VPWR sky130_fd_sc_hd__tapvpwrvgnd_1
X_13881_ clknet_leaf_5_clk _00034_ VGND VGND VPWR VPWR u_interface.u_gelu_fp32.u_synth_top.s2_dx\[17\]
+ sky130_fd_sc_hd__dfxtp_1
XFILLER_35_909 VPWR VGND VPWR VGND sky130_ef_sc_hd__decap_12
X_12832_ u_interface.u_gelu_fp32.u_q16_to_fp32.s2_clz\[3\] net186 net781 VGND VGND
+ VPWR VPWR _00990_ sky130_fd_sc_hd__mux2_1
XFILLER_55_780 VGND VGND VPWR VPWR sky130_fd_sc_hd__decap_4
XTAP_TAPCELL_ROW_17_606 VGND VPWR sky130_fd_sc_hd__tapvpwrvgnd_1
X_12763_ u_interface.u_gelu_fp32.u_q16_to_fp32.s3_norm_mag\[10\] _01775_ net297 VGND
+ VGND VPWR VPWR _06398_ sky130_fd_sc_hd__o21ai_1
XFILLER_14_121 VPWR VGND VPWR VGND sky130_ef_sc_hd__decap_12
XFILLER_27_493 VGND VGND VPWR VPWR sky130_fd_sc_hd__fill_1
XTAP_TAPCELL_ROW_120_2262 VGND VPWR sky130_fd_sc_hd__tapvpwrvgnd_1
XTAP_TAPCELL_ROW_120_2251 VGND VPWR sky130_fd_sc_hd__tapvpwrvgnd_1
X_11714_ _05449_ _05450_ VGND VGND VPWR VPWR _05451_ sky130_fd_sc_hd__nand2_1
XFILLER_70_794 VGND VGND VPWR VPWR sky130_fd_sc_hd__decap_8
X_12694_ u_interface.u_gelu_fp32.u_q16_to_fp32.s2_mag\[19\] u_interface.u_gelu_fp32.u_q16_to_fp32.s2_mag\[18\]
+ u_interface.u_gelu_fp32.u_q16_to_fp32.s2_mag\[17\] u_interface.u_gelu_fp32.u_q16_to_fp32.s2_mag\[16\]
+ net337 net332 VGND VGND VPWR VPWR _06353_ sky130_fd_sc_hd__mux4_1
XFILLER_14_165 VGND VGND VPWR VPWR sky130_fd_sc_hd__decap_6
XFILLER_30_625 VPWR VGND VPWR VGND sky130_ef_sc_hd__decap_12
XFILLER_52_83 VGND VGND VPWR VPWR sky130_fd_sc_hd__fill_1
XFILLER_30_669 VPWR VGND VPWR VGND sky130_ef_sc_hd__decap_12
X_11645_ _05380_ _05381_ VGND VGND VPWR VPWR _05383_ sky130_fd_sc_hd__xnor2_1
Xinput26 s_axil_araddr[30] VGND VGND VPWR VPWR net26 sky130_fd_sc_hd__clkbuf_1
Xinput37 s_axil_awaddr[10] VGND VGND VPWR VPWR net37 sky130_fd_sc_hd__clkbuf_1
Xinput15 s_axil_araddr[20] VGND VGND VPWR VPWR net15 sky130_fd_sc_hd__clkbuf_1
X_11576_ net195 _05303_ _05302_ VGND VGND VPWR VPWR _05314_ sky130_fd_sc_hd__a21oi_1
XFILLER_10_371 VGND VGND VPWR VPWR sky130_fd_sc_hd__fill_1
XFILLER_7_821 VPWR VGND VPWR VGND sky130_ef_sc_hd__decap_12
XPHY_EDGE_ROW_30_Left_186 VGND VGND VPWR VPWR sky130_fd_sc_hd__decap_3
Xinput59 s_axil_awaddr[30] VGND VGND VPWR VPWR net59 sky130_fd_sc_hd__clkbuf_1
Xinput48 s_axil_awaddr[20] VGND VGND VPWR VPWR net48 sky130_fd_sc_hd__clkbuf_1
XFILLER_155_365 VGND VGND VPWR VPWR sky130_fd_sc_hd__fill_1
XFILLER_143_505 VGND VGND VPWR VPWR sky130_fd_sc_hd__decap_4
X_13315_ clknet_leaf_46_clk _00325_ VGND VGND VPWR VPWR u_interface.fifo_data\[8\]\[24\]
+ sky130_fd_sc_hd__dfxtp_1
X_10527_ _04149_ _04272_ _04273_ VGND VGND VPWR VPWR _04275_ sky130_fd_sc_hd__nand3_2
XFILLER_7_865 VPWR VGND VPWR VGND sky130_ef_sc_hd__decap_12
XFILLER_155_398 VGND VGND VPWR VPWR sky130_fd_sc_hd__decap_4
X_13246_ clknet_leaf_47_clk _00256_ VGND VGND VPWR VPWR u_interface.fifo_data\[11\]\[24\]
+ sky130_fd_sc_hd__dfxtp_1
X_10458_ _03999_ _04108_ _04109_ net715 VGND VGND VPWR VPWR _04206_ sky130_fd_sc_hd__a22o_1
XFILLER_6_375 VGND VGND VPWR VPWR sky130_fd_sc_hd__decap_3
XFILLER_108_281 VPWR VGND VPWR VGND sky130_ef_sc_hd__decap_12
X_13177_ clknet_leaf_42_clk _00187_ VGND VGND VPWR VPWR u_interface.fifo_data\[9\]\[19\]
+ sky130_fd_sc_hd__dfxtp_1
XFILLER_111_402 VGND VGND VPWR VPWR sky130_fd_sc_hd__fill_1
X_10389_ _04136_ _04137_ _04057_ VGND VGND VPWR VPWR _04138_ sky130_fd_sc_hd__o21ai_1
XFILLER_123_295 VGND VGND VPWR VPWR sky130_fd_sc_hd__fill_1
XFILLER_2_581 VGND VGND VPWR VPWR sky130_fd_sc_hd__decap_6
X_12128_ _05857_ _05858_ VGND VGND VPWR VPWR _05860_ sky130_fd_sc_hd__xor2_1
XFILLER_96_157 VGND VGND VPWR VPWR sky130_fd_sc_hd__decap_3
X_12059_ net193 _05717_ _05716_ VGND VGND VPWR VPWR _05792_ sky130_fd_sc_hd__a21oi_1
XFILLER_77_393 VGND VGND VPWR VPWR sky130_fd_sc_hd__decap_4
X_06620_ _01191_ _01193_ _01196_ net318 VGND VGND VPWR VPWR net142 sky130_fd_sc_hd__a22o_1
XFILLER_53_706 VGND VGND VPWR VPWR sky130_fd_sc_hd__decap_3
XFILLER_93_886 VGND VGND VPWR VPWR sky130_fd_sc_hd__fill_2
XTAP_TAPCELL_ROW_36_904 VGND VPWR sky130_fd_sc_hd__tapvpwrvgnd_1
XTAP_TAPCELL_ROW_36_915 VGND VPWR sky130_fd_sc_hd__tapvpwrvgnd_1
XFILLER_37_279 VGND VGND VPWR VPWR sky130_fd_sc_hd__fill_1
X_06551_ u_interface.u_gelu_fp32.s1_data\[14\] net287 _01146_ net537 VGND VGND VPWR
+ VPWR _01147_ sky130_fd_sc_hd__and4b_1
X_09270_ _02920_ _02921_ VGND VGND VPWR VPWR _03029_ sky130_fd_sc_hd__nor2_1
XFILLER_33_441 VGND VGND VPWR VPWR sky130_fd_sc_hd__fill_2
X_08221_ _02047_ _02049_ _02050_ VGND VGND VPWR VPWR _00737_ sky130_fd_sc_hd__a21boi_1
XTAP_TAPCELL_ROW_43_1028 VGND VPWR sky130_fd_sc_hd__tapvpwrvgnd_1
XTAP_TAPCELL_ROW_43_1017 VGND VPWR sky130_fd_sc_hd__tapvpwrvgnd_1
XTAP_TAPCELL_ROW_138_2545 VGND VPWR sky130_fd_sc_hd__tapvpwrvgnd_1
XFILLER_119_502 VGND VGND VPWR VPWR sky130_fd_sc_hd__fill_2
X_08152_ u_interface.u_gelu_fp32.u_fp32_to_q16.s3_mag\[17\] _01884_ VGND VGND VPWR
+ VPWR _01992_ sky130_fd_sc_hd__nor2_1
XFILLER_20_168 VPWR VGND VPWR VGND sky130_ef_sc_hd__decap_12
XTAP_TAPCELL_ROW_151_2745 VGND VPWR sky130_fd_sc_hd__tapvpwrvgnd_1
X_07103_ net1304 net340 net227 VGND VGND VPWR VPWR _00143_ sky130_fd_sc_hd__mux2_1
X_08083_ net169 _01934_ net163 VGND VGND VPWR VPWR _01935_ sky130_fd_sc_hd__a21oi_1
Xclkbuf_leaf_9_clk clknet_3_2__leaf_clk VGND VGND VPWR VPWR clknet_leaf_9_clk sky130_fd_sc_hd__clkbuf_8
XTAP_TAPCELL_ROW_151_2756 VGND VPWR sky130_fd_sc_hd__tapvpwrvgnd_1
X_07034_ net981 net351 net272 VGND VGND VPWR VPWR _00074_ sky130_fd_sc_hd__mux2_1
XFILLER_106_218 VGND VGND VPWR VPWR sky130_fd_sc_hd__fill_1
XTAP_TAPCELL_ROW_58_1271 VGND VPWR sky130_fd_sc_hd__tapvpwrvgnd_1
XTAP_TAPCELL_ROW_58_1260 VGND VPWR sky130_fd_sc_hd__tapvpwrvgnd_1
XFILLER_115_774 VGND VGND VPWR VPWR sky130_fd_sc_hd__fill_1
XFILLER_0_529 VGND VGND VPWR VPWR sky130_fd_sc_hd__decap_3
X_08985_ _02584_ _02586_ VGND VGND VPWR VPWR _02744_ sky130_fd_sc_hd__xnor2_1
XFILLER_130_755 VGND VGND VPWR VPWR sky130_fd_sc_hd__fill_1
XFILLER_114_273 VPWR VGND VPWR VGND sky130_ef_sc_hd__decap_12
XFILLER_87_113 VGND VGND VPWR VPWR sky130_fd_sc_hd__fill_1
X_07936_ net817 net557 _01825_ _01828_ VGND VGND VPWR VPWR _00674_ sky130_fd_sc_hd__a22o_1
XFILLER_102_468 VGND VGND VPWR VPWR sky130_fd_sc_hd__fill_1
XFILLER_75_319 VPWR VGND VPWR VGND sky130_ef_sc_hd__decap_12
XTAP_TAPCELL_ROW_71_1471 VGND VPWR sky130_fd_sc_hd__tapvpwrvgnd_1
XFILLER_57_39 VGND VGND VPWR VPWR sky130_fd_sc_hd__fill_1
XFILLER_56_511 VGND VGND VPWR VPWR sky130_fd_sc_hd__fill_2
X_07867_ net1010 net383 net268 VGND VGND VPWR VPWR _00628_ sky130_fd_sc_hd__mux2_1
XFILLER_56_533 VGND VGND VPWR VPWR sky130_fd_sc_hd__decap_8
XTAP_TAPCELL_ROW_3_378 VGND VPWR sky130_fd_sc_hd__tapvpwrvgnd_1
XFILLER_17_909 VPWR VGND VPWR VGND sky130_ef_sc_hd__decap_12
XFILLER_28_224 VGND VGND VPWR VPWR sky130_fd_sc_hd__fill_1
X_07798_ net1185 net567 net236 VGND VGND VPWR VPWR _00559_ sky130_fd_sc_hd__mux2_1
X_06818_ u_interface.fifo_data\[4\]\[23\] u_interface.fifo_data\[5\]\[23\] u_interface.fifo_data\[6\]\[23\]
+ u_interface.fifo_data\[7\]\[23\] net766 net749 VGND VGND VPWR VPWR _01370_ sky130_fd_sc_hd__mux4_1
XFILLER_113_89 VGND VGND VPWR VPWR sky130_fd_sc_hd__decap_4
X_09606_ _03328_ _03360_ _03361_ VGND VGND VPWR VPWR _03362_ sky130_fd_sc_hd__and3_1
XFILLER_73_27 VGND VGND VPWR VPWR sky130_fd_sc_hd__decap_8
XFILLER_71_503 VGND VGND VPWR VPWR sky130_fd_sc_hd__fill_1
XTAP_TAPCELL_ROW_3_389 VGND VPWR sky130_fd_sc_hd__tapvpwrvgnd_1
XFILLER_16_419 VGND VGND VPWR VPWR sky130_fd_sc_hd__fill_1
X_09537_ _03290_ _03291_ _03292_ VGND VGND VPWR VPWR _03294_ sky130_fd_sc_hd__a21o_1
X_06749_ u_interface.fifo_data\[8\]\[15\] u_interface.fifo_data\[9\]\[15\] u_interface.fifo_data\[10\]\[15\]
+ u_interface.fifo_data\[11\]\[15\] net762 net745 VGND VGND VPWR VPWR _01309_ sky130_fd_sc_hd__mux4_1
XFILLER_73_49 VGND VGND VPWR VPWR sky130_fd_sc_hd__decap_6
XFILLER_24_452 VGND VGND VPWR VPWR sky130_fd_sc_hd__decap_6
X_09468_ _02661_ _03185_ _03184_ VGND VGND VPWR VPWR _03225_ sky130_fd_sc_hd__o21ba_1
XFILLER_51_260 VGND VGND VPWR VPWR sky130_fd_sc_hd__fill_1
XFILLER_11_113 VPWR VGND VPWR VGND sky130_ef_sc_hd__decap_12
XFILLER_12_625 VPWR VGND VPWR VGND sky130_ef_sc_hd__decap_12
X_09399_ _03156_ _03155_ VGND VGND VPWR VPWR _03157_ sky130_fd_sc_hd__and2b_1
X_08419_ u_interface.u_gelu_fp32.u_synth_top.s3_mult\[18\] u_interface.u_gelu_fp32.u_synth_top.s3_b\[2\]
+ VGND VGND VPWR VPWR _02210_ sky130_fd_sc_hd__or2_1
XFILLER_12_669 VPWR VGND VPWR VGND sky130_ef_sc_hd__decap_12
XFILLER_137_321 VGND VGND VPWR VPWR sky130_fd_sc_hd__fill_1
XTAP_TAPCELL_ROW_22_686 VGND VPWR sky130_fd_sc_hd__tapvpwrvgnd_1
X_11430_ _05168_ _05169_ VGND VGND VPWR VPWR _05170_ sky130_fd_sc_hd__nor2_1
X_11361_ _05044_ _05101_ VGND VGND VPWR VPWR _05102_ sky130_fd_sc_hd__xor2_1
XFILLER_22_53 VPWR VGND VPWR VGND sky130_ef_sc_hd__decap_12
XFILLER_153_836 VGND VGND VPWR VPWR sky130_fd_sc_hd__decap_4
XFILLER_125_538 VPWR VGND VPWR VGND sky130_ef_sc_hd__decap_12
XFILLER_98_35 VGND VGND VPWR VPWR sky130_fd_sc_hd__fill_1
X_10312_ _03944_ _04059_ _04060_ VGND VGND VPWR VPWR _04062_ sky130_fd_sc_hd__and3_1
XFILLER_4_813 VPWR VGND VPWR VGND sky130_ef_sc_hd__decap_12
XFILLER_22_97 VPWR VGND VPWR VGND sky130_ef_sc_hd__decap_12
X_13100_ clknet_leaf_77_clk _00110_ VGND VGND VPWR VPWR u_interface.fifo_data\[15\]\[21\]
+ sky130_fd_sc_hd__dfxtp_1
X_14080_ clknet_leaf_18_clk net1615 VGND VGND VPWR VPWR u_interface.u_gelu_fp32.u_fp32_to_q16.s2_norm_mag\[17\]
+ sky130_fd_sc_hd__dfxtp_1
X_11292_ _04934_ _05032_ VGND VGND VPWR VPWR _05033_ sky130_fd_sc_hd__nor2_1
X_13031_ clknet_leaf_37_clk _00041_ VGND VGND VPWR VPWR u_interface.fifo_tuser\[14\]
+ sky130_fd_sc_hd__dfxtp_1
X_10243_ net190 _03990_ _03991_ VGND VGND VPWR VPWR _03993_ sky130_fd_sc_hd__nand3_1
XFILLER_154_41 VPWR VGND VPWR VGND sky130_ef_sc_hd__decap_12
X_10174_ _03923_ _03924_ VGND VGND VPWR VPWR _03925_ sky130_fd_sc_hd__nor2_1
XFILLER_87_691 VGND VGND VPWR VPWR sky130_fd_sc_hd__decap_3
Xfanout170 _06268_ VGND VGND VPWR VPWR net170 sky130_fd_sc_hd__buf_2
Xfanout192 net194 VGND VGND VPWR VPWR net192 sky130_fd_sc_hd__buf_1
X_13933_ clknet_leaf_7_clk _00018_ VGND VGND VPWR VPWR u_interface.u_gelu_fp32.u_synth_top.s1_hits\[5\]
+ sky130_fd_sc_hd__dfxtp_1
XFILLER_93_138 VGND VGND VPWR VPWR sky130_fd_sc_hd__fill_2
XTAP_TAPCELL_ROW_89_1765 VGND VPWR sky130_fd_sc_hd__tapvpwrvgnd_1
XTAP_TAPCELL_ROW_89_1754 VGND VPWR sky130_fd_sc_hd__tapvpwrvgnd_1
XFILLER_59_393 VPWR VGND VPWR VGND sky130_ef_sc_hd__decap_12
XFILLER_35_706 VPWR VGND VPWR VGND sky130_ef_sc_hd__decap_12
X_13864_ clknet_leaf_19_clk net873 VGND VGND VPWR VPWR u_interface.u_gelu_fp32.u_synth_top.s2_dx\[0\]
+ sky130_fd_sc_hd__dfxtp_1
XFILLER_75_897 VGND VGND VPWR VPWR sky130_fd_sc_hd__decap_4
XFILLER_47_588 VPWR VGND VPWR VGND sky130_ef_sc_hd__decap_12
XFILLER_19_279 VGND VGND VPWR VPWR sky130_fd_sc_hd__fill_1
XFILLER_34_205 VGND VGND VPWR VPWR sky130_fd_sc_hd__fill_2
X_12815_ net778 net105 VGND VGND VPWR VPWR _00973_ sky130_fd_sc_hd__and2_1
XFILLER_74_385 VGND VGND VPWR VPWR sky130_fd_sc_hd__decap_3
XFILLER_34_249 VGND VGND VPWR VPWR sky130_fd_sc_hd__decap_3
X_13795_ clknet_leaf_80_clk _00805_ VGND VGND VPWR VPWR u_interface.u_gelu_fp32.s2_data\[29\]
+ sky130_fd_sc_hd__dfxtp_1
X_12746_ net281 _06392_ _06393_ VGND VGND VPWR VPWR _06394_ sky130_fd_sc_hd__a21o_1
Xclkbuf_3_4__f_clk clknet_0_clk VGND VGND VPWR VPWR clknet_3_4__leaf_clk sky130_fd_sc_hd__clkbuf_16
XFILLER_15_485 VGND VGND VPWR VPWR sky130_fd_sc_hd__decap_8
XTAP_TAPCELL_ROW_100_1943 VGND VPWR sky130_fd_sc_hd__tapvpwrvgnd_1
XTAP_TAPCELL_ROW_100_1932 VGND VPWR sky130_fd_sc_hd__tapvpwrvgnd_1
X_12677_ net913 u_interface.u_gelu_fp32.u_q16_to_fp32.s2_sign net797 VGND VGND VPWR
+ VPWR _00913_ sky130_fd_sc_hd__mux2_1
XFILLER_128_321 VPWR VGND VPWR VGND sky130_ef_sc_hd__decap_12
X_11628_ net633 net389 _05364_ VGND VGND VPWR VPWR _05366_ sky130_fd_sc_hd__and3_1
XFILLER_30_477 VGND VGND VPWR VPWR sky130_fd_sc_hd__decap_3
XTAP_TAPCELL_ROW_41_984 VGND VPWR sky130_fd_sc_hd__tapvpwrvgnd_1
XTAP_TAPCELL_ROW_41_995 VGND VPWR sky130_fd_sc_hd__tapvpwrvgnd_1
XFILLER_8_77 VGND VGND VPWR VPWR sky130_fd_sc_hd__decap_6
Xhold607 u_interface.fifo_data\[7\]\[16\] VGND VGND VPWR VPWR net1472 sky130_fd_sc_hd__dlygate4sd3_1
Xhold618 u_interface.u_gelu_fp32.u_fp32_to_q16.s3_frac\[1\] VGND VGND VPWR VPWR net1483
+ sky130_fd_sc_hd__dlygate4sd3_1
XFILLER_128_365 VGND VGND VPWR VPWR sky130_fd_sc_hd__decap_4
X_11559_ _05296_ _05297_ VGND VGND VPWR VPWR _05298_ sky130_fd_sc_hd__nor2_1
XFILLER_7_673 VPWR VGND VPWR VGND sky130_ef_sc_hd__decap_12
XFILLER_155_195 VGND VGND VPWR VPWR sky130_fd_sc_hd__fill_1
XFILLER_143_335 VGND VGND VPWR VPWR sky130_fd_sc_hd__fill_1
XTAP_TAPCELL_ROW_133_2464 VGND VPWR sky130_fd_sc_hd__tapvpwrvgnd_1
XFILLER_109_590 VPWR VGND VPWR VGND sky130_ef_sc_hd__decap_12
Xhold629 u_interface.fifo_data\[5\]\[8\] VGND VGND VPWR VPWR net1494 sky130_fd_sc_hd__dlygate4sd3_1
XFILLER_143_368 VPWR VGND VPWR VGND sky130_ef_sc_hd__decap_12
X_13229_ clknet_leaf_45_clk _00239_ VGND VGND VPWR VPWR u_interface.fifo_data\[11\]\[7\]
+ sky130_fd_sc_hd__dfxtp_1
XFILLER_40_3 VPWR VGND VPWR VGND sky130_ef_sc_hd__decap_12
XFILLER_124_582 VGND VGND VPWR VPWR sky130_fd_sc_hd__decap_6
XFILLER_111_221 VGND VGND VPWR VPWR sky130_fd_sc_hd__decap_3
XFILLER_69_124 VGND VGND VPWR VPWR sky130_fd_sc_hd__decap_8
XFILLER_69_113 VGND VGND VPWR VPWR sky130_fd_sc_hd__fill_1
X_08770_ net614 net476 net480 net621 VGND VGND VPWR VPWR _02529_ sky130_fd_sc_hd__a22o_1
XFILLER_69_179 VPWR VGND VPWR VGND sky130_ef_sc_hd__decap_12
XTAP_TAPCELL_ROW_53_1190 VGND VPWR sky130_fd_sc_hd__tapvpwrvgnd_1
X_07721_ net1740 _01430_ _01764_ _01771_ VGND VGND VPWR VPWR _00515_ sky130_fd_sc_hd__or4_1
XFILLER_38_533 VGND VGND VPWR VPWR sky130_fd_sc_hd__fill_2
X_07652_ _01710_ _01736_ net306 VGND VGND VPWR VPWR _01737_ sky130_fd_sc_hd__mux2_1
XFILLER_65_374 VGND VGND VPWR VPWR sky130_fd_sc_hd__decap_8
XTAP_TAPCELL_ROW_0_315 VGND VPWR sky130_fd_sc_hd__tapvpwrvgnd_1
XTAP_TAPCELL_ROW_0_326 VGND VPWR sky130_fd_sc_hd__tapvpwrvgnd_1
XTAP_TAPCELL_ROW_0_337 VGND VPWR sky130_fd_sc_hd__tapvpwrvgnd_1
XFILLER_38_566 VGND VGND VPWR VPWR sky130_fd_sc_hd__decap_4
X_07583_ net810 net1779 net303 _01688_ VGND VGND VPWR VPWR _00460_ sky130_fd_sc_hd__a22o_1
X_06603_ net535 _01175_ _01180_ VGND VGND VPWR VPWR _00004_ sky130_fd_sc_hd__and3_1
XFILLER_80_333 VPWR VGND VPWR VGND sky130_ef_sc_hd__decap_12
X_06534_ u_interface.fifo_count\[3\] u_interface.fifo_count\[2\] u_interface.fifo_count\[1\]
+ u_interface.fifo_count\[0\] VGND VGND VPWR VPWR _01132_ sky130_fd_sc_hd__or4_1
X_09322_ _03049_ _03076_ _03077_ VGND VGND VPWR VPWR _03081_ sky130_fd_sc_hd__a21oi_1
XFILLER_80_377 VGND VGND VPWR VPWR sky130_fd_sc_hd__fill_1
X_09253_ _02973_ _02976_ _02975_ VGND VGND VPWR VPWR _03012_ sky130_fd_sc_hd__a21o_1
XFILLER_33_293 VPWR VGND VPWR VGND sky130_ef_sc_hd__decap_12
X_09184_ _02880_ _02924_ VGND VGND VPWR VPWR _02943_ sky130_fd_sc_hd__nor2_1
X_08204_ _02025_ _02026_ _02030_ VGND VGND VPWR VPWR _02036_ sky130_fd_sc_hd__nor3b_1
X_08135_ _01971_ _01972_ VGND VGND VPWR VPWR _01978_ sky130_fd_sc_hd__nand2_1
XFILLER_107_505 VPWR VGND VPWR VGND sky130_ef_sc_hd__decap_12
XFILLER_4_109 VPWR VGND VPWR VGND sky130_ef_sc_hd__decap_12
XFILLER_134_324 VGND VGND VPWR VPWR sky130_fd_sc_hd__decap_8
X_08066_ net291 _01920_ VGND VGND VPWR VPWR _00712_ sky130_fd_sc_hd__nor2_1
XTAP_TAPCELL_ROW_73_1500 VGND VPWR sky130_fd_sc_hd__tapvpwrvgnd_1
XTAP_TAPCELL_ROW_73_1511 VGND VPWR sky130_fd_sc_hd__tapvpwrvgnd_1
X_07017_ net1103 net385 net270 VGND VGND VPWR VPWR _00057_ sky130_fd_sc_hd__mux2_1
XFILLER_68_27 VGND VGND VPWR VPWR sky130_fd_sc_hd__fill_1
XTAP_TAPCELL_ROW_8_459 VGND VPWR sky130_fd_sc_hd__tapvpwrvgnd_1
XFILLER_0_337 VPWR VGND VPWR VGND sky130_ef_sc_hd__decap_12
X_08968_ _02724_ _02725_ _02726_ VGND VGND VPWR VPWR _02727_ sky130_fd_sc_hd__or3_1
X_07919_ u_interface.u_gelu_fp32.u_fp32_to_q16.s1_exp\[7\] _01812_ u_interface.u_gelu_fp32.u_fp32_to_q16.s1_exp\[6\]
+ VGND VGND VPWR VPWR _01813_ sky130_fd_sc_hd__or3b_1
X_08899_ _02656_ _02657_ VGND VGND VPWR VPWR _02658_ sky130_fd_sc_hd__nor2_1
XFILLER_84_15 VGND VGND VPWR VPWR sky130_fd_sc_hd__fill_1
XFILLER_84_59 VGND VGND VPWR VPWR sky130_fd_sc_hd__fill_2
XFILLER_71_300 VGND VGND VPWR VPWR sky130_fd_sc_hd__decap_6
X_10930_ _04569_ _04571_ VGND VGND VPWR VPWR _04674_ sky130_fd_sc_hd__nand2_1
XFILLER_44_503 VGND VGND VPWR VPWR sky130_fd_sc_hd__decap_3
XFILLER_56_396 VGND VGND VPWR VPWR sky130_fd_sc_hd__decap_3
XFILLER_16_238 VGND VGND VPWR VPWR sky130_fd_sc_hd__fill_1
X_12600_ u_interface.u_gelu_fp32.u_q16_to_fp32.s1_mag\[13\] net211 _06301_ _06302_
+ u_interface.u_gelu_fp32.u_q16_to_fp32.s1_mag\[29\] VGND VGND VPWR VPWR _06303_ sky130_fd_sc_hd__a2111o_1
X_10861_ net652 net431 net426 net644 VGND VGND VPWR VPWR _04606_ sky130_fd_sc_hd__a22oi_1
XTAP_TAPCELL_ROW_27_767 VGND VPWR sky130_fd_sc_hd__tapvpwrvgnd_1
XTAP_TAPCELL_ROW_84_1684 VGND VPWR sky130_fd_sc_hd__tapvpwrvgnd_1
XTAP_TAPCELL_ROW_84_1673 VGND VPWR sky130_fd_sc_hd__tapvpwrvgnd_1
X_13580_ clknet_leaf_67_clk _00590_ VGND VGND VPWR VPWR u_interface.fifo_data\[4\]\[27\]
+ sky130_fd_sc_hd__dfxtp_1
X_10792_ _04488_ _04489_ _04535_ _04536_ VGND VGND VPWR VPWR _04538_ sky130_fd_sc_hd__a2bb2oi_1
XFILLER_25_783 VGND VGND VPWR VPWR sky130_fd_sc_hd__fill_1
X_12531_ _06227_ _06230_ _06253_ VGND VGND VPWR VPWR _06255_ sky130_fd_sc_hd__nor3_1
XFILLER_8_426 VPWR VGND VPWR VGND sky130_ef_sc_hd__decap_12
X_12462_ _06186_ _06187_ VGND VGND VPWR VPWR _06188_ sky130_fd_sc_hd__or2_1
XFILLER_40_797 VGND VGND VPWR VPWR sky130_fd_sc_hd__fill_1
XFILLER_149_74 VGND VGND VPWR VPWR sky130_fd_sc_hd__decap_8
X_11413_ _05149_ _05150_ _05151_ VGND VGND VPWR VPWR _05153_ sky130_fd_sc_hd__nand3_1
XFILLER_153_600 VGND VGND VPWR VPWR sky130_fd_sc_hd__fill_2
XPHY_EDGE_ROW_104_Left_260 VGND VGND VPWR VPWR sky130_fd_sc_hd__decap_3
X_12393_ _06119_ _06120_ VGND VGND VPWR VPWR _06121_ sky130_fd_sc_hd__or2_1
X_14132_ clknet_leaf_29_clk _01058_ VGND VGND VPWR VPWR u_interface.in_flight_count\[5\]
+ sky130_fd_sc_hd__dfxtp_1
XFILLER_126_847 VGND VGND VPWR VPWR sky130_fd_sc_hd__decap_4
XFILLER_125_335 VGND VGND VPWR VPWR sky130_fd_sc_hd__fill_1
XTAP_TAPCELL_ROW_115_2172 VGND VPWR sky130_fd_sc_hd__tapvpwrvgnd_1
XFILLER_4_643 VGND VGND VPWR VPWR sky130_fd_sc_hd__fill_1
X_11344_ net611 net392 _05083_ VGND VGND VPWR VPWR _05085_ sky130_fd_sc_hd__and3_1
XTAP_TAPCELL_ROW_115_2183 VGND VPWR sky130_fd_sc_hd__tapvpwrvgnd_1
XFILLER_113_508 VGND VGND VPWR VPWR sky130_fd_sc_hd__fill_1
X_14063_ clknet_leaf_55_clk _00989_ VGND VGND VPWR VPWR u_interface.u_gelu_fp32.u_q16_to_fp32.s2_clz\[2\]
+ sky130_fd_sc_hd__dfxtp_1
X_11275_ _04915_ _05016_ VGND VGND VPWR VPWR _05017_ sky130_fd_sc_hd__xnor2_1
XPHY_EDGE_ROW_148_Right_148 VGND VGND VPWR VPWR sky130_fd_sc_hd__decap_3
X_10226_ _03887_ _03919_ _03920_ VGND VGND VPWR VPWR _03976_ sky130_fd_sc_hd__a21bo_1
X_13014_ net1060 net562 net221 VGND VGND VPWR VPWR _01097_ sky130_fd_sc_hd__mux2_1
XFILLER_39_308 VGND VGND VPWR VPWR sky130_fd_sc_hd__decap_4
Xhold4 u_interface.u_gelu_fp32.u_synth_top.s1_x\[1\] VGND VGND VPWR VPWR net869 sky130_fd_sc_hd__dlygate4sd3_1
XFILLER_121_596 VPWR VGND VPWR VGND sky130_ef_sc_hd__decap_12
X_10157_ net461 net665 _03906_ _03907_ VGND VGND VPWR VPWR _03908_ sky130_fd_sc_hd__a22o_1
XFILLER_39_319 VPWR VGND VPWR VGND sky130_ef_sc_hd__decap_12
X_10088_ _03805_ _03837_ _03838_ VGND VGND VPWR VPWR _03840_ sky130_fd_sc_hd__nand3_1
XFILLER_66_149 VGND VGND VPWR VPWR sky130_fd_sc_hd__fill_2
XFILLER_58_93 VGND VGND VPWR VPWR sky130_fd_sc_hd__decap_3
XFILLER_48_864 VGND VGND VPWR VPWR sky130_fd_sc_hd__decap_4
X_13916_ clknet_leaf_6_clk net898 VGND VGND VPWR VPWR u_interface.u_gelu_fp32.u_synth_top.s1_x\[20\]
+ sky130_fd_sc_hd__dfxtp_1
XFILLER_63_801 VGND VGND VPWR VPWR sky130_fd_sc_hd__decap_4
XFILLER_90_642 VGND VGND VPWR VPWR sky130_fd_sc_hd__fill_2
XFILLER_90_631 VGND VGND VPWR VPWR sky130_fd_sc_hd__fill_2
XFILLER_74_193 VGND VGND VPWR VPWR sky130_fd_sc_hd__decap_3
XFILLER_74_70 VPWR VGND VPWR VGND sky130_ef_sc_hd__decap_12
X_13847_ clknet_leaf_24_clk _00857_ VGND VGND VPWR VPWR u_interface.u_gelu_fp32.u_synth_top.s3_b\[3\]
+ sky130_fd_sc_hd__dfxtp_1
XFILLER_62_355 VGND VGND VPWR VPWR sky130_fd_sc_hd__fill_2
XFILLER_23_709 VPWR VGND VPWR VGND sky130_ef_sc_hd__decap_12
X_13778_ clknet_leaf_87_clk _00788_ VGND VGND VPWR VPWR u_interface.u_gelu_fp32.s2_data\[12\]
+ sky130_fd_sc_hd__dfxtp_1
XFILLER_15_271 VGND VGND VPWR VPWR sky130_fd_sc_hd__decap_8
X_12729_ net281 _06379_ _06380_ VGND VGND VPWR VPWR _06381_ sky130_fd_sc_hd__a21o_1
XFILLER_31_753 VPWR VGND VPWR VGND sky130_ef_sc_hd__decap_12
XFILLER_148_449 VGND VGND VPWR VPWR sky130_fd_sc_hd__decap_4
XFILLER_88_3 VGND VGND VPWR VPWR sky130_fd_sc_hd__decap_8
XFILLER_30_241 VGND VGND VPWR VPWR sky130_fd_sc_hd__fill_1
XFILLER_31_797 VPWR VGND VPWR VGND sky130_ef_sc_hd__decap_12
Xhold404 u_interface.fifo_data\[15\]\[10\] VGND VGND VPWR VPWR net1269 sky130_fd_sc_hd__dlygate4sd3_1
XFILLER_143_132 VGND VGND VPWR VPWR sky130_fd_sc_hd__decap_8
Xhold415 u_interface.fifo_data\[2\]\[11\] VGND VGND VPWR VPWR net1280 sky130_fd_sc_hd__dlygate4sd3_1
Xhold426 u_interface.fifo_data\[0\]\[27\] VGND VGND VPWR VPWR net1291 sky130_fd_sc_hd__dlygate4sd3_1
Xhold437 u_interface.u_gelu_fp32.u_fp32_to_q16.s1_mant\[18\] VGND VGND VPWR VPWR net1302
+ sky130_fd_sc_hd__dlygate4sd3_1
Xhold448 u_interface.fifo_data\[14\]\[26\] VGND VGND VPWR VPWR net1313 sky130_fd_sc_hd__dlygate4sd3_1
Xhold459 u_interface.fifo_data\[0\]\[19\] VGND VGND VPWR VPWR net1324 sky130_fd_sc_hd__dlygate4sd3_1
X_09940_ net473 net673 VGND VGND VPWR VPWR _03693_ sky130_fd_sc_hd__and2_1
XPHY_EDGE_ROW_115_Right_115 VGND VGND VPWR VPWR sky130_fd_sc_hd__decap_3
X_09871_ _03513_ _03515_ _03622_ _03623_ VGND VGND VPWR VPWR _03625_ sky130_fd_sc_hd__a211oi_1
XFILLER_58_606 VGND VGND VPWR VPWR sky130_fd_sc_hd__decap_6
XTAP_TAPCELL_ROW_5_418 VGND VPWR sky130_fd_sc_hd__tapvpwrvgnd_1
X_08822_ _02461_ _02466_ _02465_ VGND VGND VPWR VPWR _02581_ sky130_fd_sc_hd__a21oi_1
XFILLER_57_105 VGND VGND VPWR VPWR sky130_fd_sc_hd__decap_6
XTAP_TAPCELL_ROW_51_1149 VGND VPWR sky130_fd_sc_hd__tapvpwrvgnd_1
XTAP_TAPCELL_ROW_146_2677 VGND VPWR sky130_fd_sc_hd__tapvpwrvgnd_1
XTAP_TAPCELL_ROW_146_2666 VGND VPWR sky130_fd_sc_hd__tapvpwrvgnd_1
X_08753_ net622 net488 net492 net629 VGND VGND VPWR VPWR _02512_ sky130_fd_sc_hd__a22oi_1
X_07704_ u_interface.u_gelu_fp32.u_synth_top.s1_hits\[0\] _01763_ _01764_ VGND VGND
+ VPWR VPWR _01765_ sky130_fd_sc_hd__nor3_1
XFILLER_26_514 VGND VGND VPWR VPWR sky130_fd_sc_hd__decap_8
XFILLER_38_352 VPWR VGND VPWR VGND sky130_ef_sc_hd__decap_12
XFILLER_39_875 VGND VGND VPWR VPWR sky130_fd_sc_hd__decap_3
X_08684_ net670 net502 net679 net508 VGND VGND VPWR VPWR _02443_ sky130_fd_sc_hd__nand4_1
XFILLER_54_29 VGND VGND VPWR VPWR sky130_fd_sc_hd__decap_4
X_07635_ u_interface.u_gelu_fp32.u_q16_to_fp32.s2_mag\[7\] u_interface.u_gelu_fp32.u_q16_to_fp32.s2_mag\[6\]
+ u_interface.u_gelu_fp32.u_q16_to_fp32.s2_mag\[5\] u_interface.u_gelu_fp32.u_q16_to_fp32.s2_mag\[4\]
+ net338 net334 VGND VGND VPWR VPWR _01724_ sky130_fd_sc_hd__mux4_1
XFILLER_65_193 VGND VGND VPWR VPWR sky130_fd_sc_hd__fill_2
XFILLER_54_878 VGND VGND VPWR VPWR sky130_fd_sc_hd__decap_6
X_07566_ _01646_ _01648_ net547 VGND VGND VPWR VPWR _01679_ sky130_fd_sc_hd__mux2_1
XTAP_TAPCELL_ROW_24_715 VGND VPWR sky130_fd_sc_hd__tapvpwrvgnd_1
XTAP_TAPCELL_ROW_24_726 VGND VPWR sky130_fd_sc_hd__tapvpwrvgnd_1
X_09305_ _03027_ _03028_ _03030_ VGND VGND VPWR VPWR _03064_ sky130_fd_sc_hd__a21o_1
X_06517_ u_interface.fifo_count\[1\] u_interface.in_flight_count\[1\] u_interface.in_flight_count\[0\]
+ u_interface.fifo_count\[0\] VGND VGND VPWR VPWR _01117_ sky130_fd_sc_hd__a22o_1
XTAP_TAPCELL_ROW_66_1392 VGND VPWR sky130_fd_sc_hd__tapvpwrvgnd_1
X_09236_ _02897_ _02899_ VGND VGND VPWR VPWR _02995_ sky130_fd_sc_hd__nand2_1
XFILLER_139_449 VGND VGND VPWR VPWR sky130_fd_sc_hd__fill_2
X_07497_ net551 _01557_ VGND VGND VPWR VPWR _01629_ sky130_fd_sc_hd__or2_1
XFILLER_155_909 VPWR VGND VPWR VGND sky130_ef_sc_hd__decap_12
XPHY_EDGE_ROW_17_Right_17 VGND VGND VPWR VPWR sky130_fd_sc_hd__decap_3
X_09167_ _02891_ _02894_ _02893_ VGND VGND VPWR VPWR _02926_ sky130_fd_sc_hd__a21o_1
XFILLER_119_162 VGND VGND VPWR VPWR sky130_fd_sc_hd__decap_6
X_09098_ _02854_ _02855_ _02856_ VGND VGND VPWR VPWR _02857_ sky130_fd_sc_hd__nor3b_1
XFILLER_119_55 VGND VGND VPWR VPWR sky130_fd_sc_hd__fill_1
X_08118_ _01962_ _01963_ VGND VGND VPWR VPWR _01964_ sky130_fd_sc_hd__xor2_1
XFILLER_79_15 VGND VGND VPWR VPWR sky130_fd_sc_hd__decap_4
XFILLER_150_603 VGND VGND VPWR VPWR sky130_fd_sc_hd__decap_3
X_08049_ u_interface.u_gelu_fp32.u_fp32_to_q16.s3_frac\[29\] u_interface.u_gelu_fp32.u_fp32_to_q16.s3_frac\[28\]
+ u_interface.u_gelu_fp32.u_fp32_to_q16.s3_frac\[30\] _01905_ VGND VGND VPWR VPWR
+ _01906_ sky130_fd_sc_hd__or4_1
XFILLER_135_32 VGND VGND VPWR VPWR sky130_fd_sc_hd__decap_8
X_11060_ _04688_ _04802_ VGND VGND VPWR VPWR _04803_ sky130_fd_sc_hd__nor2_1
XFILLER_135_54 VGND VGND VPWR VPWR sky130_fd_sc_hd__fill_2
X_10011_ net486 net491 net723 VGND VGND VPWR VPWR _03763_ sky130_fd_sc_hd__nand3_1
XFILLER_135_76 VGND VGND VPWR VPWR sky130_fd_sc_hd__fill_1
XTAP_TAPCELL_ROW_110_2091 VGND VPWR sky130_fd_sc_hd__tapvpwrvgnd_1
XFILLER_76_414 VGND VGND VPWR VPWR sky130_fd_sc_hd__decap_3
XFILLER_49_617 VGND VGND VPWR VPWR sky130_fd_sc_hd__decap_6
XFILLER_48_105 VGND VGND VPWR VPWR sky130_fd_sc_hd__fill_1
XPHY_EDGE_ROW_26_Right_26 VGND VGND VPWR VPWR sky130_fd_sc_hd__decap_3
XFILLER_92_918 VGND VGND VPWR VPWR sky130_fd_sc_hd__decap_3
XFILLER_28_41 VPWR VGND VPWR VGND sky130_ef_sc_hd__decap_12
XFILLER_151_42 VPWR VGND VPWR VGND sky130_ef_sc_hd__decap_12
XFILLER_91_406 VGND VGND VPWR VPWR sky130_fd_sc_hd__decap_3
XTAP_TAPCELL_ROW_86_1713 VGND VPWR sky130_fd_sc_hd__tapvpwrvgnd_1
XFILLER_17_503 VGND VGND VPWR VPWR sky130_fd_sc_hd__fill_1
X_13701_ clknet_leaf_19_clk _00711_ VGND VGND VPWR VPWR u_interface.u_gelu_fp32.s1_data\[1\]
+ sky130_fd_sc_hd__dfxtp_1
XFILLER_91_439 VGND VGND VPWR VPWR sky130_fd_sc_hd__decap_8
XFILLER_17_547 VGND VGND VPWR VPWR sky130_fd_sc_hd__fill_2
X_11962_ _05692_ _05693_ VGND VGND VPWR VPWR _05696_ sky130_fd_sc_hd__xnor2_1
XFILLER_28_85 VPWR VGND VPWR VGND sky130_ef_sc_hd__decap_12
XFILLER_71_141 VGND VGND VPWR VPWR sky130_fd_sc_hd__fill_1
X_10913_ _04654_ _04655_ _04656_ VGND VGND VPWR VPWR _04658_ sky130_fd_sc_hd__and3_1
XFILLER_17_558 VGND VGND VPWR VPWR sky130_fd_sc_hd__fill_2
X_11893_ _05625_ _05626_ VGND VGND VPWR VPWR _05628_ sky130_fd_sc_hd__xnor2_1
X_13632_ clknet_leaf_66_clk _00642_ VGND VGND VPWR VPWR u_interface.fifo_data\[13\]\[15\]
+ sky130_fd_sc_hd__dfxtp_1
X_10844_ _04476_ _04478_ _04587_ VGND VGND VPWR VPWR _04589_ sky130_fd_sc_hd__a21o_1
XFILLER_44_399 VPWR VGND VPWR VGND sky130_ef_sc_hd__decap_12
XFILLER_32_517 VPWR VGND VPWR VGND sky130_ef_sc_hd__decap_12
X_13563_ clknet_leaf_40_clk _00573_ VGND VGND VPWR VPWR u_interface.fifo_data\[4\]\[10\]
+ sky130_fd_sc_hd__dfxtp_1
XFILLER_60_859 VGND VGND VPWR VPWR sky130_fd_sc_hd__decap_8
XFILLER_13_753 VPWR VGND VPWR VGND sky130_ef_sc_hd__decap_12
X_10775_ net618 net417 net414 net609 VGND VGND VPWR VPWR _04521_ sky130_fd_sc_hd__a22o_1
X_12514_ _06237_ _06238_ VGND VGND VPWR VPWR _06239_ sky130_fd_sc_hd__nor2_1
XPHY_EDGE_ROW_35_Right_35 VGND VGND VPWR VPWR sky130_fd_sc_hd__decap_3
XTAP_TAPCELL_ROW_117_2212 VGND VPWR sky130_fd_sc_hd__tapvpwrvgnd_1
XTAP_TAPCELL_ROW_117_2201 VGND VPWR sky130_fd_sc_hd__tapvpwrvgnd_1
X_13494_ clknet_leaf_3_clk _00504_ VGND VGND VPWR VPWR u_interface.u_gelu_fp32.u_synth_top.s2_m\[17\]
+ sky130_fd_sc_hd__dfxtp_1
XFILLER_100_90 VPWR VGND VPWR VGND sky130_ef_sc_hd__decap_12
XFILLER_12_296 VPWR VGND VPWR VGND sky130_ef_sc_hd__decap_12
XFILLER_13_797 VPWR VGND VPWR VGND sky130_ef_sc_hd__decap_12
XFILLER_138_460 VPWR VGND VPWR VGND sky130_ef_sc_hd__decap_12
X_12445_ _06170_ _06171_ VGND VGND VPWR VPWR _06172_ sky130_fd_sc_hd__nand2_1
XFILLER_138_482 VGND VGND VPWR VPWR sky130_fd_sc_hd__fill_1
XFILLER_125_110 VGND VGND VPWR VPWR sky130_fd_sc_hd__fill_2
XTAP_TAPCELL_ROW_97_1886 VGND VPWR sky130_fd_sc_hd__tapvpwrvgnd_1
X_12376_ _06101_ _06102_ VGND VGND VPWR VPWR _06104_ sky130_fd_sc_hd__xor2_1
XTAP_TAPCELL_ROW_130_2423 VGND VPWR sky130_fd_sc_hd__tapvpwrvgnd_1
XTAP_TAPCELL_ROW_130_2412 VGND VPWR sky130_fd_sc_hd__tapvpwrvgnd_1
X_14115_ clknet_leaf_26_clk _01041_ VGND VGND VPWR VPWR u_interface.meta_tlast_pipe\[8\]
+ sky130_fd_sc_hd__dfxtp_1
XFILLER_114_817 VGND VGND VPWR VPWR sky130_fd_sc_hd__fill_1
XFILLER_114_806 VGND VGND VPWR VPWR sky130_fd_sc_hd__decap_6
XFILLER_113_305 VPWR VGND VPWR VGND sky130_ef_sc_hd__decap_12
X_11327_ net659 net416 net412 net651 VGND VGND VPWR VPWR _05068_ sky130_fd_sc_hd__a22o_1
XTAP_TAPCELL_ROW_10_497 VGND VPWR sky130_fd_sc_hd__tapvpwrvgnd_1
XFILLER_153_485 VGND VGND VPWR VPWR sky130_fd_sc_hd__fill_2
XFILLER_126_699 VGND VGND VPWR VPWR sky130_fd_sc_hd__fill_1
XFILLER_107_891 VGND VGND VPWR VPWR sky130_fd_sc_hd__decap_4
X_14046_ clknet_leaf_17_clk _00972_ VGND VGND VPWR VPWR u_interface.u_gelu_fp32.u_fp32_to_q16.s1_mant\[8\]
+ sky130_fd_sc_hd__dfxtp_1
XFILLER_141_669 VGND VGND VPWR VPWR sky130_fd_sc_hd__decap_3
XFILLER_69_81 VPWR VGND VPWR VGND sky130_ef_sc_hd__decap_12
X_11258_ _04965_ _04999_ VGND VGND VPWR VPWR _05000_ sky130_fd_sc_hd__xnor2_2
XPHY_EDGE_ROW_44_Right_44 VGND VGND VPWR VPWR sky130_fd_sc_hd__decap_3
X_10209_ _03957_ _03959_ _03849_ _03851_ VGND VGND VPWR VPWR _03960_ sky130_fd_sc_hd__a211oi_1
X_11189_ _04816_ _04930_ _04701_ VGND VGND VPWR VPWR _04931_ sky130_fd_sc_hd__o21a_1
XFILLER_95_756 VGND VGND VPWR VPWR sky130_fd_sc_hd__fill_1
XFILLER_39_149 VGND VGND VPWR VPWR sky130_fd_sc_hd__decap_3
XTAP_TAPCELL_ROW_128_2385 VGND VPWR sky130_fd_sc_hd__tapvpwrvgnd_1
XFILLER_94_277 VPWR VGND VPWR VGND sky130_ef_sc_hd__decap_12
XFILLER_35_322 VGND VGND VPWR VPWR sky130_fd_sc_hd__fill_1
XFILLER_90_450 VPWR VGND VPWR VGND sky130_ef_sc_hd__decap_12
XFILLER_47_193 VGND VGND VPWR VPWR sky130_fd_sc_hd__fill_2
XFILLER_35_355 VPWR VGND VPWR VGND sky130_ef_sc_hd__decap_12
X_07420_ net560 u_interface.u_gelu_fp32.u_fp32_to_q16.s2_norm_mag\[30\] VGND VGND
+ VPWR VPWR _01556_ sky130_fd_sc_hd__nor2_1
XTAP_TAPCELL_ROW_141_2596 VGND VPWR sky130_fd_sc_hd__tapvpwrvgnd_1
XTAP_TAPCELL_ROW_141_2585 VGND VPWR sky130_fd_sc_hd__tapvpwrvgnd_1
XFILLER_62_174 VPWR VGND VPWR VGND sky130_ef_sc_hd__decap_12
XFILLER_35_399 VGND VGND VPWR VPWR sky130_fd_sc_hd__fill_1
X_07351_ net352 net1472 net243 VGND VGND VPWR VPWR _00381_ sky130_fd_sc_hd__mux2_1
XPHY_EDGE_ROW_53_Right_53 VGND VGND VPWR VPWR sky130_fd_sc_hd__decap_3
X_07282_ net1141 net363 net247 VGND VGND VPWR VPWR _00312_ sky130_fd_sc_hd__mux2_1
X_09021_ _02730_ _02778_ _02779_ VGND VGND VPWR VPWR _02780_ sky130_fd_sc_hd__nand3_2
XFILLER_129_493 VGND VGND VPWR VPWR sky130_fd_sc_hd__decap_8
Xhold201 u_interface.fifo_data\[6\]\[17\] VGND VGND VPWR VPWR net1066 sky130_fd_sc_hd__dlygate4sd3_1
XFILLER_116_121 VGND VGND VPWR VPWR sky130_fd_sc_hd__fill_2
Xhold223 u_interface.fifo_tuser\[8\] VGND VGND VPWR VPWR net1088 sky130_fd_sc_hd__dlygate4sd3_1
Xhold212 u_interface.fifo_data\[0\]\[13\] VGND VGND VPWR VPWR net1077 sky130_fd_sc_hd__dlygate4sd3_1
Xhold234 u_interface.fifo_data\[1\]\[1\] VGND VGND VPWR VPWR net1099 sky130_fd_sc_hd__dlygate4sd3_1
Xhold278 u_interface.fifo_tuser\[12\] VGND VGND VPWR VPWR net1143 sky130_fd_sc_hd__dlygate4sd3_1
XFILLER_131_113 VGND VGND VPWR VPWR sky130_fd_sc_hd__decap_4
Xhold267 u_interface.fifo_data\[9\]\[1\] VGND VGND VPWR VPWR net1132 sky130_fd_sc_hd__dlygate4sd3_1
Xhold256 u_interface.fifo_data\[6\]\[24\] VGND VGND VPWR VPWR net1121 sky130_fd_sc_hd__dlygate4sd3_1
Xhold245 u_interface.fifo_data\[9\]\[15\] VGND VGND VPWR VPWR net1110 sky130_fd_sc_hd__dlygate4sd3_1
XPHY_EDGE_ROW_62_Right_62 VGND VGND VPWR VPWR sky130_fd_sc_hd__decap_3
XTAP_TAPCELL_ROW_148_2706 VGND VPWR sky130_fd_sc_hd__tapvpwrvgnd_1
XFILLER_113_861 VGND VGND VPWR VPWR sky130_fd_sc_hd__decap_8
Xfanout714 net716 VGND VGND VPWR VPWR net714 sky130_fd_sc_hd__dlymetal6s2s_1
X_09923_ net580 net588 net432 net427 VGND VGND VPWR VPWR _03676_ sky130_fd_sc_hd__and4_1
Xhold289 u_interface.fifo_data\[8\]\[27\] VGND VGND VPWR VPWR net1154 sky130_fd_sc_hd__dlygate4sd3_1
Xfanout703 net704 VGND VGND VPWR VPWR net703 sky130_fd_sc_hd__buf_2
Xfanout736 net737 VGND VGND VPWR VPWR net736 sky130_fd_sc_hd__clkbuf_4
Xfanout747 net754 VGND VGND VPWR VPWR net747 sky130_fd_sc_hd__clkbuf_2
X_09854_ _03606_ _03607_ _03594_ VGND VGND VPWR VPWR _03608_ sky130_fd_sc_hd__o21ai_1
Xfanout725 _00003_ VGND VGND VPWR VPWR net725 sky130_fd_sc_hd__clkbuf_4
Xfanout758 net759 VGND VGND VPWR VPWR net758 sky130_fd_sc_hd__clkbuf_4
XFILLER_58_425 VPWR VGND VPWR VGND sky130_ef_sc_hd__decap_12
Xfanout769 net770 VGND VGND VPWR VPWR net769 sky130_fd_sc_hd__buf_4
X_08805_ net605 net485 _02562_ _02560_ VGND VGND VPWR VPWR _02564_ sky130_fd_sc_hd__a31o_1
XFILLER_105_57 VGND VGND VPWR VPWR sky130_fd_sc_hd__fill_2
XFILLER_100_533 VGND VGND VPWR VPWR sky130_fd_sc_hd__decap_8
XFILLER_85_244 VGND VGND VPWR VPWR sky130_fd_sc_hd__fill_2
X_06997_ net827 _01508_ _01515_ VGND VGND VPWR VPWR _01516_ sky130_fd_sc_hd__or3_2
X_09785_ _03531_ _03537_ VGND VGND VPWR VPWR _03539_ sky130_fd_sc_hd__xnor2_1
XFILLER_85_255 VPWR VGND VPWR VGND sky130_ef_sc_hd__decap_12
XTAP_TAPCELL_ROW_29_807 VGND VPWR sky130_fd_sc_hd__tapvpwrvgnd_1
X_08736_ net654 net497 _02493_ _02494_ VGND VGND VPWR VPWR _02495_ sky130_fd_sc_hd__a22o_1
XTAP_TAPCELL_ROW_68_1421 VGND VPWR sky130_fd_sc_hd__tapvpwrvgnd_1
XFILLER_26_333 VPWR VGND VPWR VGND sky130_ef_sc_hd__decap_12
X_08667_ net152 _02430_ net795 VGND VGND VPWR VPWR _00803_ sky130_fd_sc_hd__a21oi_1
X_07618_ net307 net299 _01710_ net1230 net808 VGND VGND VPWR VPWR _00473_ sky130_fd_sc_hd__a32o_1
XFILLER_81_472 VGND VGND VPWR VPWR sky130_fd_sc_hd__fill_2
XFILLER_81_27 VGND VGND VPWR VPWR sky130_fd_sc_hd__decap_6
XPHY_EDGE_ROW_71_Right_71 VGND VGND VPWR VPWR sky130_fd_sc_hd__decap_3
XFILLER_53_152 VGND VGND VPWR VPWR sky130_fd_sc_hd__decap_8
XFILLER_27_889 VGND VGND VPWR VPWR sky130_fd_sc_hd__decap_6
X_08598_ _02192_ _02193_ _02227_ VGND VGND VPWR VPWR _02380_ sky130_fd_sc_hd__o21ba_1
XTAP_TAPCELL_ROW_81_1632 VGND VPWR sky130_fd_sc_hd__tapvpwrvgnd_1
X_07549_ _01610_ _01603_ net548 VGND VGND VPWR VPWR _01666_ sky130_fd_sc_hd__mux2_1
XFILLER_10_701 VPWR VGND VPWR VGND sky130_ef_sc_hd__decap_12
XFILLER_155_706 VGND VGND VPWR VPWR sky130_fd_sc_hd__decap_4
X_10560_ _04103_ _04106_ _04305_ _04306_ VGND VGND VPWR VPWR _04308_ sky130_fd_sc_hd__a211oi_1
XFILLER_14_65 VPWR VGND VPWR VGND sky130_ef_sc_hd__decap_12
XFILLER_148_780 VGND VGND VPWR VPWR sky130_fd_sc_hd__fill_2
X_09219_ _02975_ _02976_ _02973_ VGND VGND VPWR VPWR _02978_ sky130_fd_sc_hd__a21bo_1
XFILLER_136_920 VGND VGND VPWR VPWR sky130_fd_sc_hd__fill_1
X_10491_ _04125_ _04128_ VGND VGND VPWR VPWR _04239_ sky130_fd_sc_hd__nand2_1
XFILLER_6_749 VGND VGND VPWR VPWR sky130_fd_sc_hd__decap_6
X_12230_ net702 net390 VGND VGND VPWR VPWR _05960_ sky130_fd_sc_hd__nand2_1
XFILLER_5_237 VPWR VGND VPWR VGND sky130_ef_sc_hd__decap_12
XTAP_TAPCELL_ROW_112_2120 VGND VPWR sky130_fd_sc_hd__tapvpwrvgnd_1
XPHY_EDGE_ROW_80_Right_80 VGND VGND VPWR VPWR sky130_fd_sc_hd__decap_3
XTAP_TAPCELL_ROW_79_1594 VGND VPWR sky130_fd_sc_hd__tapvpwrvgnd_1
XFILLER_30_53 VPWR VGND VPWR VGND sky130_ef_sc_hd__decap_12
XFILLER_146_53 VPWR VGND VPWR VGND sky130_ef_sc_hd__decap_12
XTAP_TAPCELL_ROW_112_2131 VGND VPWR sky130_fd_sc_hd__tapvpwrvgnd_1
XFILLER_108_699 VGND VGND VPWR VPWR sky130_fd_sc_hd__fill_1
X_12161_ _05826_ _05891_ VGND VGND VPWR VPWR _05892_ sky130_fd_sc_hd__xor2_1
XFILLER_30_97 VGND VGND VPWR VPWR sky130_fd_sc_hd__fill_2
XFILLER_150_433 VGND VGND VPWR VPWR sky130_fd_sc_hd__fill_2
XFILLER_111_809 VGND VGND VPWR VPWR sky130_fd_sc_hd__fill_1
XFILLER_89_550 VGND VGND VPWR VPWR sky130_fd_sc_hd__decap_8
Xhold790 u_interface.u_gelu_fp32.s2_data\[20\] VGND VGND VPWR VPWR net1655 sky130_fd_sc_hd__dlygate4sd3_1
X_11112_ net643 net416 net413 net634 VGND VGND VPWR VPWR _04855_ sky130_fd_sc_hd__a22o_1
X_12092_ net701 net709 net401 net397 VGND VGND VPWR VPWR _05824_ sky130_fd_sc_hd__and4_1
XFILLER_89_561 VGND VGND VPWR VPWR sky130_fd_sc_hd__fill_1
XFILLER_77_723 VGND VGND VPWR VPWR sky130_fd_sc_hd__fill_1
X_11043_ net196 _04786_ VGND VGND VPWR VPWR _04787_ sky130_fd_sc_hd__xnor2_1
XFILLER_39_51 VGND VGND VPWR VPWR sky130_fd_sc_hd__decap_4
XFILLER_103_382 VGND VGND VPWR VPWR sky130_fd_sc_hd__decap_3
XFILLER_49_447 VGND VGND VPWR VPWR sky130_fd_sc_hd__fill_1
XFILLER_92_715 VPWR VGND VPWR VGND sky130_ef_sc_hd__decap_12
XFILLER_37_609 VGND VGND VPWR VPWR sky130_fd_sc_hd__decap_6
X_12994_ net945 net362 net224 VGND VGND VPWR VPWR _01077_ sky130_fd_sc_hd__mux2_1
XFILLER_91_225 VPWR VGND VPWR VGND sky130_ef_sc_hd__decap_12
XFILLER_91_203 VGND VGND VPWR VPWR sky130_fd_sc_hd__decap_4
XFILLER_44_141 VPWR VGND VPWR VGND sky130_ef_sc_hd__decap_12
X_11945_ net692 net401 net398 net684 VGND VGND VPWR VPWR _05679_ sky130_fd_sc_hd__a22oi_1
XFILLER_18_867 VGND VGND VPWR VPWR sky130_fd_sc_hd__fill_1
X_13615_ clknet_leaf_68_clk _00625_ VGND VGND VPWR VPWR u_interface.fifo_data\[3\]\[30\]
+ sky130_fd_sc_hd__dfxtp_1
X_11876_ net658 net394 _05532_ _05531_ VGND VGND VPWR VPWR _05611_ sky130_fd_sc_hd__a31o_1
X_10827_ net464 net468 net722 VGND VGND VPWR VPWR _04572_ sky130_fd_sc_hd__o21ai_1
XFILLER_13_561 VPWR VGND VPWR VGND sky130_ef_sc_hd__decap_12
XTAP_TAPCELL_ROW_15_578 VGND VPWR sky130_fd_sc_hd__tapvpwrvgnd_1
XFILLER_32_358 VGND VGND VPWR VPWR sky130_fd_sc_hd__fill_1
X_13546_ clknet_leaf_47_clk _00556_ VGND VGND VPWR VPWR u_interface.fifo_data\[5\]\[25\]
+ sky130_fd_sc_hd__dfxtp_1
XTAP_TAPCELL_ROW_99_1926 VGND VPWR sky130_fd_sc_hd__tapvpwrvgnd_1
XTAP_TAPCELL_ROW_99_1915 VGND VPWR sky130_fd_sc_hd__tapvpwrvgnd_1
X_10758_ _04502_ _04503_ _04496_ VGND VGND VPWR VPWR _04504_ sky130_fd_sc_hd__a21o_1
X_13477_ clknet_leaf_4_clk _00487_ VGND VGND VPWR VPWR u_interface.u_gelu_fp32.u_synth_top.s2_b\[16\]
+ sky130_fd_sc_hd__dfxtp_1
X_10689_ _04194_ _04196_ _04316_ VGND VGND VPWR VPWR _04436_ sky130_fd_sc_hd__or3_1
X_12428_ _06153_ _06154_ VGND VGND VPWR VPWR _06155_ sky130_fd_sc_hd__and2_1
XFILLER_113_113 VGND VGND VPWR VPWR sky130_fd_sc_hd__decap_4
X_12359_ _06024_ _06085_ VGND VGND VPWR VPWR _06087_ sky130_fd_sc_hd__xnor2_1
XFILLER_153_293 VPWR VGND VPWR VGND sky130_ef_sc_hd__decap_12
XFILLER_99_369 VGND VGND VPWR VPWR sky130_fd_sc_hd__decap_6
XFILLER_101_308 VPWR VGND VPWR VGND sky130_ef_sc_hd__decap_12
X_14029_ clknet_leaf_50_clk net1662 VGND VGND VPWR VPWR u_interface.core_data_out\[15\]
+ sky130_fd_sc_hd__dfxtp_1
X_06920_ u_interface.u_gelu_fp32.u_synth_top.s1_x\[21\] net274 VGND VGND VPWR VPWR
+ _01457_ sky130_fd_sc_hd__xnor2_1
XFILLER_122_691 VGND VGND VPWR VPWR sky130_fd_sc_hd__fill_2
XTAP_TAPCELL_ROW_143_2625 VGND VPWR sky130_fd_sc_hd__tapvpwrvgnd_1
XFILLER_110_864 VGND VGND VPWR VPWR sky130_fd_sc_hd__decap_4
X_06851_ _01397_ _01398_ net731 VGND VGND VPWR VPWR _01399_ sky130_fd_sc_hd__mux2_1
XFILLER_56_918 VGND VGND VPWR VPWR sky130_fd_sc_hd__decap_3
X_06782_ u_interface.fifo_data\[8\]\[19\] u_interface.fifo_data\[9\]\[19\] u_interface.fifo_data\[10\]\[19\]
+ u_interface.fifo_data\[11\]\[19\] net767 net750 VGND VGND VPWR VPWR _01338_ sky130_fd_sc_hd__mux4_1
X_09570_ net589 net447 net442 net585 VGND VGND VPWR VPWR _03326_ sky130_fd_sc_hd__a22o_1
XFILLER_95_597 VGND VGND VPWR VPWR sky130_fd_sc_hd__decap_6
X_08521_ u_interface.u_gelu_fp32.u_synth_top.s3_mult\[63\] net525 VGND VGND VPWR VPWR
+ _02312_ sky130_fd_sc_hd__nor2_1
X_08452_ net527 u_interface.u_gelu_fp32.u_synth_top.s3_mult\[35\] VGND VGND VPWR VPWR
+ _02243_ sky130_fd_sc_hd__or2_1
XFILLER_24_837 VPWR VGND VPWR VGND sky130_ef_sc_hd__decap_12
XFILLER_36_697 VGND VGND VPWR VPWR sky130_fd_sc_hd__decap_3
X_07403_ net549 _01538_ VGND VGND VPWR VPWR _01540_ sky130_fd_sc_hd__nor2_1
XFILLER_50_111 VGND VGND VPWR VPWR sky130_fd_sc_hd__decap_4
XTAP_TAPCELL_ROW_63_1351 VGND VPWR sky130_fd_sc_hd__tapvpwrvgnd_1
XTAP_TAPCELL_ROW_63_1340 VGND VPWR sky130_fd_sc_hd__tapvpwrvgnd_1
X_08383_ u_interface.u_gelu_fp32.u_synth_top.s3_mult\[32\] u_interface.u_gelu_fp32.u_synth_top.s3_b\[16\]
+ VGND VGND VPWR VPWR _02174_ sky130_fd_sc_hd__nand2_1
XFILLER_23_369 VGND VGND VPWR VPWR sky130_fd_sc_hd__fill_1
XTAP_TAPCELL_ROW_34_876 VGND VPWR sky130_fd_sc_hd__tapvpwrvgnd_1
XFILLER_32_881 VPWR VGND VPWR VGND sky130_ef_sc_hd__decap_12
XTAP_TAPCELL_ROW_34_887 VGND VPWR sky130_fd_sc_hd__tapvpwrvgnd_1
X_07334_ net1423 net561 net253 VGND VGND VPWR VPWR _00364_ sky130_fd_sc_hd__mux2_1
X_07265_ net1248 net565 net252 VGND VGND VPWR VPWR _00297_ sky130_fd_sc_hd__mux2_1
XFILLER_136_238 VPWR VGND VPWR VGND sky130_ef_sc_hd__decap_12
X_09004_ _02761_ _02762_ _02469_ _02471_ VGND VGND VPWR VPWR _02763_ sky130_fd_sc_hd__a211o_1
XTAP_TAPCELL_ROW_154_2798 VGND VPWR sky130_fd_sc_hd__tapvpwrvgnd_1
X_07196_ net376 net1452 net258 VGND VGND VPWR VPWR _00236_ sky130_fd_sc_hd__mux2_1
Xgelu_top_861 VGND VGND VPWR VPWR gelu_top_861/HI s_axil_rdata[29] sky130_fd_sc_hd__conb_1
Xgelu_top_850 VGND VGND VPWR VPWR gelu_top_850/HI s_axil_rdata[18] sky130_fd_sc_hd__conb_1
XFILLER_132_411 VGND VGND VPWR VPWR sky130_fd_sc_hd__fill_2
XFILLER_104_102 VGND VGND VPWR VPWR sky130_fd_sc_hd__decap_6
XFILLER_132_444 VGND VGND VPWR VPWR sky130_fd_sc_hd__decap_4
XFILLER_132_466 VGND VGND VPWR VPWR sky130_fd_sc_hd__fill_2
Xfanout511 u_interface.u_gelu_fp32.u_synth_top.s2_dx\[2\] VGND VGND VPWR VPWR net511
+ sky130_fd_sc_hd__clkbuf_2
Xfanout500 net504 VGND VGND VPWR VPWR net500 sky130_fd_sc_hd__clkbuf_2
Xfanout533 net534 VGND VGND VPWR VPWR net533 sky130_fd_sc_hd__buf_2
X_09906_ net215 _03658_ VGND VGND VPWR VPWR _03659_ sky130_fd_sc_hd__xor2_1
Xfanout522 net523 VGND VGND VPWR VPWR net522 sky130_fd_sc_hd__buf_2
Xfanout555 net556 VGND VGND VPWR VPWR net555 sky130_fd_sc_hd__clkbuf_4
Xfanout544 net546 VGND VGND VPWR VPWR net544 sky130_fd_sc_hd__buf_2
XFILLER_116_78 VGND VGND VPWR VPWR sky130_fd_sc_hd__decap_6
Xfanout566 u_interface.core_data_out\[29\] VGND VGND VPWR VPWR net566 sky130_fd_sc_hd__buf_1
XFILLER_86_531 VGND VGND VPWR VPWR sky130_fd_sc_hd__fill_1
XFILLER_76_49 VPWR VGND VPWR VGND sky130_ef_sc_hd__decap_12
Xfanout599 net600 VGND VGND VPWR VPWR net599 sky130_fd_sc_hd__buf_2
XFILLER_112_190 VGND VGND VPWR VPWR sky130_fd_sc_hd__fill_1
Xfanout577 net578 VGND VGND VPWR VPWR net577 sky130_fd_sc_hd__clkbuf_2
XFILLER_101_853 VGND VGND VPWR VPWR sky130_fd_sc_hd__fill_1
XFILLER_100_352 VGND VGND VPWR VPWR sky130_fd_sc_hd__decap_4
X_09837_ _03587_ _03588_ _03589_ VGND VGND VPWR VPWR _03591_ sky130_fd_sc_hd__a21o_1
Xfanout588 net593 VGND VGND VPWR VPWR net588 sky130_fd_sc_hd__clkbuf_2
XFILLER_132_22 VGND VGND VPWR VPWR sky130_fd_sc_hd__decap_6
X_09768_ _03318_ _03319_ _03415_ _03416_ VGND VGND VPWR VPWR _03523_ sky130_fd_sc_hd__or4_1
XFILLER_100_363 VGND VGND VPWR VPWR sky130_fd_sc_hd__fill_1
XFILLER_58_277 VPWR VGND VPWR VGND sky130_ef_sc_hd__decap_12
XFILLER_46_428 VGND VGND VPWR VPWR sky130_fd_sc_hd__decap_8
X_08719_ _02472_ _02476_ _02477_ VGND VGND VPWR VPWR _02478_ sky130_fd_sc_hd__and3_1
XFILLER_26_130 VGND VGND VPWR VPWR sky130_fd_sc_hd__decap_8
XFILLER_27_653 VPWR VGND VPWR VGND sky130_ef_sc_hd__decap_12
X_09699_ _03447_ _03450_ _03451_ VGND VGND VPWR VPWR _03454_ sky130_fd_sc_hd__and3_1
XFILLER_26_141 VGND VGND VPWR VPWR sky130_fd_sc_hd__decap_8
XFILLER_26_163 VPWR VGND VPWR VGND sky130_ef_sc_hd__decap_12
XFILLER_27_697 VPWR VGND VPWR VGND sky130_ef_sc_hd__decap_12
X_11730_ _05464_ _05465_ VGND VGND VPWR VPWR _05467_ sky130_fd_sc_hd__xor2_1
XFILLER_42_601 VPWR VGND VPWR VGND sky130_ef_sc_hd__decap_12
XFILLER_14_325 VGND VGND VPWR VPWR sky130_fd_sc_hd__decap_4
XFILLER_41_111 VGND VGND VPWR VPWR sky130_fd_sc_hd__fill_1
X_11661_ _05397_ _05398_ VGND VGND VPWR VPWR _05399_ sky130_fd_sc_hd__xnor2_1
X_13400_ clknet_leaf_26_clk _00410_ VGND VGND VPWR VPWR u_interface.fifo_data\[6\]\[13\]
+ sky130_fd_sc_hd__dfxtp_1
X_10612_ _04353_ _04356_ _04357_ VGND VGND VPWR VPWR _04359_ sky130_fd_sc_hd__nand3_1
XTAP_TAPCELL_ROW_12_526 VGND VPWR sky130_fd_sc_hd__tapvpwrvgnd_1
X_11592_ _05256_ _05259_ _05260_ _05264_ VGND VGND VPWR VPWR _05330_ sky130_fd_sc_hd__a31o_1
XFILLER_128_717 VGND VGND VPWR VPWR sky130_fd_sc_hd__fill_1
X_10543_ _04281_ _04289_ VGND VGND VPWR VPWR _04291_ sky130_fd_sc_hd__xor2_1
X_13331_ clknet_leaf_72_clk _00341_ VGND VGND VPWR VPWR u_interface.fifo_data\[10\]\[8\]
+ sky130_fd_sc_hd__dfxtp_1
XFILLER_41_41 VPWR VGND VPWR VGND sky130_ef_sc_hd__decap_12
XFILLER_6_513 VPWR VGND VPWR VGND sky130_ef_sc_hd__decap_12
X_13262_ clknet_leaf_48_clk _00272_ VGND VGND VPWR VPWR u_interface.fifo_data\[0\]\[4\]
+ sky130_fd_sc_hd__dfxtp_1
X_10474_ _04201_ _04219_ _04220_ VGND VGND VPWR VPWR _04222_ sky130_fd_sc_hd__nand3_2
XFILLER_6_557 VPWR VGND VPWR VGND sky130_ef_sc_hd__decap_12
XTAP_TAPCELL_ROW_94_1845 VGND VPWR sky130_fd_sc_hd__tapvpwrvgnd_1
XTAP_TAPCELL_ROW_94_1834 VGND VPWR sky130_fd_sc_hd__tapvpwrvgnd_1
X_12213_ net202 _05881_ _05880_ VGND VGND VPWR VPWR _05943_ sky130_fd_sc_hd__o21a_1
X_13193_ clknet_leaf_74_clk _00203_ VGND VGND VPWR VPWR u_interface.fifo_data\[12\]\[3\]
+ sky130_fd_sc_hd__dfxtp_1
X_12144_ net198 _05874_ VGND VGND VPWR VPWR _05875_ sky130_fd_sc_hd__and2_1
XFILLER_123_477 VGND VGND VPWR VPWR sky130_fd_sc_hd__decap_3
XFILLER_111_617 VPWR VGND VPWR VGND sky130_ef_sc_hd__decap_12
XFILLER_150_285 VPWR VGND VPWR VGND sky130_ef_sc_hd__decap_12
XFILLER_110_138 VGND VGND VPWR VPWR sky130_fd_sc_hd__fill_2
XFILLER_1_273 VGND VGND VPWR VPWR sky130_fd_sc_hd__decap_6
X_12075_ net200 _05805_ VGND VGND VPWR VPWR _05807_ sky130_fd_sc_hd__xnor2_1
X_11026_ _04767_ _04768_ VGND VGND VPWR VPWR _04770_ sky130_fd_sc_hd__xnor2_1
XFILLER_37_406 VPWR VGND VPWR VGND sky130_ef_sc_hd__decap_12
XTAP_TAPCELL_ROW_125_2333 VGND VPWR sky130_fd_sc_hd__tapvpwrvgnd_1
XFILLER_66_71 VPWR VGND VPWR VGND sky130_ef_sc_hd__decap_12
XFILLER_49_288 VPWR VGND VPWR VGND sky130_ef_sc_hd__decap_12
X_12977_ _06466_ _06493_ VGND VGND VPWR VPWR _06494_ sky130_fd_sc_hd__or2_1
XFILLER_92_589 VGND VGND VPWR VPWR sky130_fd_sc_hd__fill_2
XFILLER_73_781 VGND VGND VPWR VPWR sky130_fd_sc_hd__decap_3
XFILLER_45_461 VPWR VGND VPWR VGND sky130_ef_sc_hd__decap_12
X_11928_ net214 _05580_ _05577_ VGND VGND VPWR VPWR _05662_ sky130_fd_sc_hd__a21o_1
X_11859_ _05588_ _05593_ VGND VGND VPWR VPWR _05594_ sky130_fd_sc_hd__nand2_1
XFILLER_32_155 VGND VGND VPWR VPWR sky130_fd_sc_hd__fill_2
XTAP_TAPCELL_ROW_103_1985 VGND VPWR sky130_fd_sc_hd__tapvpwrvgnd_1
XFILLER_60_475 VGND VGND VPWR VPWR sky130_fd_sc_hd__fill_1
XFILLER_14_881 VPWR VGND VPWR VGND sky130_ef_sc_hd__decap_12
XTAP_TAPCELL_ROW_31_824 VGND VPWR sky130_fd_sc_hd__tapvpwrvgnd_1
XTAP_TAPCELL_ROW_31_835 VGND VPWR sky130_fd_sc_hd__tapvpwrvgnd_1
XFILLER_118_205 VPWR VGND VPWR VGND sky130_ef_sc_hd__decap_12
X_13529_ clknet_leaf_71_clk _00539_ VGND VGND VPWR VPWR u_interface.fifo_data\[5\]\[8\]
+ sky130_fd_sc_hd__dfxtp_1
X_07050_ net1037 net383 net210 VGND VGND VPWR VPWR _00090_ sky130_fd_sc_hd__mux2_1
XFILLER_70_3 VPWR VGND VPWR VGND sky130_ef_sc_hd__decap_12
XFILLER_127_794 VGND VGND VPWR VPWR sky130_fd_sc_hd__decap_4
Xoutput114 net114 VGND VGND VPWR VPWR m_axis_tdata[14] sky130_fd_sc_hd__buf_2
Xoutput125 net125 VGND VGND VPWR VPWR m_axis_tdata[24] sky130_fd_sc_hd__buf_2
Xoutput147 net147 VGND VGND VPWR VPWR s_axil_rdata[0] sky130_fd_sc_hd__buf_2
XFILLER_114_433 VPWR VGND VPWR VGND sky130_ef_sc_hd__decap_12
Xoutput136 net136 VGND VGND VPWR VPWR m_axis_tdata[5] sky130_fd_sc_hd__buf_2
XFILLER_142_797 VGND VGND VPWR VPWR sky130_fd_sc_hd__decap_4
X_07952_ net1431 net1312 net819 VGND VGND VPWR VPWR _00681_ sky130_fd_sc_hd__mux2_1
XFILLER_101_138 VGND VGND VPWR VPWR sky130_fd_sc_hd__decap_3
X_07883_ net992 net351 net268 VGND VGND VPWR VPWR _00644_ sky130_fd_sc_hd__mux2_1
X_06903_ u_interface.u_gelu_fp32.u_synth_top.s1_x\[17\] _01184_ net286 VGND VGND VPWR
+ VPWR _01444_ sky130_fd_sc_hd__nand3_1
X_09622_ _03376_ _03377_ VGND VGND VPWR VPWR _03378_ sky130_fd_sc_hd__and2b_1
X_06834_ u_interface.fifo_data\[4\]\[25\] u_interface.fifo_data\[5\]\[25\] u_interface.fifo_data\[6\]\[25\]
+ u_interface.fifo_data\[7\]\[25\] net765 net748 VGND VGND VPWR VPWR _01384_ sky130_fd_sc_hd__mux4_1
XFILLER_83_512 VPWR VGND VPWR VGND sky130_ef_sc_hd__decap_12
XFILLER_55_225 VGND VGND VPWR VPWR sky130_fd_sc_hd__decap_6
XFILLER_55_214 VGND VGND VPWR VPWR sky130_fd_sc_hd__decap_8
XFILLER_28_417 VGND VGND VPWR VPWR sky130_fd_sc_hd__decap_3
X_09553_ _03210_ _03307_ _03308_ VGND VGND VPWR VPWR _03310_ sky130_fd_sc_hd__nand3_2
XFILLER_55_247 VGND VGND VPWR VPWR sky130_fd_sc_hd__fill_2
XTAP_TAPCELL_ROW_39_957 VGND VPWR sky130_fd_sc_hd__tapvpwrvgnd_1
X_06765_ u_interface.fifo_data\[8\]\[17\] u_interface.fifo_data\[9\]\[17\] u_interface.fifo_data\[10\]\[17\]
+ u_interface.fifo_data\[11\]\[17\] net763 net746 VGND VGND VPWR VPWR _01323_ sky130_fd_sc_hd__mux4_1
XFILLER_102_25 VGND VGND VPWR VPWR sky130_fd_sc_hd__decap_3
XFILLER_71_729 VGND VGND VPWR VPWR sky130_fd_sc_hd__decap_3
XFILLER_70_217 VGND VGND VPWR VPWR sky130_fd_sc_hd__fill_1
X_08504_ _02291_ _02294_ VGND VGND VPWR VPWR _02295_ sky130_fd_sc_hd__or2_1
X_09484_ _03228_ _03239_ VGND VGND VPWR VPWR _03241_ sky130_fd_sc_hd__xnor2_1
X_06696_ net729 _01260_ net725 VGND VGND VPWR VPWR _01263_ sky130_fd_sc_hd__o21a_1
XFILLER_23_111 VGND VGND VPWR VPWR sky130_fd_sc_hd__fill_1
XFILLER_24_645 VPWR VGND VPWR VGND sky130_ef_sc_hd__decap_12
X_08435_ _02195_ _02225_ VGND VGND VPWR VPWR _02226_ sky130_fd_sc_hd__nand2_1
XFILLER_62_29 VGND VGND VPWR VPWR sky130_fd_sc_hd__decap_4
X_08366_ net524 u_interface.u_gelu_fp32.u_synth_top.s3_mult\[56\] VGND VGND VPWR VPWR
+ _02157_ sky130_fd_sc_hd__xor2_2
XFILLER_137_503 VGND VGND VPWR VPWR sky130_fd_sc_hd__fill_1
X_07317_ net1039 net357 net255 VGND VGND VPWR VPWR _00347_ sky130_fd_sc_hd__mux2_1
X_08297_ net530 net1597 _02104_ net799 VGND VGND VPWR VPWR _02106_ sky130_fd_sc_hd__a31o_1
X_07248_ net1428 net360 net249 VGND VGND VPWR VPWR _00280_ sky130_fd_sc_hd__mux2_1
X_07179_ net1206 net347 net264 VGND VGND VPWR VPWR _00219_ sky130_fd_sc_hd__mux2_1
XFILLER_11_55 VGND VGND VPWR VPWR sky130_fd_sc_hd__fill_1
XFILLER_3_505 VPWR VGND VPWR VGND sky130_ef_sc_hd__decap_12
XFILLER_87_15 VPWR VGND VPWR VGND sky130_ef_sc_hd__decap_12
X_10190_ _03790_ _03798_ _03797_ VGND VGND VPWR VPWR _03941_ sky130_fd_sc_hd__a21bo_1
XTAP_TAPCELL_ROW_76_1553 VGND VPWR sky130_fd_sc_hd__tapvpwrvgnd_1
XFILLER_133_797 VPWR VGND VPWR VGND sky130_ef_sc_hd__decap_12
XFILLER_132_263 VGND VGND VPWR VPWR sky130_fd_sc_hd__fill_1
Xfanout341 u_interface.core_data_out\[22\] VGND VGND VPWR VPWR net341 sky130_fd_sc_hd__buf_1
XFILLER_120_425 VGND VGND VPWR VPWR sky130_fd_sc_hd__decap_3
Xfanout330 net331 VGND VGND VPWR VPWR net330 sky130_fd_sc_hd__buf_2
Xfanout352 u_interface.core_data_out\[16\] VGND VGND VPWR VPWR net352 sky130_fd_sc_hd__clkbuf_2
Xfanout363 u_interface.core_data_out\[11\] VGND VGND VPWR VPWR net363 sky130_fd_sc_hd__buf_1
Xfanout374 u_interface.core_data_out\[5\] VGND VGND VPWR VPWR net374 sky130_fd_sc_hd__clkbuf_2
X_12900_ net787 net907 VGND VGND VPWR VPWR _01042_ sky130_fd_sc_hd__and2_1
X_13880_ clknet_leaf_4_clk _00033_ VGND VGND VPWR VPWR u_interface.u_gelu_fp32.u_synth_top.s2_dx\[16\]
+ sky130_fd_sc_hd__dfxtp_1
XFILLER_86_372 VGND VGND VPWR VPWR sky130_fd_sc_hd__fill_1
Xfanout385 u_interface.core_data_out\[0\] VGND VGND VPWR VPWR net385 sky130_fd_sc_hd__buf_1
Xfanout396 u_interface.u_gelu_fp32.u_synth_top.s2_dx\[29\] VGND VGND VPWR VPWR net396
+ sky130_fd_sc_hd__clkbuf_4
XTAP_TAPCELL_ROW_107_2052 VGND VPWR sky130_fd_sc_hd__tapvpwrvgnd_1
XTAP_TAPCELL_ROW_107_2041 VGND VPWR sky130_fd_sc_hd__tapvpwrvgnd_1
X_12831_ net331 _06316_ net781 VGND VGND VPWR VPWR _00989_ sky130_fd_sc_hd__mux2_1
XFILLER_86_394 VGND VGND VPWR VPWR sky130_fd_sc_hd__fill_2
XTAP_TAPCELL_ROW_17_607 VGND VPWR sky130_fd_sc_hd__tapvpwrvgnd_1
XFILLER_27_461 VGND VGND VPWR VPWR sky130_fd_sc_hd__decap_6
XFILLER_36_41 VGND VGND VPWR VPWR sky130_fd_sc_hd__decap_3
X_12762_ _01775_ net297 _06397_ VGND VGND VPWR VPWR _00941_ sky130_fd_sc_hd__and3b_1
XFILLER_36_85 VGND VGND VPWR VPWR sky130_fd_sc_hd__decap_4
XTAP_TAPCELL_ROW_120_2263 VGND VPWR sky130_fd_sc_hd__tapvpwrvgnd_1
XTAP_TAPCELL_ROW_120_2252 VGND VPWR sky130_fd_sc_hd__tapvpwrvgnd_1
X_12693_ u_interface.u_gelu_fp32.u_q16_to_fp32.s2_clz\[3\] _01709_ net288 VGND VGND
+ VPWR VPWR _06352_ sky130_fd_sc_hd__o21ai_1
XFILLER_14_133 VGND VGND VPWR VPWR sky130_fd_sc_hd__decap_6
X_11713_ net642 net394 _05367_ _05366_ VGND VGND VPWR VPWR _05450_ sky130_fd_sc_hd__a31o_1
XFILLER_14_177 VGND VGND VPWR VPWR sky130_fd_sc_hd__fill_1
XFILLER_30_637 VGND VGND VPWR VPWR sky130_fd_sc_hd__decap_6
X_11644_ _05380_ _05381_ VGND VGND VPWR VPWR _05382_ sky130_fd_sc_hd__or2_1
XFILLER_42_475 VGND VGND VPWR VPWR sky130_fd_sc_hd__fill_1
Xinput27 s_axil_araddr[31] VGND VGND VPWR VPWR net27 sky130_fd_sc_hd__clkbuf_1
Xinput16 s_axil_araddr[21] VGND VGND VPWR VPWR net16 sky130_fd_sc_hd__clkbuf_1
XFILLER_155_300 VGND VGND VPWR VPWR sky130_fd_sc_hd__decap_4
X_11575_ _05307_ _05312_ _05313_ VGND VGND VPWR VPWR _00828_ sky130_fd_sc_hd__o21a_1
XFILLER_7_833 VGND VGND VPWR VPWR sky130_fd_sc_hd__decap_6
XFILLER_11_895 VGND VGND VPWR VPWR sky130_fd_sc_hd__fill_1
Xinput49 s_axil_awaddr[21] VGND VGND VPWR VPWR net49 sky130_fd_sc_hd__clkbuf_1
Xinput38 s_axil_awaddr[11] VGND VGND VPWR VPWR net38 sky130_fd_sc_hd__clkbuf_1
X_13314_ clknet_leaf_52_clk _00324_ VGND VGND VPWR VPWR u_interface.fifo_data\[8\]\[23\]
+ sky130_fd_sc_hd__dfxtp_1
X_10526_ _04272_ _04273_ _04149_ VGND VGND VPWR VPWR _04274_ sky130_fd_sc_hd__a21o_1
XFILLER_7_877 VPWR VGND VPWR VGND sky130_ef_sc_hd__decap_12
XFILLER_143_528 VGND VGND VPWR VPWR sky130_fd_sc_hd__fill_1
X_13245_ clknet_leaf_52_clk _00255_ VGND VGND VPWR VPWR u_interface.fifo_data\[11\]\[23\]
+ sky130_fd_sc_hd__dfxtp_1
X_10457_ _04111_ _04119_ _04120_ VGND VGND VPWR VPWR _04205_ sky130_fd_sc_hd__a21o_1
XFILLER_6_365 VGND VGND VPWR VPWR sky130_fd_sc_hd__fill_1
XFILLER_108_293 VGND VGND VPWR VPWR sky130_fd_sc_hd__decap_3
XFILLER_151_561 VGND VGND VPWR VPWR sky130_fd_sc_hd__decap_6
XFILLER_123_263 VGND VGND VPWR VPWR sky130_fd_sc_hd__fill_1
XFILLER_123_241 VGND VGND VPWR VPWR sky130_fd_sc_hd__fill_1
X_13176_ clknet_leaf_50_clk _00186_ VGND VGND VPWR VPWR u_interface.fifo_data\[9\]\[18\]
+ sky130_fd_sc_hd__dfxtp_1
X_10388_ _04122_ _04134_ _04135_ VGND VGND VPWR VPWR _04137_ sky130_fd_sc_hd__nor3_1
XFILLER_69_317 VGND VGND VPWR VPWR sky130_fd_sc_hd__fill_1
X_12127_ _05857_ _05858_ VGND VGND VPWR VPWR _05859_ sky130_fd_sc_hd__nor2_1
XFILLER_84_309 VPWR VGND VPWR VGND sky130_ef_sc_hd__decap_12
X_12058_ _05789_ _05790_ VGND VGND VPWR VPWR _05791_ sky130_fd_sc_hd__nand2_1
X_11009_ net602 net611 net404 net400 VGND VGND VPWR VPWR _04753_ sky130_fd_sc_hd__and4_1
XFILLER_37_225 VGND VGND VPWR VPWR sky130_fd_sc_hd__decap_6
XFILLER_37_247 VPWR VGND VPWR VGND sky130_ef_sc_hd__decap_12
XFILLER_53_729 VGND VGND VPWR VPWR sky130_fd_sc_hd__decap_3
XTAP_TAPCELL_ROW_36_905 VGND VPWR sky130_fd_sc_hd__tapvpwrvgnd_1
XTAP_TAPCELL_ROW_36_916 VGND VPWR sky130_fd_sc_hd__tapvpwrvgnd_1
X_06550_ _01144_ _01145_ VGND VGND VPWR VPWR _01146_ sky130_fd_sc_hd__nor2_1
XFILLER_93_80 VGND VGND VPWR VPWR sky130_fd_sc_hd__decap_8
X_08220_ _02047_ _02049_ net289 VGND VGND VPWR VPWR _02050_ sky130_fd_sc_hd__o21ba_1
XTAP_TAPCELL_ROW_43_1029 VGND VPWR sky130_fd_sc_hd__tapvpwrvgnd_1
XTAP_TAPCELL_ROW_43_1018 VGND VPWR sky130_fd_sc_hd__tapvpwrvgnd_1
XTAP_TAPCELL_ROW_138_2546 VGND VPWR sky130_fd_sc_hd__tapvpwrvgnd_1
X_08151_ net293 _01991_ VGND VGND VPWR VPWR _00726_ sky130_fd_sc_hd__nor2_1
XFILLER_146_344 VGND VGND VPWR VPWR sky130_fd_sc_hd__decap_4
X_08082_ _01932_ _01933_ VGND VGND VPWR VPWR _01934_ sky130_fd_sc_hd__xnor2_1
X_07102_ net1142 net343 net225 VGND VGND VPWR VPWR _00142_ sky130_fd_sc_hd__mux2_1
XFILLER_9_181 VGND VGND VPWR VPWR sky130_fd_sc_hd__decap_4
XTAP_TAPCELL_ROW_151_2757 VGND VPWR sky130_fd_sc_hd__tapvpwrvgnd_1
XTAP_TAPCELL_ROW_151_2746 VGND VPWR sky130_fd_sc_hd__tapvpwrvgnd_1
X_07033_ net999 net353 net271 VGND VGND VPWR VPWR _00073_ sky130_fd_sc_hd__mux2_1
XTAP_TAPCELL_ROW_58_1261 VGND VPWR sky130_fd_sc_hd__tapvpwrvgnd_1
X_08984_ _02739_ _02742_ VGND VGND VPWR VPWR _02743_ sky130_fd_sc_hd__nand2b_1
XFILLER_130_734 VGND VGND VPWR VPWR sky130_fd_sc_hd__decap_4
XFILLER_114_285 VGND VGND VPWR VPWR sky130_fd_sc_hd__fill_2
X_07935_ _01809_ _01816_ _01827_ net775 VGND VGND VPWR VPWR _01828_ sky130_fd_sc_hd__o31a_1
XFILLER_87_169 VPWR VGND VPWR VGND sky130_ef_sc_hd__decap_12
XTAP_TAPCELL_ROW_71_1472 VGND VPWR sky130_fd_sc_hd__tapvpwrvgnd_1
XFILLER_84_810 VGND VGND VPWR VPWR sky130_fd_sc_hd__fill_2
XFILLER_110_491 VGND VGND VPWR VPWR sky130_fd_sc_hd__fill_1
X_09605_ _03357_ _03358_ _03280_ _03298_ VGND VGND VPWR VPWR _03361_ sky130_fd_sc_hd__a211o_1
XFILLER_83_331 VGND VGND VPWR VPWR sky130_fd_sc_hd__decap_4
X_07866_ net976 net385 net266 VGND VGND VPWR VPWR _00627_ sky130_fd_sc_hd__mux2_1
X_06817_ u_interface.fifo_data\[0\]\[23\] u_interface.fifo_data\[1\]\[23\] u_interface.fifo_data\[2\]\[23\]
+ u_interface.fifo_data\[3\]\[23\] net763 net746 VGND VGND VPWR VPWR _01369_ sky130_fd_sc_hd__mux4_1
XFILLER_113_57 VGND VGND VPWR VPWR sky130_fd_sc_hd__decap_3
X_07797_ net1025 net569 net234 VGND VGND VPWR VPWR _00558_ sky130_fd_sc_hd__mux2_1
XFILLER_71_515 VGND VGND VPWR VPWR sky130_fd_sc_hd__fill_2
XFILLER_56_589 VGND VGND VPWR VPWR sky130_fd_sc_hd__decap_6
XFILLER_44_707 VPWR VGND VPWR VGND sky130_ef_sc_hd__decap_12
XTAP_TAPCELL_ROW_3_379 VGND VPWR sky130_fd_sc_hd__tapvpwrvgnd_1
X_06748_ _01304_ _01305_ _01308_ net318 VGND VGND VPWR VPWR net114 sky130_fd_sc_hd__a22o_1
X_09536_ _03290_ _03291_ _03292_ VGND VGND VPWR VPWR _03293_ sky130_fd_sc_hd__a21oi_1
XFILLER_43_239 VGND VGND VPWR VPWR sky130_fd_sc_hd__decap_8
X_09467_ net826 _03224_ VGND VGND VPWR VPWR _00809_ sky130_fd_sc_hd__nor2_1
XFILLER_52_740 VGND VGND VPWR VPWR sky130_fd_sc_hd__fill_1
X_08418_ u_interface.u_gelu_fp32.u_synth_top.s3_mult\[18\] u_interface.u_gelu_fp32.u_synth_top.s3_b\[2\]
+ VGND VGND VPWR VPWR _02209_ sky130_fd_sc_hd__nand2_1
XFILLER_12_637 VGND VGND VPWR VPWR sky130_fd_sc_hd__decap_6
XFILLER_24_475 VGND VGND VPWR VPWR sky130_fd_sc_hd__fill_1
X_06679_ u_interface.fifo_data\[12\]\[6\] u_interface.fifo_data\[13\]\[6\] u_interface.fifo_data\[14\]\[6\]
+ u_interface.fifo_data\[15\]\[6\] net756 net739 VGND VGND VPWR VPWR _01248_ sky130_fd_sc_hd__mux4_1
X_09398_ net462 net599 _02633_ _02632_ VGND VGND VPWR VPWR _03156_ sky130_fd_sc_hd__a31oi_1
XFILLER_11_125 VPWR VGND VPWR VGND sky130_ef_sc_hd__decap_12
XFILLER_11_169 VPWR VGND VPWR VGND sky130_ef_sc_hd__decap_12
X_08349_ net528 net1632 _02143_ net797 VGND VGND VPWR VPWR _02145_ sky130_fd_sc_hd__a31o_1
XPHY_EDGE_ROW_129_Right_129 VGND VGND VPWR VPWR sky130_fd_sc_hd__decap_3
X_11360_ _05098_ _05099_ VGND VGND VPWR VPWR _05101_ sky130_fd_sc_hd__xor2_2
XFILLER_20_681 VPWR VGND VPWR VGND sky130_ef_sc_hd__decap_12
XFILLER_22_65 VPWR VGND VPWR VGND sky130_ef_sc_hd__decap_12
XTAP_TAPCELL_ROW_22_687 VGND VPWR sky130_fd_sc_hd__tapvpwrvgnd_1
XFILLER_153_815 VGND VGND VPWR VPWR sky130_fd_sc_hd__fill_1
XFILLER_118_3 VGND VGND VPWR VPWR sky130_fd_sc_hd__decap_6
X_10311_ _04059_ _04060_ _03944_ VGND VGND VPWR VPWR _04061_ sky130_fd_sc_hd__a21oi_1
XFILLER_4_825 VPWR VGND VPWR VGND sky130_ef_sc_hd__decap_12
X_13030_ net1639 _01532_ _01534_ VGND VGND VPWR VPWR _01048_ sky130_fd_sc_hd__o21a_1
XFILLER_106_742 VGND VGND VPWR VPWR sky130_fd_sc_hd__decap_3
X_11291_ _04947_ _04949_ _04948_ VGND VGND VPWR VPWR _05032_ sky130_fd_sc_hd__o21ba_1
XFILLER_4_869 VPWR VGND VPWR VGND sky130_ef_sc_hd__decap_12
XFILLER_3_335 VGND VGND VPWR VPWR sky130_fd_sc_hd__fill_1
XFILLER_133_561 VGND VGND VPWR VPWR sky130_fd_sc_hd__decap_4
XFILLER_105_241 VPWR VGND VPWR VGND sky130_ef_sc_hd__decap_12
X_10242_ _03990_ _03991_ net190 VGND VGND VPWR VPWR _03992_ sky130_fd_sc_hd__a21o_1
XFILLER_79_615 VGND VGND VPWR VPWR sky130_fd_sc_hd__fill_1
XFILLER_0_3 VPWR VGND VPWR VGND sky130_ef_sc_hd__decap_12
XFILLER_154_53 VGND VGND VPWR VPWR sky130_fd_sc_hd__fill_2
XFILLER_121_745 VGND VGND VPWR VPWR sky130_fd_sc_hd__fill_1
XFILLER_121_723 VGND VGND VPWR VPWR sky130_fd_sc_hd__decap_4
XFILLER_120_211 VPWR VGND VPWR VGND sky130_ef_sc_hd__decap_12
X_10173_ net579 net586 net423 net418 VGND VGND VPWR VPWR _03924_ sky130_fd_sc_hd__and4_1
XFILLER_120_244 VGND VGND VPWR VPWR sky130_fd_sc_hd__decap_8
XFILLER_78_169 VPWR VGND VPWR VGND sky130_ef_sc_hd__decap_12
XFILLER_66_309 VPWR VGND VPWR VGND sky130_ef_sc_hd__decap_12
XFILLER_93_106 VGND VGND VPWR VPWR sky130_fd_sc_hd__decap_6
XFILLER_47_512 VGND VGND VPWR VPWR sky130_fd_sc_hd__decap_4
Xfanout160 _06278_ VGND VGND VPWR VPWR net160 sky130_fd_sc_hd__buf_2
Xfanout182 _05024_ VGND VGND VPWR VPWR net182 sky130_fd_sc_hd__buf_4
XFILLER_101_480 VGND VGND VPWR VPWR sky130_fd_sc_hd__fill_1
X_13932_ clknet_leaf_7_clk _00017_ VGND VGND VPWR VPWR u_interface.u_gelu_fp32.u_synth_top.s1_hits\[4\]
+ sky130_fd_sc_hd__dfxtp_1
XTAP_TAPCELL_ROW_89_1766 VGND VPWR sky130_fd_sc_hd__tapvpwrvgnd_1
XTAP_TAPCELL_ROW_89_1755 VGND VPWR sky130_fd_sc_hd__tapvpwrvgnd_1
XFILLER_86_191 VGND VGND VPWR VPWR sky130_fd_sc_hd__decap_4
Xfanout193 net194 VGND VGND VPWR VPWR net193 sky130_fd_sc_hd__clkbuf_4
XFILLER_19_225 VGND VGND VPWR VPWR sky130_fd_sc_hd__fill_2
X_13863_ clknet_leaf_4_clk u_interface.u_gelu_fp32.u_synth_top.comb_b\[18\] VGND VGND
+ VPWR VPWR u_interface.u_gelu_fp32.u_synth_top.s2_b\[18\] sky130_fd_sc_hd__dfxtp_1
XFILLER_75_887 VGND VGND VPWR VPWR sky130_fd_sc_hd__fill_1
XFILLER_35_718 VGND VGND VPWR VPWR sky130_fd_sc_hd__decap_8
X_12814_ net778 net104 VGND VGND VPWR VPWR _00972_ sky130_fd_sc_hd__and2_1
XFILLER_28_781 VPWR VGND VPWR VGND sky130_ef_sc_hd__decap_12
X_13794_ clknet_leaf_80_clk _00804_ VGND VGND VPWR VPWR u_interface.u_gelu_fp32.s2_data\[28\]
+ sky130_fd_sc_hd__dfxtp_1
X_12745_ net807 u_interface.u_gelu_fp32.u_q16_to_fp32.s3_norm_mag\[30\] net280 _06365_
+ VGND VGND VPWR VPWR _06393_ sky130_fd_sc_hd__a22o_1
XFILLER_62_559 VGND VGND VPWR VPWR sky130_fd_sc_hd__decap_6
XFILLER_42_261 VGND VGND VPWR VPWR sky130_fd_sc_hd__fill_1
XTAP_TAPCELL_ROW_100_1933 VGND VPWR sky130_fd_sc_hd__tapvpwrvgnd_1
X_12676_ u_interface.u_gelu_fp32.u_q16_to_fp32.s1_is_zero net781 VGND VGND VPWR VPWR
+ _00912_ sky130_fd_sc_hd__and2_1
XFILLER_15_497 VGND VGND VPWR VPWR sky130_fd_sc_hd__decap_6
XFILLER_30_456 VGND VGND VPWR VPWR sky130_fd_sc_hd__fill_1
X_11627_ net633 net389 VGND VGND VPWR VPWR _05365_ sky130_fd_sc_hd__nand2_1
XTAP_TAPCELL_ROW_41_985 VGND VPWR sky130_fd_sc_hd__tapvpwrvgnd_1
XFILLER_155_141 VGND VGND VPWR VPWR sky130_fd_sc_hd__fill_2
XFILLER_128_333 VGND VGND VPWR VPWR sky130_fd_sc_hd__decap_6
X_11558_ _05127_ _05202_ _05201_ VGND VGND VPWR VPWR _05297_ sky130_fd_sc_hd__a21boi_1
XFILLER_7_641 VPWR VGND VPWR VGND sky130_ef_sc_hd__decap_12
XTAP_TAPCELL_ROW_41_996 VGND VPWR sky130_fd_sc_hd__tapvpwrvgnd_1
Xhold608 u_interface.fifo_data\[15\]\[26\] VGND VGND VPWR VPWR net1473 sky130_fd_sc_hd__dlygate4sd3_1
X_10509_ _04223_ _04254_ _04255_ VGND VGND VPWR VPWR _04257_ sky130_fd_sc_hd__nand3_1
XFILLER_7_685 VPWR VGND VPWR VGND sky130_ef_sc_hd__decap_12
XTAP_TAPCELL_ROW_133_2465 VGND VPWR sky130_fd_sc_hd__tapvpwrvgnd_1
Xhold619 u_interface.fifo_data\[11\]\[9\] VGND VGND VPWR VPWR net1484 sky130_fd_sc_hd__dlygate4sd3_1
X_11489_ _05225_ _05227_ VGND VGND VPWR VPWR _05228_ sky130_fd_sc_hd__xor2_1
XFILLER_6_195 VGND VGND VPWR VPWR sky130_fd_sc_hd__fill_1
XFILLER_112_701 VGND VGND VPWR VPWR sky130_fd_sc_hd__fill_1
X_13228_ clknet_leaf_75_clk _00238_ VGND VGND VPWR VPWR u_interface.fifo_data\[11\]\[6\]
+ sky130_fd_sc_hd__dfxtp_1
XFILLER_112_734 VGND VGND VPWR VPWR sky130_fd_sc_hd__fill_1
X_13159_ clknet_leaf_54_clk _00169_ VGND VGND VPWR VPWR u_interface.fifo_data\[9\]\[1\]
+ sky130_fd_sc_hd__dfxtp_1
XFILLER_33_3 VPWR VGND VPWR VGND sky130_ef_sc_hd__decap_12
XFILLER_151_391 VGND VGND VPWR VPWR sky130_fd_sc_hd__fill_1
X_07720_ u_interface.u_gelu_fp32.u_synth_top.s1_hits\[13\] net386 u_interface.u_gelu_fp32.u_synth_top.s1_hits\[4\]
+ u_interface.u_gelu_fp32.u_synth_top.s1_hits\[2\] VGND VGND VPWR VPWR _01771_ sky130_fd_sc_hd__or4_1
XFILLER_85_629 VGND VGND VPWR VPWR sky130_fd_sc_hd__fill_1
XFILLER_69_169 VGND VGND VPWR VPWR sky130_fd_sc_hd__decap_4
XTAP_TAPCELL_ROW_53_1191 VGND VPWR sky130_fd_sc_hd__tapvpwrvgnd_1
XTAP_TAPCELL_ROW_53_1180 VGND VPWR sky130_fd_sc_hd__tapvpwrvgnd_1
X_07651_ _01735_ _01724_ net330 VGND VGND VPWR VPWR _01736_ sky130_fd_sc_hd__mux2_1
XTAP_TAPCELL_ROW_0_316 VGND VPWR sky130_fd_sc_hd__tapvpwrvgnd_1
XTAP_TAPCELL_ROW_0_327 VGND VPWR sky130_fd_sc_hd__tapvpwrvgnd_1
XFILLER_38_589 VPWR VGND VPWR VGND sky130_ef_sc_hd__decap_12
X_07582_ net310 _01640_ VGND VGND VPWR VPWR _01688_ sky130_fd_sc_hd__and2_1
X_06602_ net535 _01174_ _01180_ _01182_ VGND VGND VPWR VPWR _00015_ sky130_fd_sc_hd__and4_1
XFILLER_92_161 VPWR VGND VPWR VGND sky130_ef_sc_hd__decap_12
XTAP_TAPCELL_ROW_0_338 VGND VPWR sky130_fd_sc_hd__tapvpwrvgnd_1
XFILLER_25_239 VGND VGND VPWR VPWR sky130_fd_sc_hd__decap_6
X_09321_ _03074_ _03079_ VGND VGND VPWR VPWR _03080_ sky130_fd_sc_hd__nor2_1
X_06533_ _01130_ _01131_ VGND VGND VPWR VPWR _00023_ sky130_fd_sc_hd__nand2_1
XFILLER_80_345 VGND VGND VPWR VPWR sky130_fd_sc_hd__decap_4
XFILLER_53_559 VGND VGND VPWR VPWR sky130_fd_sc_hd__fill_1
XFILLER_40_209 VGND VGND VPWR VPWR sky130_fd_sc_hd__fill_1
X_09252_ net623 net630 net513 net518 VGND VGND VPWR VPWR _03011_ sky130_fd_sc_hd__and4_1
X_09183_ _02939_ _02940_ _02925_ VGND VGND VPWR VPWR _02942_ sky130_fd_sc_hd__a21o_1
XFILLER_147_620 VGND VGND VPWR VPWR sky130_fd_sc_hd__decap_8
XFILLER_138_119 VPWR VGND VPWR VGND sky130_ef_sc_hd__decap_12
XFILLER_119_300 VGND VGND VPWR VPWR sky130_fd_sc_hd__fill_2
X_08203_ _01890_ _02034_ VGND VGND VPWR VPWR _02035_ sky130_fd_sc_hd__nand2b_1
XFILLER_119_322 VGND VGND VPWR VPWR sky130_fd_sc_hd__fill_2
X_08134_ _01883_ _01976_ VGND VGND VPWR VPWR _01977_ sky130_fd_sc_hd__nor2_1
XFILLER_134_303 VGND VGND VPWR VPWR sky130_fd_sc_hd__decap_4
XFILLER_107_517 VGND VGND VPWR VPWR sky130_fd_sc_hd__fill_2
X_08065_ net169 _01919_ net163 VGND VGND VPWR VPWR _01920_ sky130_fd_sc_hd__a21oi_1
X_07016_ net1187 net325 net220 VGND VGND VPWR VPWR _00056_ sky130_fd_sc_hd__mux2_1
XFILLER_108_68 VPWR VGND VPWR VGND sky130_ef_sc_hd__decap_12
XTAP_TAPCELL_ROW_73_1501 VGND VPWR sky130_fd_sc_hd__tapvpwrvgnd_1
XFILLER_0_305 VGND VGND VPWR VPWR sky130_fd_sc_hd__decap_3
XFILLER_1_839 VGND VGND VPWR VPWR sky130_fd_sc_hd__fill_1
XFILLER_102_233 VGND VGND VPWR VPWR sky130_fd_sc_hd__fill_1
XFILLER_0_349 VPWR VGND VPWR VGND sky130_ef_sc_hd__decap_12
X_08967_ net606 net487 net493 net613 VGND VGND VPWR VPWR _02726_ sky130_fd_sc_hd__a22oi_1
XFILLER_130_586 VGND VGND VPWR VPWR sky130_fd_sc_hd__fill_2
XFILLER_124_45 VGND VGND VPWR VPWR sky130_fd_sc_hd__fill_2
XFILLER_57_821 VGND VGND VPWR VPWR sky130_fd_sc_hd__decap_6
XFILLER_48_309 VGND VGND VPWR VPWR sky130_fd_sc_hd__decap_8
X_07918_ u_interface.u_gelu_fp32.u_fp32_to_q16.s1_exp\[5\] u_interface.u_gelu_fp32.u_fp32_to_q16.s1_exp\[4\]
+ _01811_ VGND VGND VPWR VPWR _01812_ sky130_fd_sc_hd__nor3_1
XFILLER_124_67 VGND VGND VPWR VPWR sky130_fd_sc_hd__fill_1
X_08898_ _02622_ _02655_ VGND VGND VPWR VPWR _02657_ sky130_fd_sc_hd__and2_1
XFILLER_84_38 VGND VGND VPWR VPWR sky130_fd_sc_hd__decap_4
XTAP_TAPCELL_ROW_104_2000 VGND VPWR sky130_fd_sc_hd__tapvpwrvgnd_1
X_07849_ net355 net1405 net283 VGND VGND VPWR VPWR _00610_ sky130_fd_sc_hd__mux2_1
XFILLER_17_729 VPWR VGND VPWR VGND sky130_ef_sc_hd__decap_12
X_10860_ net644 net652 net431 net426 VGND VGND VPWR VPWR _04605_ sky130_fd_sc_hd__and4_1
X_09519_ _03272_ _03275_ VGND VGND VPWR VPWR _03276_ sky130_fd_sc_hd__xnor2_1
XTAP_TAPCELL_ROW_27_768 VGND VPWR sky130_fd_sc_hd__tapvpwrvgnd_1
XTAP_TAPCELL_ROW_84_1685 VGND VPWR sky130_fd_sc_hd__tapvpwrvgnd_1
XTAP_TAPCELL_ROW_84_1674 VGND VPWR sky130_fd_sc_hd__tapvpwrvgnd_1
XFILLER_71_378 VGND VGND VPWR VPWR sky130_fd_sc_hd__fill_1
X_10791_ _04536_ VGND VGND VPWR VPWR _04537_ sky130_fd_sc_hd__inv_2
XFILLER_40_710 VGND VGND VPWR VPWR sky130_fd_sc_hd__fill_1
X_12530_ _06227_ _06230_ _06253_ VGND VGND VPWR VPWR _06254_ sky130_fd_sc_hd__o21a_1
XFILLER_24_283 VGND VGND VPWR VPWR sky130_fd_sc_hd__fill_1
XFILLER_149_53 VGND VGND VPWR VPWR sky130_fd_sc_hd__decap_3
X_12461_ _06019_ _06139_ VGND VGND VPWR VPWR _06187_ sky130_fd_sc_hd__and2b_1
XFILLER_8_438 VGND VGND VPWR VPWR sky130_fd_sc_hd__decap_4
X_11412_ _05150_ _05151_ _05149_ VGND VGND VPWR VPWR _05152_ sky130_fd_sc_hd__a21o_1
XFILLER_153_612 VGND VGND VPWR VPWR sky130_fd_sc_hd__decap_4
X_14131_ clknet_leaf_29_clk _01057_ VGND VGND VPWR VPWR u_interface.in_flight_count\[4\]
+ sky130_fd_sc_hd__dfxtp_1
XFILLER_126_837 VGND VGND VPWR VPWR sky130_fd_sc_hd__fill_2
X_12392_ _06052_ _06055_ _06118_ VGND VGND VPWR VPWR _06120_ sky130_fd_sc_hd__a21oi_1
XFILLER_152_111 VGND VGND VPWR VPWR sky130_fd_sc_hd__fill_2
XTAP_TAPCELL_ROW_115_2173 VGND VPWR sky130_fd_sc_hd__tapvpwrvgnd_1
X_11343_ net611 net392 VGND VGND VPWR VPWR _05084_ sky130_fd_sc_hd__nand2_1
XFILLER_106_550 VPWR VGND VPWR VGND sky130_ef_sc_hd__decap_12
X_14062_ clknet_leaf_56_clk _00988_ VGND VGND VPWR VPWR u_interface.u_gelu_fp32.u_q16_to_fp32.s2_clz\[1\]
+ sky130_fd_sc_hd__dfxtp_1
X_11274_ _05013_ _05014_ VGND VGND VPWR VPWR _05016_ sky130_fd_sc_hd__xor2_1
XFILLER_106_594 VPWR VGND VPWR VGND sky130_ef_sc_hd__decap_12
X_10225_ _03880_ _03882_ VGND VGND VPWR VPWR _03975_ sky130_fd_sc_hd__nand2_1
X_13013_ net1236 net563 net221 VGND VGND VPWR VPWR _01096_ sky130_fd_sc_hd__mux2_1
XFILLER_4_699 VGND VGND VPWR VPWR sky130_fd_sc_hd__fill_1
XFILLER_133_391 VGND VGND VPWR VPWR sky130_fd_sc_hd__fill_1
XFILLER_95_916 VGND VGND VPWR VPWR sky130_fd_sc_hd__fill_1
XFILLER_79_467 VGND VGND VPWR VPWR sky130_fd_sc_hd__decap_3
X_10156_ u_interface.u_gelu_fp32.u_synth_top.s2_dx\[16\] net645 net653 net457 VGND
+ VGND VPWR VPWR _03907_ sky130_fd_sc_hd__a22o_1
Xhold5 u_interface.u_gelu_fp32.u_synth_top.s1_x\[6\] VGND VGND VPWR VPWR net870 sky130_fd_sc_hd__dlygate4sd3_1
X_10087_ _03837_ _03838_ _03805_ VGND VGND VPWR VPWR _03839_ sky130_fd_sc_hd__a21o_1
X_13915_ clknet_leaf_6_clk net900 VGND VGND VPWR VPWR u_interface.u_gelu_fp32.u_synth_top.s1_x\[19\]
+ sky130_fd_sc_hd__dfxtp_1
XFILLER_47_364 VPWR VGND VPWR VGND sky130_ef_sc_hd__decap_12
XFILLER_74_60 VGND VGND VPWR VPWR sky130_fd_sc_hd__fill_2
XFILLER_63_857 VGND VGND VPWR VPWR sky130_fd_sc_hd__fill_1
XFILLER_35_537 VGND VGND VPWR VPWR sky130_fd_sc_hd__decap_4
X_13846_ clknet_leaf_24_clk _00856_ VGND VGND VPWR VPWR u_interface.u_gelu_fp32.u_synth_top.s3_b\[2\]
+ sky130_fd_sc_hd__dfxtp_1
XFILLER_74_93 VPWR VGND VPWR VGND sky130_ef_sc_hd__decap_12
XFILLER_74_82 VGND VGND VPWR VPWR sky130_fd_sc_hd__fill_2
XFILLER_35_559 VGND VGND VPWR VPWR sky130_fd_sc_hd__fill_1
X_13777_ clknet_leaf_87_clk _00787_ VGND VGND VPWR VPWR u_interface.u_gelu_fp32.s2_data\[11\]
+ sky130_fd_sc_hd__dfxtp_1
X_10989_ _04730_ _04731_ VGND VGND VPWR VPWR _04733_ sky130_fd_sc_hd__xnor2_1
XFILLER_31_721 VGND VGND VPWR VPWR sky130_fd_sc_hd__decap_6
XFILLER_149_918 VGND VGND VPWR VPWR sky130_fd_sc_hd__decap_3
X_12728_ net804 u_interface.u_gelu_fp32.u_q16_to_fp32.s3_norm_mag\[26\] net280 _06350_
+ VGND VGND VPWR VPWR _06380_ sky130_fd_sc_hd__a22o_1
XFILLER_90_70 VGND VGND VPWR VPWR sky130_fd_sc_hd__decap_8
X_12659_ net960 u_interface.u_gelu_fp32.u_q16_to_fp32.s2_mag\[14\] net804 VGND VGND
+ VPWR VPWR _00895_ sky130_fd_sc_hd__mux2_1
XFILLER_30_253 VGND VGND VPWR VPWR sky130_fd_sc_hd__decap_8
XFILLER_31_765 VPWR VGND VPWR VGND sky130_ef_sc_hd__decap_12
XFILLER_128_141 VGND VGND VPWR VPWR sky130_fd_sc_hd__decap_4
XFILLER_116_336 VGND VGND VPWR VPWR sky130_fd_sc_hd__decap_3
Xhold427 u_interface.fifo_data\[8\]\[25\] VGND VGND VPWR VPWR net1292 sky130_fd_sc_hd__dlygate4sd3_1
Xhold416 u_interface.fifo_data\[14\]\[15\] VGND VGND VPWR VPWR net1281 sky130_fd_sc_hd__dlygate4sd3_1
Xhold405 u_interface.fifo_data\[2\]\[20\] VGND VGND VPWR VPWR net1270 sky130_fd_sc_hd__dlygate4sd3_1
Xhold438 _01015_ VGND VGND VPWR VPWR net1303 sky130_fd_sc_hd__dlygate4sd3_1
Xhold449 u_interface.fifo_data\[2\]\[3\] VGND VGND VPWR VPWR net1314 sky130_fd_sc_hd__dlygate4sd3_1
X_09870_ _03622_ _03623_ _03513_ _03515_ VGND VGND VPWR VPWR _03624_ sky130_fd_sc_hd__o211a_1
XTAP_TAPCELL_ROW_55_1220 VGND VPWR sky130_fd_sc_hd__tapvpwrvgnd_1
X_08821_ net679 net690 net516 net520 VGND VGND VPWR VPWR _02580_ sky130_fd_sc_hd__and4_1
XFILLER_98_754 VGND VGND VPWR VPWR sky130_fd_sc_hd__fill_2
XFILLER_97_220 VGND VGND VPWR VPWR sky130_fd_sc_hd__decap_4
XTAP_TAPCELL_ROW_5_419 VGND VPWR sky130_fd_sc_hd__tapvpwrvgnd_1
XTAP_TAPCELL_ROW_5_408 VGND VPWR sky130_fd_sc_hd__tapvpwrvgnd_1
XFILLER_85_426 VPWR VGND VPWR VGND sky130_ef_sc_hd__decap_12
XTAP_TAPCELL_ROW_146_2667 VGND VPWR sky130_fd_sc_hd__tapvpwrvgnd_1
X_08752_ net637 net496 VGND VGND VPWR VPWR _02511_ sky130_fd_sc_hd__nand2_1
XTAP_TAPCELL_ROW_146_2678 VGND VPWR sky130_fd_sc_hd__tapvpwrvgnd_1
X_08683_ _02441_ VGND VGND VPWR VPWR _02442_ sky130_fd_sc_hd__inv_2
X_07703_ u_interface.u_gelu_fp32.u_synth_top.s1_hits\[7\] u_interface.u_gelu_fp32.u_synth_top.s1_hits\[10\]
+ VGND VGND VPWR VPWR _01764_ sky130_fd_sc_hd__or2_1
X_07634_ net306 net298 _01723_ net1000 net803 VGND VGND VPWR VPWR _00476_ sky130_fd_sc_hd__a32o_1
XFILLER_53_323 VGND VGND VPWR VPWR sky130_fd_sc_hd__fill_1
X_07565_ _01677_ VGND VGND VPWR VPWR _01678_ sky130_fd_sc_hd__inv_2
XTAP_TAPCELL_ROW_24_716 VGND VPWR sky130_fd_sc_hd__tapvpwrvgnd_1
XTAP_TAPCELL_ROW_24_727 VGND VPWR sky130_fd_sc_hd__tapvpwrvgnd_1
X_06516_ u_interface.fifo_count\[5\] u_interface.in_flight_count\[5\] VGND VGND VPWR
+ VPWR _01116_ sky130_fd_sc_hd__xnor2_1
X_09304_ _03059_ _03060_ _03062_ VGND VGND VPWR VPWR _03063_ sky130_fd_sc_hd__and3_1
X_07496_ _01548_ _01552_ net550 VGND VGND VPWR VPWR _01628_ sky130_fd_sc_hd__mux2_1
XFILLER_80_197 VGND VGND VPWR VPWR sky130_fd_sc_hd__fill_2
XTAP_TAPCELL_ROW_66_1393 VGND VPWR sky130_fd_sc_hd__tapvpwrvgnd_1
X_09235_ _02991_ _02993_ _02953_ _02962_ VGND VGND VPWR VPWR _02994_ sky130_fd_sc_hd__a211oi_1
XFILLER_10_905 VPWR VGND VPWR VGND sky130_ef_sc_hd__decap_12
XFILLER_147_461 VPWR VGND VPWR VGND sky130_ef_sc_hd__decap_12
X_09166_ net639 net647 net514 net518 VGND VGND VPWR VPWR _02925_ sky130_fd_sc_hd__and4_1
X_09097_ _02555_ _02556_ VGND VGND VPWR VPWR _02856_ sky130_fd_sc_hd__xnor2_1
X_08117_ _01957_ _01958_ net313 VGND VGND VPWR VPWR _01963_ sky130_fd_sc_hd__a21o_1
XFILLER_107_325 VGND VGND VPWR VPWR sky130_fd_sc_hd__fill_2
XFILLER_79_27 VGND VGND VPWR VPWR sky130_fd_sc_hd__decap_4
X_08048_ u_interface.u_gelu_fp32.u_fp32_to_q16.s3_frac\[25\] u_interface.u_gelu_fp32.u_fp32_to_q16.s3_frac\[24\]
+ u_interface.u_gelu_fp32.u_fp32_to_q16.s3_frac\[27\] u_interface.u_gelu_fp32.u_fp32_to_q16.s3_frac\[26\]
+ VGND VGND VPWR VPWR _01905_ sky130_fd_sc_hd__or4_1
XFILLER_135_11 VGND VGND VPWR VPWR sky130_fd_sc_hd__fill_1
XFILLER_103_531 VGND VGND VPWR VPWR sky130_fd_sc_hd__decap_3
X_10010_ net486 net713 net723 net491 VGND VGND VPWR VPWR _03762_ sky130_fd_sc_hd__a22o_1
XFILLER_0_113 VGND VGND VPWR VPWR sky130_fd_sc_hd__fill_2
XFILLER_131_895 VGND VGND VPWR VPWR sky130_fd_sc_hd__fill_1
XFILLER_130_361 VGND VGND VPWR VPWR sky130_fd_sc_hd__decap_3
XTAP_TAPCELL_ROW_110_2092 VGND VPWR sky130_fd_sc_hd__tapvpwrvgnd_1
XFILLER_103_575 VGND VGND VPWR VPWR sky130_fd_sc_hd__fill_2
XFILLER_95_15 VGND VGND VPWR VPWR sky130_fd_sc_hd__decap_4
XFILLER_88_253 VGND VGND VPWR VPWR sky130_fd_sc_hd__fill_2
X_09999_ net215 _03654_ _03750_ VGND VGND VPWR VPWR _03751_ sky130_fd_sc_hd__a21oi_1
XFILLER_88_297 VGND VGND VPWR VPWR sky130_fd_sc_hd__decap_8
XFILLER_76_437 VGND VGND VPWR VPWR sky130_fd_sc_hd__decap_6
XTAP_TAPCELL_ROW_86_1714 VGND VPWR sky130_fd_sc_hd__tapvpwrvgnd_1
XFILLER_57_651 VGND VGND VPWR VPWR sky130_fd_sc_hd__fill_2
X_11961_ _05692_ _05693_ VGND VGND VPWR VPWR _05695_ sky130_fd_sc_hd__nor2_1
XFILLER_28_53 VPWR VGND VPWR VGND sky130_ef_sc_hd__decap_12
XFILLER_151_54 VGND VGND VPWR VPWR sky130_fd_sc_hd__fill_2
X_13700_ clknet_leaf_19_clk _00710_ VGND VGND VPWR VPWR u_interface.u_gelu_fp32.s1_data\[0\]
+ sky130_fd_sc_hd__dfxtp_1
X_10912_ _04654_ _04655_ _04656_ VGND VGND VPWR VPWR _04657_ sky130_fd_sc_hd__a21oi_1
XFILLER_44_323 VPWR VGND VPWR VGND sky130_ef_sc_hd__decap_12
XFILLER_28_97 VGND VGND VPWR VPWR sky130_fd_sc_hd__fill_1
XFILLER_72_654 VGND VGND VPWR VPWR sky130_fd_sc_hd__fill_1
X_11892_ _05625_ _05626_ VGND VGND VPWR VPWR _05627_ sky130_fd_sc_hd__or2_1
X_13631_ clknet_leaf_42_clk _00641_ VGND VGND VPWR VPWR u_interface.fifo_data\[13\]\[14\]
+ sky130_fd_sc_hd__dfxtp_1
X_10843_ _04476_ _04478_ _04587_ VGND VGND VPWR VPWR _04588_ sky130_fd_sc_hd__nand3_1
XFILLER_60_838 VGND VGND VPWR VPWR sky130_fd_sc_hd__decap_3
XFILLER_32_529 VGND VGND VPWR VPWR sky130_fd_sc_hd__decap_3
X_10774_ net609 net618 net417 net414 VGND VGND VPWR VPWR _04520_ sky130_fd_sc_hd__nand4_2
XFILLER_53_890 VGND VGND VPWR VPWR sky130_fd_sc_hd__fill_2
X_13562_ clknet_leaf_83_clk _00572_ VGND VGND VPWR VPWR u_interface.fifo_data\[4\]\[9\]
+ sky130_fd_sc_hd__dfxtp_1
XFILLER_44_85 VPWR VGND VPWR VGND sky130_ef_sc_hd__decap_12
XFILLER_13_721 VGND VGND VPWR VPWR sky130_fd_sc_hd__decap_6
XFILLER_8_202 VPWR VGND VPWR VGND sky130_ef_sc_hd__decap_12
X_12513_ _06235_ _06236_ VGND VGND VPWR VPWR _06238_ sky130_fd_sc_hd__nor2_1
XFILLER_13_765 VPWR VGND VPWR VGND sky130_ef_sc_hd__decap_12
XTAP_TAPCELL_ROW_117_2213 VGND VPWR sky130_fd_sc_hd__tapvpwrvgnd_1
XTAP_TAPCELL_ROW_117_2202 VGND VPWR sky130_fd_sc_hd__tapvpwrvgnd_1
X_13493_ clknet_leaf_2_clk _00503_ VGND VGND VPWR VPWR u_interface.u_gelu_fp32.u_synth_top.s2_b\[0\]
+ sky130_fd_sc_hd__dfxtp_1
XFILLER_138_472 VGND VGND VPWR VPWR sky130_fd_sc_hd__decap_4
XFILLER_138_450 VGND VGND VPWR VPWR sky130_fd_sc_hd__fill_1
X_12444_ _06168_ _06169_ VGND VGND VPWR VPWR _06171_ sky130_fd_sc_hd__nand2_1
X_12375_ _06101_ _06102_ VGND VGND VPWR VPWR _06103_ sky130_fd_sc_hd__nor2_1
XTAP_TAPCELL_ROW_130_2413 VGND VPWR sky130_fd_sc_hd__tapvpwrvgnd_1
X_14114_ clknet_leaf_27_clk _01040_ VGND VGND VPWR VPWR u_interface.meta_tlast_pipe\[7\]
+ sky130_fd_sc_hd__dfxtp_1
XTAP_TAPCELL_ROW_97_1887 VGND VPWR sky130_fd_sc_hd__tapvpwrvgnd_1
XTAP_TAPCELL_ROW_10_498 VGND VPWR sky130_fd_sc_hd__tapvpwrvgnd_1
X_11326_ net651 net659 net416 net412 VGND VGND VPWR VPWR _05067_ sky130_fd_sc_hd__and4_1
X_14045_ clknet_leaf_17_clk _00971_ VGND VGND VPWR VPWR u_interface.u_gelu_fp32.u_fp32_to_q16.s1_mant\[7\]
+ sky130_fd_sc_hd__dfxtp_1
XFILLER_113_317 VPWR VGND VPWR VGND sky130_ef_sc_hd__decap_12
XFILLER_5_57 VPWR VGND VPWR VGND sky130_ef_sc_hd__decap_12
XFILLER_140_125 VGND VGND VPWR VPWR sky130_fd_sc_hd__fill_2
XFILLER_69_93 VGND VGND VPWR VPWR sky130_fd_sc_hd__fill_2
X_11257_ _04996_ _04997_ VGND VGND VPWR VPWR _04999_ sky130_fd_sc_hd__xnor2_2
XFILLER_122_884 VGND VGND VPWR VPWR sky130_fd_sc_hd__fill_1
XFILLER_95_724 VGND VGND VPWR VPWR sky130_fd_sc_hd__decap_4
X_10208_ _03782_ _03784_ _03955_ _03956_ VGND VGND VPWR VPWR _03959_ sky130_fd_sc_hd__a211o_1
XFILLER_67_404 VGND VGND VPWR VPWR sky130_fd_sc_hd__decap_4
X_11188_ net453 net456 net720 VGND VGND VPWR VPWR _04930_ sky130_fd_sc_hd__o21ai_2
XFILLER_95_735 VGND VGND VPWR VPWR sky130_fd_sc_hd__fill_1
X_10139_ net474 net699 net707 net478 VGND VGND VPWR VPWR _03890_ sky130_fd_sc_hd__a22o_1
XTAP_TAPCELL_ROW_128_2386 VGND VPWR sky130_fd_sc_hd__tapvpwrvgnd_1
XFILLER_94_289 VGND VGND VPWR VPWR sky130_fd_sc_hd__decap_6
XFILLER_47_150 VGND VGND VPWR VPWR sky130_fd_sc_hd__decap_8
XFILLER_35_301 VGND VGND VPWR VPWR sky130_fd_sc_hd__decap_6
XTAP_TAPCELL_ROW_141_2597 VGND VPWR sky130_fd_sc_hd__tapvpwrvgnd_1
XTAP_TAPCELL_ROW_141_2586 VGND VPWR sky130_fd_sc_hd__tapvpwrvgnd_1
XFILLER_90_462 VGND VGND VPWR VPWR sky130_fd_sc_hd__fill_2
XFILLER_50_315 VPWR VGND VPWR VGND sky130_ef_sc_hd__decap_12
XFILLER_16_570 VPWR VGND VPWR VGND sky130_ef_sc_hd__decap_12
X_13829_ clknet_leaf_79_clk _00839_ VGND VGND VPWR VPWR u_interface.u_gelu_fp32.u_synth_top.s3_mult\[47\]
+ sky130_fd_sc_hd__dfxtp_1
XFILLER_35_367 VGND VGND VPWR VPWR sky130_fd_sc_hd__decap_6
XFILLER_35_378 VPWR VGND VPWR VGND sky130_ef_sc_hd__decap_12
X_07350_ net354 net1519 net242 VGND VGND VPWR VPWR _00380_ sky130_fd_sc_hd__mux2_1
XFILLER_62_197 VGND VGND VPWR VPWR sky130_fd_sc_hd__fill_2
XFILLER_62_186 VGND VGND VPWR VPWR sky130_fd_sc_hd__decap_8
X_07281_ net1219 net365 net248 VGND VGND VPWR VPWR _00311_ sky130_fd_sc_hd__mux2_1
X_09020_ _02723_ _02729_ _02728_ VGND VGND VPWR VPWR _02779_ sky130_fd_sc_hd__a21o_1
Xhold202 u_interface.fifo_tlast\[8\] VGND VGND VPWR VPWR net1067 sky130_fd_sc_hd__dlygate4sd3_1
Xhold235 u_interface.fifo_data\[0\]\[17\] VGND VGND VPWR VPWR net1100 sky130_fd_sc_hd__dlygate4sd3_1
Xhold224 u_interface.fifo_data\[6\]\[0\] VGND VGND VPWR VPWR net1089 sky130_fd_sc_hd__dlygate4sd3_1
Xhold213 u_interface.fifo_data\[2\]\[9\] VGND VGND VPWR VPWR net1078 sky130_fd_sc_hd__dlygate4sd3_1
Xhold246 u_interface.fifo_data\[9\]\[10\] VGND VGND VPWR VPWR net1111 sky130_fd_sc_hd__dlygate4sd3_1
Xhold257 u_interface.fifo_data\[10\]\[19\] VGND VGND VPWR VPWR net1122 sky130_fd_sc_hd__dlygate4sd3_1
Xhold268 u_interface.fifo_data\[8\]\[14\] VGND VGND VPWR VPWR net1133 sky130_fd_sc_hd__dlygate4sd3_1
XFILLER_104_328 VPWR VGND VPWR VGND sky130_ef_sc_hd__decap_12
XTAP_TAPCELL_ROW_148_2707 VGND VPWR sky130_fd_sc_hd__tapvpwrvgnd_1
Xhold279 u_interface.fifo_data\[10\]\[17\] VGND VGND VPWR VPWR net1144 sky130_fd_sc_hd__dlygate4sd3_1
X_09922_ net596 net436 VGND VGND VPWR VPWR _03675_ sky130_fd_sc_hd__nand2_1
Xfanout715 net716 VGND VGND VPWR VPWR net715 sky130_fd_sc_hd__buf_2
Xfanout704 net708 VGND VGND VPWR VPWR net704 sky130_fd_sc_hd__clkbuf_2
Xfanout737 _00002_ VGND VGND VPWR VPWR net737 sky130_fd_sc_hd__buf_2
XFILLER_131_169 VGND VGND VPWR VPWR sky130_fd_sc_hd__decap_4
XPHY_EDGE_ROW_123_Left_279 VGND VGND VPWR VPWR sky130_fd_sc_hd__decap_3
Xfanout748 net754 VGND VGND VPWR VPWR net748 sky130_fd_sc_hd__clkbuf_4
X_09853_ _03603_ _03604_ _03605_ VGND VGND VPWR VPWR _03607_ sky130_fd_sc_hd__and3_1
XFILLER_100_501 VGND VGND VPWR VPWR sky130_fd_sc_hd__decap_8
Xfanout726 _00003_ VGND VGND VPWR VPWR net726 sky130_fd_sc_hd__buf_2
X_08804_ _02560_ _02562_ VGND VGND VPWR VPWR _02563_ sky130_fd_sc_hd__and2b_1
XFILLER_105_25 VPWR VGND VPWR VGND sky130_ef_sc_hd__decap_12
X_09784_ _03531_ _03537_ VGND VGND VPWR VPWR _03538_ sky130_fd_sc_hd__and2b_1
Xfanout759 _00000_ VGND VGND VPWR VPWR net759 sky130_fd_sc_hd__clkbuf_2
XFILLER_58_437 VPWR VGND VPWR VGND sky130_ef_sc_hd__decap_12
X_06996_ u_interface.fifo_wr_ptr\[3\] _01101_ VGND VGND VPWR VPWR _01515_ sky130_fd_sc_hd__or2_2
X_08735_ net637 net488 net493 net646 VGND VGND VPWR VPWR _02494_ sky130_fd_sc_hd__a22o_1
XFILLER_85_267 VGND VGND VPWR VPWR sky130_fd_sc_hd__decap_4
XTAP_TAPCELL_ROW_68_1422 VGND VPWR sky130_fd_sc_hd__tapvpwrvgnd_1
XFILLER_121_13 VGND VGND VPWR VPWR sky130_fd_sc_hd__decap_4
XFILLER_26_345 VGND VGND VPWR VPWR sky130_fd_sc_hd__decap_6
X_08666_ _02429_ net156 VGND VGND VPWR VPWR _02430_ sky130_fd_sc_hd__nand2b_1
XFILLER_121_57 VGND VGND VPWR VPWR sky130_fd_sc_hd__decap_8
X_07617_ _01709_ VGND VGND VPWR VPWR _01710_ sky130_fd_sc_hd__inv_2
X_08597_ _02192_ _02194_ _02227_ VGND VGND VPWR VPWR _02379_ sky130_fd_sc_hd__and3b_1
XFILLER_53_175 VGND VGND VPWR VPWR sky130_fd_sc_hd__fill_1
XFILLER_26_389 VGND VGND VPWR VPWR sky130_fd_sc_hd__fill_2
XPHY_EDGE_ROW_132_Left_288 VGND VGND VPWR VPWR sky130_fd_sc_hd__decap_3
X_07548_ net546 _01606_ VGND VGND VPWR VPWR _01665_ sky130_fd_sc_hd__and2b_1
XTAP_TAPCELL_ROW_81_1633 VGND VPWR sky130_fd_sc_hd__tapvpwrvgnd_1
XFILLER_41_337 VGND VGND VPWR VPWR sky130_fd_sc_hd__fill_1
X_07479_ _01612_ _01610_ net548 VGND VGND VPWR VPWR _01613_ sky130_fd_sc_hd__mux2_1
XFILLER_10_713 VPWR VGND VPWR VGND sky130_ef_sc_hd__decap_12
XFILLER_14_77 VGND VGND VPWR VPWR sky130_fd_sc_hd__decap_6
X_09218_ _02973_ _02975_ _02976_ VGND VGND VPWR VPWR _02977_ sky130_fd_sc_hd__nand3_1
XFILLER_139_258 VGND VGND VPWR VPWR sky130_fd_sc_hd__decap_8
X_10490_ _04226_ _04237_ VGND VGND VPWR VPWR _04238_ sky130_fd_sc_hd__xnor2_1
XFILLER_10_757 VPWR VGND VPWR VGND sky130_ef_sc_hd__decap_12
XFILLER_154_239 VPWR VGND VPWR VGND sky130_ef_sc_hd__decap_12
X_09149_ _02854_ _02855_ _02856_ VGND VGND VPWR VPWR _02908_ sky130_fd_sc_hd__o21ba_1
XFILLER_107_111 VGND VGND VPWR VPWR sky130_fd_sc_hd__fill_1
XFILLER_5_205 VPWR VGND VPWR VGND sky130_ef_sc_hd__decap_12
XTAP_TAPCELL_ROW_112_2121 VGND VPWR sky130_fd_sc_hd__tapvpwrvgnd_1
XTAP_TAPCELL_ROW_79_1595 VGND VPWR sky130_fd_sc_hd__tapvpwrvgnd_1
X_12160_ net709 _05890_ _05889_ VGND VGND VPWR VPWR _05891_ sky130_fd_sc_hd__a21bo_1
XFILLER_5_249 VPWR VGND VPWR VGND sky130_ef_sc_hd__decap_12
XFILLER_30_65 VPWR VGND VPWR VGND sky130_ef_sc_hd__decap_12
XFILLER_150_412 VGND VGND VPWR VPWR sky130_fd_sc_hd__decap_8
XFILLER_146_65 VGND VGND VPWR VPWR sky130_fd_sc_hd__decap_8
XTAP_TAPCELL_ROW_112_2132 VGND VPWR sky130_fd_sc_hd__tapvpwrvgnd_1
XFILLER_100_3 VGND VGND VPWR VPWR sky130_fd_sc_hd__decap_4
X_11111_ net634 net643 net416 net412 VGND VGND VPWR VPWR _04854_ sky130_fd_sc_hd__and4_1
XPHY_EDGE_ROW_141_Left_297 VGND VGND VPWR VPWR sky130_fd_sc_hd__decap_3
Xhold780 u_interface.u_gelu_fp32.u_fp32_to_q16.s3_mag\[25\] VGND VGND VPWR VPWR net1645
+ sky130_fd_sc_hd__dlygate4sd3_1
XFILLER_104_851 VGND VGND VPWR VPWR sky130_fd_sc_hd__decap_3
Xhold791 u_interface.u_gelu_fp32.u_q16_to_fp32.s1_mag\[6\] VGND VGND VPWR VPWR net1656
+ sky130_fd_sc_hd__dlygate4sd3_1
X_12091_ net709 net401 net397 net701 VGND VGND VPWR VPWR _05823_ sky130_fd_sc_hd__a22oi_1
XFILLER_110_309 VPWR VGND VPWR VGND sky130_ef_sc_hd__decap_12
X_11042_ _04783_ _04784_ VGND VGND VPWR VPWR _04786_ sky130_fd_sc_hd__xnor2_1
XFILLER_76_223 VGND VGND VPWR VPWR sky130_fd_sc_hd__decap_3
XFILLER_76_267 VGND VGND VPWR VPWR sky130_fd_sc_hd__decap_6
X_12993_ net1307 net364 net223 VGND VGND VPWR VPWR _01076_ sky130_fd_sc_hd__mux2_1
XFILLER_92_727 VGND VGND VPWR VPWR sky130_fd_sc_hd__decap_4
XFILLER_18_813 VPWR VGND VPWR VGND sky130_ef_sc_hd__decap_12
XFILLER_91_259 VPWR VGND VPWR VGND sky130_ef_sc_hd__decap_12
XFILLER_91_237 VPWR VGND VPWR VGND sky130_ef_sc_hd__decap_12
X_11944_ net684 net692 net402 net397 VGND VGND VPWR VPWR _05678_ sky130_fd_sc_hd__and4_1
XFILLER_44_153 VPWR VGND VPWR VGND sky130_ef_sc_hd__decap_12
X_11875_ _05605_ _05609_ VGND VGND VPWR VPWR _05610_ sky130_fd_sc_hd__xnor2_1
X_13614_ clknet_leaf_44_clk _00624_ VGND VGND VPWR VPWR u_interface.fifo_data\[3\]\[29\]
+ sky130_fd_sc_hd__dfxtp_1
X_10826_ _04558_ _04568_ _04569_ VGND VGND VPWR VPWR _04571_ sky130_fd_sc_hd__nand3_1
XFILLER_32_315 VPWR VGND VPWR VGND sky130_ef_sc_hd__decap_12
XTAP_TAPCELL_ROW_15_568 VGND VPWR sky130_fd_sc_hd__tapvpwrvgnd_1
XFILLER_41_871 VGND VGND VPWR VPWR sky130_fd_sc_hd__decap_6
X_13545_ clknet_leaf_46_clk _00555_ VGND VGND VPWR VPWR u_interface.fifo_data\[5\]\[24\]
+ sky130_fd_sc_hd__dfxtp_1
XTAP_TAPCELL_ROW_99_1927 VGND VPWR sky130_fd_sc_hd__tapvpwrvgnd_1
XTAP_TAPCELL_ROW_99_1916 VGND VPWR sky130_fd_sc_hd__tapvpwrvgnd_1
X_10757_ _04499_ _04500_ _04501_ VGND VGND VPWR VPWR _04503_ sky130_fd_sc_hd__nand3_1
XFILLER_13_573 VPWR VGND VPWR VGND sky130_ef_sc_hd__decap_12
XTAP_TAPCELL_ROW_15_579 VGND VPWR sky130_fd_sc_hd__tapvpwrvgnd_1
XFILLER_40_381 VGND VGND VPWR VPWR sky130_fd_sc_hd__fill_1
X_13476_ clknet_leaf_4_clk _00486_ VGND VGND VPWR VPWR u_interface.u_gelu_fp32.u_synth_top.s2_b\[17\]
+ sky130_fd_sc_hd__dfxtp_1
X_10688_ _04433_ _04434_ VGND VGND VPWR VPWR _04435_ sky130_fd_sc_hd__or2_1
XFILLER_71_94 VGND VGND VPWR VPWR sky130_fd_sc_hd__fill_1
X_12427_ _06077_ _06104_ _06103_ VGND VGND VPWR VPWR _06154_ sky130_fd_sc_hd__a21oi_1
XFILLER_126_453 VPWR VGND VPWR VGND sky130_ef_sc_hd__decap_12
XFILLER_126_497 VPWR VGND VPWR VGND sky130_ef_sc_hd__decap_12
X_12358_ net718 net395 _06085_ VGND VGND VPWR VPWR _06086_ sky130_fd_sc_hd__and3_1
XFILLER_5_783 VGND VGND VPWR VPWR sky130_fd_sc_hd__fill_1
XFILLER_99_337 VGND VGND VPWR VPWR sky130_fd_sc_hd__decap_4
X_11309_ _05046_ _05049_ VGND VGND VPWR VPWR _05050_ sky130_fd_sc_hd__xor2_2
X_12289_ _06016_ _06017_ VGND VGND VPWR VPWR _06018_ sky130_fd_sc_hd__nor2_2
X_14028_ clknet_leaf_53_clk _00954_ VGND VGND VPWR VPWR u_interface.core_data_out\[14\]
+ sky130_fd_sc_hd__dfxtp_1
XFILLER_110_810 VGND VGND VPWR VPWR sky130_fd_sc_hd__fill_2
X_06850_ u_interface.fifo_data\[4\]\[27\] u_interface.fifo_data\[5\]\[27\] u_interface.fifo_data\[6\]\[27\]
+ u_interface.fifo_data\[7\]\[27\] net761 net744 VGND VGND VPWR VPWR _01398_ sky130_fd_sc_hd__mux4_1
XFILLER_67_212 VGND VGND VPWR VPWR sky130_fd_sc_hd__decap_8
XFILLER_67_245 VGND VGND VPWR VPWR sky130_fd_sc_hd__fill_1
XTAP_TAPCELL_ROW_143_2626 VGND VPWR sky130_fd_sc_hd__tapvpwrvgnd_1
X_06781_ u_interface.fifo_data\[12\]\[19\] u_interface.fifo_data\[13\]\[19\] u_interface.fifo_data\[14\]\[19\]
+ u_interface.fifo_data\[15\]\[19\] net770 net753 VGND VGND VPWR VPWR _01337_ sky130_fd_sc_hd__mux4_1
XFILLER_83_749 VGND VGND VPWR VPWR sky130_fd_sc_hd__decap_4
XFILLER_48_470 VGND VGND VPWR VPWR sky130_fd_sc_hd__decap_6
X_08520_ u_interface.u_gelu_fp32.u_synth_top.s3_mult\[57\] u_interface.u_gelu_fp32.u_synth_top.s3_mult\[56\]
+ net525 VGND VGND VPWR VPWR _02311_ sky130_fd_sc_hd__o21a_1
XFILLER_36_643 VGND VGND VPWR VPWR sky130_fd_sc_hd__fill_1
XFILLER_63_462 VGND VGND VPWR VPWR sky130_fd_sc_hd__decap_4
X_08451_ net527 u_interface.u_gelu_fp32.u_synth_top.s3_mult\[35\] VGND VGND VPWR VPWR
+ _02242_ sky130_fd_sc_hd__nand2_1
XFILLER_24_805 VGND VGND VPWR VPWR sky130_fd_sc_hd__decap_6
X_07402_ _01538_ VGND VGND VPWR VPWR _01539_ sky130_fd_sc_hd__inv_2
XFILLER_23_326 VGND VGND VPWR VPWR sky130_fd_sc_hd__decap_4
XFILLER_23_337 VPWR VGND VPWR VGND sky130_ef_sc_hd__decap_12
XFILLER_24_849 VPWR VGND VPWR VGND sky130_ef_sc_hd__decap_12
XTAP_TAPCELL_ROW_63_1341 VGND VPWR sky130_fd_sc_hd__tapvpwrvgnd_1
X_08382_ _02171_ _02172_ VGND VGND VPWR VPWR _02173_ sky130_fd_sc_hd__nand2_1
XTAP_TAPCELL_ROW_34_877 VGND VPWR sky130_fd_sc_hd__tapvpwrvgnd_1
X_07333_ net1406 net563 net253 VGND VGND VPWR VPWR _00363_ sky130_fd_sc_hd__mux2_1
XFILLER_32_893 VPWR VGND VPWR VGND sky130_ef_sc_hd__decap_12
XFILLER_149_589 VGND VGND VPWR VPWR sky130_fd_sc_hd__fill_1
X_07264_ net1339 net567 net252 VGND VGND VPWR VPWR _00296_ sky130_fd_sc_hd__mux2_1
X_09003_ _02758_ _02760_ _02707_ _02708_ VGND VGND VPWR VPWR _02762_ sky130_fd_sc_hd__a211o_1
Xgelu_top_862 VGND VGND VPWR VPWR gelu_top_862/HI s_axil_rdata[30] sky130_fd_sc_hd__conb_1
Xgelu_top_840 VGND VGND VPWR VPWR gelu_top_840/HI s_axil_rdata[8] sky130_fd_sc_hd__conb_1
XTAP_TAPCELL_ROW_154_2799 VGND VPWR sky130_fd_sc_hd__tapvpwrvgnd_1
Xgelu_top_851 VGND VGND VPWR VPWR gelu_top_851/HI s_axil_rdata[19] sky130_fd_sc_hd__conb_1
XFILLER_3_709 VPWR VGND VPWR VGND sky130_ef_sc_hd__decap_12
X_07195_ net378 net1448 net257 VGND VGND VPWR VPWR _00235_ sky130_fd_sc_hd__mux2_1
XFILLER_132_434 VGND VGND VPWR VPWR sky130_fd_sc_hd__decap_4
XFILLER_104_114 VGND VGND VPWR VPWR sky130_fd_sc_hd__decap_3
Xfanout501 net503 VGND VGND VPWR VPWR net501 sky130_fd_sc_hd__clkbuf_4
Xfanout512 u_interface.u_gelu_fp32.u_synth_top.s2_dx\[2\] VGND VGND VPWR VPWR net512
+ sky130_fd_sc_hd__buf_2
X_09905_ _03655_ _03657_ VGND VGND VPWR VPWR _03658_ sky130_fd_sc_hd__nand2_1
Xfanout523 u_interface.u_gelu_fp32.u_synth_top.s3_b\[18\] VGND VGND VPWR VPWR net523
+ sky130_fd_sc_hd__buf_2
Xfanout556 net557 VGND VGND VPWR VPWR net556 sky130_fd_sc_hd__clkbuf_2
Xfanout545 net546 VGND VGND VPWR VPWR net545 sky130_fd_sc_hd__dlymetal6s2s_1
XFILLER_86_510 VGND VGND VPWR VPWR sky130_fd_sc_hd__decap_4
Xfanout534 u_interface.u_gelu_fp32.s2_data\[31\] VGND VGND VPWR VPWR net534 sky130_fd_sc_hd__clkbuf_2
Xfanout567 u_interface.core_data_out\[28\] VGND VGND VPWR VPWR net567 sky130_fd_sc_hd__clkbuf_2
Xfanout578 u_interface.core_data_out\[23\] VGND VGND VPWR VPWR net578 sky130_fd_sc_hd__clkbuf_2
Xfanout589 net593 VGND VGND VPWR VPWR net589 sky130_fd_sc_hd__clkbuf_2
X_09836_ _03587_ _03588_ _03589_ VGND VGND VPWR VPWR _03590_ sky130_fd_sc_hd__a21oi_1
XFILLER_59_768 VGND VGND VPWR VPWR sky130_fd_sc_hd__fill_1
X_06979_ _01100_ u_interface.fifo_wr_ptr\[1\] net827 u_interface.fifo_wr_ptr\[0\]
+ VGND VGND VPWR VPWR _01504_ sky130_fd_sc_hd__or4b_4
X_09767_ _03519_ _03520_ VGND VGND VPWR VPWR _03522_ sky130_fd_sc_hd__xor2_1
XFILLER_86_587 VGND VGND VPWR VPWR sky130_fd_sc_hd__fill_1
XFILLER_58_289 VGND VGND VPWR VPWR sky130_fd_sc_hd__decap_6
XFILLER_18_109 VPWR VGND VPWR VGND sky130_ef_sc_hd__decap_12
X_08718_ _02474_ _02475_ _02473_ VGND VGND VPWR VPWR _02477_ sky130_fd_sc_hd__o21ai_1
X_09698_ _03450_ _03451_ _03447_ VGND VGND VPWR VPWR _03453_ sky130_fd_sc_hd__a21o_1
XFILLER_73_259 VPWR VGND VPWR VGND sky130_ef_sc_hd__decap_12
XFILLER_39_492 VGND VGND VPWR VPWR sky130_fd_sc_hd__fill_2
X_08649_ net156 _02416_ VGND VGND VPWR VPWR _02417_ sky130_fd_sc_hd__nand2_1
XFILLER_27_665 VGND VGND VPWR VPWR sky130_fd_sc_hd__decap_6
XFILLER_42_613 VPWR VGND VPWR VGND sky130_ef_sc_hd__decap_12
XFILLER_54_495 VGND VGND VPWR VPWR sky130_fd_sc_hd__fill_1
XFILLER_26_175 VPWR VGND VPWR VGND sky130_ef_sc_hd__decap_12
XFILLER_148_3 VPWR VGND VPWR VGND sky130_ef_sc_hd__decap_12
X_11660_ _05307_ _05312_ _05306_ VGND VGND VPWR VPWR _05398_ sky130_fd_sc_hd__a21oi_1
X_10611_ _04356_ _04357_ _04353_ VGND VGND VPWR VPWR _04358_ sky130_fd_sc_hd__a21o_1
XTAP_TAPCELL_ROW_12_527 VGND VPWR sky130_fd_sc_hd__tapvpwrvgnd_1
X_11591_ net214 _05247_ _05248_ VGND VGND VPWR VPWR _05329_ sky130_fd_sc_hd__a21boi_1
X_13330_ clknet_leaf_45_clk _00340_ VGND VGND VPWR VPWR u_interface.fifo_data\[10\]\[7\]
+ sky130_fd_sc_hd__dfxtp_1
X_10542_ _04278_ _04280_ _04289_ VGND VGND VPWR VPWR _04290_ sky130_fd_sc_hd__and3_1
XFILLER_155_537 VGND VGND VPWR VPWR sky130_fd_sc_hd__fill_2
X_13261_ clknet_leaf_73_clk _00271_ VGND VGND VPWR VPWR u_interface.fifo_data\[0\]\[3\]
+ sky130_fd_sc_hd__dfxtp_1
XFILLER_10_587 VGND VGND VPWR VPWR sky130_fd_sc_hd__fill_1
XFILLER_6_525 VGND VGND VPWR VPWR sky130_fd_sc_hd__decap_6
XFILLER_41_53 VGND VGND VPWR VPWR sky130_fd_sc_hd__decap_3
X_10473_ _04219_ _04220_ _04201_ VGND VGND VPWR VPWR _04221_ sky130_fd_sc_hd__a21o_1
XFILLER_6_569 VPWR VGND VPWR VGND sky130_ef_sc_hd__decap_12
X_12212_ net183 _05941_ VGND VGND VPWR VPWR _05942_ sky130_fd_sc_hd__xnor2_1
XFILLER_142_209 VGND VGND VPWR VPWR sky130_fd_sc_hd__fill_2
XFILLER_108_475 VGND VGND VPWR VPWR sky130_fd_sc_hd__fill_1
XTAP_TAPCELL_ROW_94_1846 VGND VPWR sky130_fd_sc_hd__tapvpwrvgnd_1
XTAP_TAPCELL_ROW_94_1835 VGND VPWR sky130_fd_sc_hd__tapvpwrvgnd_1
X_13192_ clknet_leaf_74_clk _00202_ VGND VGND VPWR VPWR u_interface.fifo_data\[12\]\[2\]
+ sky130_fd_sc_hd__dfxtp_1
X_12143_ net201 _05872_ VGND VGND VPWR VPWR _05874_ sky130_fd_sc_hd__xnor2_1
XFILLER_150_242 VGND VGND VPWR VPWR sky130_fd_sc_hd__decap_8
XFILLER_123_467 VGND VGND VPWR VPWR sky130_fd_sc_hd__decap_4
XFILLER_111_629 VPWR VGND VPWR VGND sky130_ef_sc_hd__decap_12
XFILLER_97_819 VGND VGND VPWR VPWR sky130_fd_sc_hd__decap_4
XFILLER_96_307 VGND VGND VPWR VPWR sky130_fd_sc_hd__fill_1
X_12074_ net200 _05805_ VGND VGND VPWR VPWR _05806_ sky130_fd_sc_hd__nor2_1
XFILLER_150_297 VGND VGND VPWR VPWR sky130_fd_sc_hd__decap_4
X_11025_ _04767_ _04768_ VGND VGND VPWR VPWR _04769_ sky130_fd_sc_hd__and2b_1
XTAP_TAPCELL_ROW_125_2334 VGND VPWR sky130_fd_sc_hd__tapvpwrvgnd_1
XFILLER_64_215 VPWR VGND VPWR VGND sky130_ef_sc_hd__decap_12
XFILLER_37_418 VPWR VGND VPWR VGND sky130_ef_sc_hd__decap_12
XFILLER_66_83 VGND VGND VPWR VPWR sky130_fd_sc_hd__fill_1
XFILLER_18_643 VGND VGND VPWR VPWR sky130_fd_sc_hd__fill_1
X_12976_ _06489_ _06490_ _06488_ VGND VGND VPWR VPWR _06493_ sky130_fd_sc_hd__o21a_1
XFILLER_45_473 VPWR VGND VPWR VGND sky130_ef_sc_hd__decap_12
XFILLER_72_281 VGND VGND VPWR VPWR sky130_fd_sc_hd__fill_2
XFILLER_60_421 VGND VGND VPWR VPWR sky130_fd_sc_hd__decap_4
X_11927_ net214 _05580_ _05577_ VGND VGND VPWR VPWR _05661_ sky130_fd_sc_hd__a21oi_2
XFILLER_32_112 VGND VGND VPWR VPWR sky130_fd_sc_hd__decap_4
XFILLER_82_82 VGND VGND VPWR VPWR sky130_fd_sc_hd__fill_2
X_11858_ _05591_ _05592_ VGND VGND VPWR VPWR _05593_ sky130_fd_sc_hd__xor2_1
XTAP_TAPCELL_ROW_103_1986 VGND VPWR sky130_fd_sc_hd__tapvpwrvgnd_1
X_10809_ _04442_ _04554_ VGND VGND VPWR VPWR _04555_ sky130_fd_sc_hd__or2_1
XTAP_TAPCELL_ROW_45_1060 VGND VPWR sky130_fd_sc_hd__tapvpwrvgnd_1
XFILLER_14_893 VPWR VGND VPWR VGND sky130_ef_sc_hd__decap_12
X_11789_ net675 net401 net397 net666 VGND VGND VPWR VPWR _05525_ sky130_fd_sc_hd__a22oi_1
XTAP_TAPCELL_ROW_31_825 VGND VPWR sky130_fd_sc_hd__tapvpwrvgnd_1
XTAP_TAPCELL_ROW_31_836 VGND VPWR sky130_fd_sc_hd__tapvpwrvgnd_1
X_13528_ clknet_leaf_41_clk _00538_ VGND VGND VPWR VPWR u_interface.fifo_data\[5\]\[7\]
+ sky130_fd_sc_hd__dfxtp_1
XFILLER_118_217 VGND VGND VPWR VPWR sky130_fd_sc_hd__decap_3
X_13459_ clknet_leaf_13_clk _00469_ VGND VGND VPWR VPWR u_interface.u_gelu_fp32.u_fp32_to_q16.s3_mag\[30\]
+ sky130_fd_sc_hd__dfxtp_1
XFILLER_63_3 VPWR VGND VPWR VGND sky130_ef_sc_hd__decap_12
XFILLER_154_581 VGND VGND VPWR VPWR sky130_fd_sc_hd__fill_1
XFILLER_126_261 VGND VGND VPWR VPWR sky130_fd_sc_hd__fill_1
XFILLER_126_250 VGND VGND VPWR VPWR sky130_fd_sc_hd__fill_2
Xoutput115 net115 VGND VGND VPWR VPWR m_axis_tdata[15] sky130_fd_sc_hd__buf_2
Xoutput148 net148 VGND VGND VPWR VPWR s_axil_rvalid sky130_fd_sc_hd__buf_2
XFILLER_114_445 VGND VGND VPWR VPWR sky130_fd_sc_hd__decap_3
Xoutput126 net126 VGND VGND VPWR VPWR m_axis_tdata[25] sky130_fd_sc_hd__buf_2
Xoutput137 net137 VGND VGND VPWR VPWR m_axis_tdata[6] sky130_fd_sc_hd__buf_2
X_07951_ net934 u_interface.u_gelu_fp32.u_fp32_to_q16.s2_is_zero net814 VGND VGND
+ VPWR VPWR _00680_ sky130_fd_sc_hd__mux2_1
XFILLER_114_456 VGND VGND VPWR VPWR sky130_fd_sc_hd__decap_6
XFILLER_101_117 VGND VGND VPWR VPWR sky130_fd_sc_hd__fill_1
X_06902_ _01184_ net286 u_interface.u_gelu_fp32.u_synth_top.s1_x\[17\] VGND VGND VPWR
+ VPWR _01443_ sky130_fd_sc_hd__a21o_1
X_07882_ net1130 net353 net267 VGND VGND VPWR VPWR _00643_ sky130_fd_sc_hd__mux2_1
X_09621_ net216 _03238_ _03237_ VGND VGND VPWR VPWR _03377_ sky130_fd_sc_hd__a21bo_1
X_06833_ u_interface.fifo_data\[0\]\[25\] u_interface.fifo_data\[1\]\[25\] u_interface.fifo_data\[2\]\[25\]
+ u_interface.fifo_data\[3\]\[25\] net765 net748 VGND VGND VPWR VPWR _01383_ sky130_fd_sc_hd__mux4_1
XFILLER_83_524 VGND VGND VPWR VPWR sky130_fd_sc_hd__fill_1
XFILLER_55_204 VGND VGND VPWR VPWR sky130_fd_sc_hd__decap_3
X_06764_ _01318_ _01319_ _01322_ net319 VGND VGND VPWR VPWR net116 sky130_fd_sc_hd__a22o_1
X_09552_ _03307_ _03308_ _03210_ VGND VGND VPWR VPWR _03309_ sky130_fd_sc_hd__a21o_1
XTAP_TAPCELL_ROW_39_958 VGND VPWR sky130_fd_sc_hd__tapvpwrvgnd_1
XFILLER_83_579 VGND VGND VPWR VPWR sky130_fd_sc_hd__fill_1
X_08503_ _02292_ _02293_ VGND VGND VPWR VPWR _02294_ sky130_fd_sc_hd__nand2_1
X_09483_ _03228_ _03239_ VGND VGND VPWR VPWR _03240_ sky130_fd_sc_hd__nand2b_1
XFILLER_63_281 VGND VGND VPWR VPWR sky130_fd_sc_hd__decap_3
X_06695_ net320 _01261_ VGND VGND VPWR VPWR _01262_ sky130_fd_sc_hd__or2_1
X_08434_ u_interface.u_gelu_fp32.u_synth_top.s3_mult\[24\] u_interface.u_gelu_fp32.u_synth_top.s3_b\[8\]
+ VGND VGND VPWR VPWR _02225_ sky130_fd_sc_hd__or2_1
XFILLER_23_145 VGND VGND VPWR VPWR sky130_fd_sc_hd__decap_3
XFILLER_24_657 VPWR VGND VPWR VGND sky130_ef_sc_hd__decap_12
XFILLER_23_167 VGND VGND VPWR VPWR sky130_fd_sc_hd__fill_1
X_08365_ net524 u_interface.u_gelu_fp32.u_synth_top.s3_mult\[59\] VGND VGND VPWR VPWR
+ _02156_ sky130_fd_sc_hd__xnor2_1
X_07316_ net1112 net358 net256 VGND VGND VPWR VPWR _00346_ sky130_fd_sc_hd__mux2_1
XFILLER_149_386 VGND VGND VPWR VPWR sky130_fd_sc_hd__decap_6
X_08296_ net530 _02104_ net1597 VGND VGND VPWR VPWR _02105_ sky130_fd_sc_hd__a21oi_1
X_07247_ net1082 net362 net252 VGND VGND VPWR VPWR _00279_ sky130_fd_sc_hd__mux2_1
XFILLER_118_773 VGND VGND VPWR VPWR sky130_fd_sc_hd__decap_3
X_07178_ net1168 net348 net262 VGND VGND VPWR VPWR _00218_ sky130_fd_sc_hd__mux2_1
XFILLER_3_517 VPWR VGND VPWR VGND sky130_ef_sc_hd__decap_12
XFILLER_105_412 VPWR VGND VPWR VGND sky130_ef_sc_hd__decap_12
XTAP_TAPCELL_ROW_76_1554 VGND VPWR sky130_fd_sc_hd__tapvpwrvgnd_1
XFILLER_87_49 VGND VGND VPWR VPWR sky130_fd_sc_hd__decap_6
XFILLER_87_27 VGND VGND VPWR VPWR sky130_fd_sc_hd__decap_6
Xfanout331 u_interface.u_gelu_fp32.u_q16_to_fp32.s2_clz\[2\] VGND VGND VPWR VPWR net331
+ sky130_fd_sc_hd__clkbuf_2
Xfanout320 _01107_ VGND VGND VPWR VPWR net320 sky130_fd_sc_hd__clkbuf_4
Xfanout353 u_interface.core_data_out\[16\] VGND VGND VPWR VPWR net353 sky130_fd_sc_hd__buf_1
Xfanout364 u_interface.core_data_out\[10\] VGND VGND VPWR VPWR net364 sky130_fd_sc_hd__clkbuf_2
XFILLER_87_841 VGND VGND VPWR VPWR sky130_fd_sc_hd__fill_1
Xfanout375 u_interface.core_data_out\[5\] VGND VGND VPWR VPWR net375 sky130_fd_sc_hd__buf_1
Xfanout342 u_interface.core_data_out\[21\] VGND VGND VPWR VPWR net342 sky130_fd_sc_hd__clkbuf_2
XFILLER_143_55 VGND VGND VPWR VPWR sky130_fd_sc_hd__fill_1
Xfanout386 u_interface.u_gelu_fp32.u_synth_top.s1_hits\[14\] VGND VGND VPWR VPWR net386
+ sky130_fd_sc_hd__clkbuf_2
XFILLER_100_150 VGND VGND VPWR VPWR sky130_fd_sc_hd__decap_3
X_09819_ _03569_ _03572_ VGND VGND VPWR VPWR _03573_ sky130_fd_sc_hd__xnor2_1
XFILLER_59_587 VGND VGND VPWR VPWR sky130_fd_sc_hd__decap_4
XFILLER_47_738 VGND VGND VPWR VPWR sky130_fd_sc_hd__fill_2
Xfanout397 net398 VGND VGND VPWR VPWR net397 sky130_fd_sc_hd__clkbuf_2
XTAP_TAPCELL_ROW_107_2053 VGND VPWR sky130_fd_sc_hd__tapvpwrvgnd_1
XTAP_TAPCELL_ROW_107_2042 VGND VPWR sky130_fd_sc_hd__tapvpwrvgnd_1
X_12830_ net334 _06327_ net781 VGND VGND VPWR VPWR _00988_ sky130_fd_sc_hd__mux2_1
XTAP_TAPCELL_ROW_17_608 VGND VPWR sky130_fd_sc_hd__tapvpwrvgnd_1
X_12761_ u_interface.u_gelu_fp32.u_q16_to_fp32.s3_norm_mag\[7\] u_interface.u_gelu_fp32.u_q16_to_fp32.s3_norm_mag\[8\]
+ u_interface.u_gelu_fp32.u_q16_to_fp32.s3_norm_mag\[9\] VGND VGND VPWR VPWR _06397_
+ sky130_fd_sc_hd__a21o_1
XTAP_TAPCELL_ROW_120_2253 VGND VPWR sky130_fd_sc_hd__tapvpwrvgnd_1
X_12692_ _01733_ net280 _06350_ _01696_ _06351_ VGND VGND VPWR VPWR _00917_ sky130_fd_sc_hd__a221o_1
XFILLER_70_763 VGND VGND VPWR VPWR sky130_fd_sc_hd__fill_1
X_11712_ _05444_ _05448_ VGND VGND VPWR VPWR _05449_ sky130_fd_sc_hd__xnor2_1
XFILLER_42_432 VGND VGND VPWR VPWR sky130_fd_sc_hd__fill_1
X_11643_ _05254_ _05286_ _05285_ VGND VGND VPWR VPWR _05381_ sky130_fd_sc_hd__a21oi_1
XFILLER_52_85 VGND VGND VPWR VPWR sky130_fd_sc_hd__decap_4
XFILLER_52_63 VGND VGND VPWR VPWR sky130_fd_sc_hd__fill_2
XFILLER_11_841 VPWR VGND VPWR VGND sky130_ef_sc_hd__decap_12
Xinput17 s_axil_araddr[22] VGND VGND VPWR VPWR net17 sky130_fd_sc_hd__clkbuf_1
Xinput28 s_axil_araddr[3] VGND VGND VPWR VPWR net28 sky130_fd_sc_hd__clkbuf_1
X_11574_ _05307_ _05312_ net794 VGND VGND VPWR VPWR _05313_ sky130_fd_sc_hd__a21oi_1
XFILLER_10_362 VGND VGND VPWR VPWR sky130_fd_sc_hd__fill_2
Xinput39 s_axil_awaddr[12] VGND VGND VPWR VPWR net39 sky130_fd_sc_hd__buf_1
X_13313_ clknet_leaf_36_clk _00323_ VGND VGND VPWR VPWR u_interface.fifo_data\[8\]\[22\]
+ sky130_fd_sc_hd__dfxtp_1
X_10525_ _04263_ _04270_ _04271_ VGND VGND VPWR VPWR _04273_ sky130_fd_sc_hd__nand3_1
XFILLER_6_344 VGND VGND VPWR VPWR sky130_fd_sc_hd__decap_4
X_13244_ clknet_leaf_36_clk _00254_ VGND VGND VPWR VPWR u_interface.fifo_data\[11\]\[22\]
+ sky130_fd_sc_hd__dfxtp_1
XFILLER_115_209 VGND VGND VPWR VPWR sky130_fd_sc_hd__fill_1
X_10456_ _04091_ _04093_ VGND VGND VPWR VPWR _04204_ sky130_fd_sc_hd__nand2_1
XFILLER_7_889 VGND VGND VPWR VPWR sky130_fd_sc_hd__decap_6
X_13175_ clknet_leaf_53_clk _00185_ VGND VGND VPWR VPWR u_interface.fifo_data\[9\]\[17\]
+ sky130_fd_sc_hd__dfxtp_1
XFILLER_151_540 VPWR VGND VPWR VGND sky130_ef_sc_hd__decap_12
X_10387_ _04134_ _04135_ _04122_ VGND VGND VPWR VPWR _04136_ sky130_fd_sc_hd__o21a_1
X_12126_ _05724_ _05784_ _05783_ VGND VGND VPWR VPWR _05858_ sky130_fd_sc_hd__a21oi_1
X_12057_ net193 _05788_ VGND VGND VPWR VPWR _05790_ sky130_fd_sc_hd__nand2_1
XFILLER_77_93 VPWR VGND VPWR VGND sky130_ef_sc_hd__decap_12
XFILLER_65_524 VGND VGND VPWR VPWR sky130_fd_sc_hd__decap_4
X_11008_ net617 net408 VGND VGND VPWR VPWR _04752_ sky130_fd_sc_hd__nand2_1
XFILLER_92_332 VGND VGND VPWR VPWR sky130_fd_sc_hd__decap_4
XFILLER_65_557 VGND VGND VPWR VPWR sky130_fd_sc_hd__decap_3
XFILLER_38_749 VGND VGND VPWR VPWR sky130_fd_sc_hd__decap_6
XFILLER_92_354 VGND VGND VPWR VPWR sky130_fd_sc_hd__decap_3
XFILLER_18_451 VPWR VGND VPWR VGND sky130_ef_sc_hd__decap_12
XTAP_TAPCELL_ROW_36_906 VGND VPWR sky130_fd_sc_hd__tapvpwrvgnd_1
XTAP_TAPCELL_ROW_36_917 VGND VPWR sky130_fd_sc_hd__tapvpwrvgnd_1
XFILLER_37_259 VPWR VGND VPWR VGND sky130_ef_sc_hd__decap_12
X_12959_ _06472_ _06473_ _06476_ _06477_ VGND VGND VPWR VPWR _06479_ sky130_fd_sc_hd__a211oi_1
XFILLER_80_549 VGND VGND VPWR VPWR sky130_fd_sc_hd__fill_1
XFILLER_45_270 VGND VGND VPWR VPWR sky130_fd_sc_hd__decap_6
XFILLER_60_240 VGND VGND VPWR VPWR sky130_fd_sc_hd__decap_4
XFILLER_61_796 VGND VGND VPWR VPWR sky130_fd_sc_hd__decap_4
XFILLER_61_785 VGND VGND VPWR VPWR sky130_fd_sc_hd__fill_2
XTAP_TAPCELL_ROW_60_1300 VGND VPWR sky130_fd_sc_hd__tapvpwrvgnd_1
XFILLER_33_465 VPWR VGND VPWR VGND sky130_ef_sc_hd__decap_12
XTAP_TAPCELL_ROW_43_1019 VGND VPWR sky130_fd_sc_hd__tapvpwrvgnd_1
XTAP_TAPCELL_ROW_138_2547 VGND VPWR sky130_fd_sc_hd__tapvpwrvgnd_1
XTAP_TAPCELL_ROW_138_2536 VGND VPWR sky130_fd_sc_hd__tapvpwrvgnd_1
X_08150_ net167 _01989_ _01990_ net162 VGND VGND VPWR VPWR _01991_ sky130_fd_sc_hd__a31oi_1
XFILLER_119_515 VGND VGND VPWR VPWR sky130_fd_sc_hd__decap_4
X_07101_ net1270 net344 net225 VGND VGND VPWR VPWR _00141_ sky130_fd_sc_hd__mux2_1
X_08081_ _01926_ _01927_ net314 VGND VGND VPWR VPWR _01933_ sky130_fd_sc_hd__a21oi_1
XFILLER_119_559 VGND VGND VPWR VPWR sky130_fd_sc_hd__fill_1
XTAP_TAPCELL_ROW_151_2758 VGND VPWR sky130_fd_sc_hd__tapvpwrvgnd_1
XTAP_TAPCELL_ROW_151_2747 VGND VPWR sky130_fd_sc_hd__tapvpwrvgnd_1
X_07032_ net1281 net355 net270 VGND VGND VPWR VPWR _00072_ sky130_fd_sc_hd__mux2_1
XTAP_TAPCELL_ROW_58_1262 VGND VPWR sky130_fd_sc_hd__tapvpwrvgnd_1
X_08983_ _02739_ _02740_ _02741_ VGND VGND VPWR VPWR _02742_ sky130_fd_sc_hd__or3_1
XFILLER_87_104 VGND VGND VPWR VPWR sky130_fd_sc_hd__decap_8
X_07934_ u_interface.u_gelu_fp32.u_fp32_to_q16.s1_exp\[1\] u_interface.u_gelu_fp32.u_fp32_to_q16.s1_exp\[0\]
+ VGND VGND VPWR VPWR _01827_ sky130_fd_sc_hd__nor2_1
XFILLER_130_757 VGND VGND VPWR VPWR sky130_fd_sc_hd__fill_2
XTAP_TAPCELL_ROW_71_1473 VGND VPWR sky130_fd_sc_hd__tapvpwrvgnd_1
X_07865_ net562 net1502 net282 VGND VGND VPWR VPWR _00626_ sky130_fd_sc_hd__mux2_1
XFILLER_29_727 VGND VGND VPWR VPWR sky130_fd_sc_hd__fill_1
X_09604_ _03280_ _03298_ _03357_ _03358_ VGND VGND VPWR VPWR _03360_ sky130_fd_sc_hd__o211ai_1
XFILLER_83_321 VGND VGND VPWR VPWR sky130_fd_sc_hd__decap_3
X_07796_ net1063 net571 net236 VGND VGND VPWR VPWR _00557_ sky130_fd_sc_hd__mux2_1
X_06816_ net734 _01365_ net728 VGND VGND VPWR VPWR _01368_ sky130_fd_sc_hd__o21a_1
XFILLER_71_505 VGND VGND VPWR VPWR sky130_fd_sc_hd__decap_4
XFILLER_44_719 VGND VGND VPWR VPWR sky130_fd_sc_hd__fill_1
X_06747_ _01306_ _01307_ net733 VGND VGND VPWR VPWR _01308_ sky130_fd_sc_hd__mux2_1
X_09535_ _03140_ _03142_ _03141_ VGND VGND VPWR VPWR _03292_ sky130_fd_sc_hd__a21bo_1
XFILLER_24_421 VPWR VGND VPWR VGND sky130_ef_sc_hd__decap_12
XFILLER_36_270 VGND VGND VPWR VPWR sky130_fd_sc_hd__decap_3
XFILLER_43_229 VGND VGND VPWR VPWR sky130_fd_sc_hd__decap_6
X_09466_ _03222_ _03223_ VGND VGND VPWR VPWR _03224_ sky130_fd_sc_hd__xor2_1
X_06678_ net730 _01246_ VGND VGND VPWR VPWR _01247_ sky130_fd_sc_hd__or2_1
X_08417_ u_interface.u_gelu_fp32.u_synth_top.s3_mult\[19\] u_interface.u_gelu_fp32.u_synth_top.s3_b\[3\]
+ VGND VGND VPWR VPWR _02208_ sky130_fd_sc_hd__or2_1
X_09397_ _03151_ _03154_ VGND VGND VPWR VPWR _03155_ sky130_fd_sc_hd__xnor2_1
XFILLER_11_137 VPWR VGND VPWR VGND sky130_ef_sc_hd__decap_12
XFILLER_149_150 VGND VGND VPWR VPWR sky130_fd_sc_hd__fill_1
X_08348_ net528 _02143_ net1632 VGND VGND VPWR VPWR _02144_ sky130_fd_sc_hd__a21oi_1
XFILLER_138_11 VGND VGND VPWR VPWR sky130_fd_sc_hd__fill_1
X_08279_ u_interface.u_gelu_fp32.s2_data\[9\] _02089_ VGND VGND VPWR VPWR _02092_
+ sky130_fd_sc_hd__or2_1
XFILLER_20_693 VGND VGND VPWR VPWR sky130_fd_sc_hd__decap_6
XTAP_TAPCELL_ROW_22_688 VGND VPWR sky130_fd_sc_hd__tapvpwrvgnd_1
XFILLER_138_55 VGND VGND VPWR VPWR sky130_fd_sc_hd__fill_1
XFILLER_106_710 VGND VGND VPWR VPWR sky130_fd_sc_hd__decap_4
XFILLER_98_26 VGND VGND VPWR VPWR sky130_fd_sc_hd__fill_2
X_10310_ _04057_ _04058_ _04042_ VGND VGND VPWR VPWR _04060_ sky130_fd_sc_hd__a21bo_1
X_11290_ _04816_ _04932_ VGND VGND VPWR VPWR _05031_ sky130_fd_sc_hd__or2_2
XFILLER_22_77 VGND VGND VPWR VPWR sky130_fd_sc_hd__decap_6
XFILLER_153_849 VGND VGND VPWR VPWR sky130_fd_sc_hd__decap_6
X_10241_ _03987_ _03988_ _03989_ VGND VGND VPWR VPWR _03991_ sky130_fd_sc_hd__nand3_1
XFILLER_4_837 VPWR VGND VPWR VGND sky130_ef_sc_hd__decap_12
XFILLER_106_754 VGND VGND VPWR VPWR sky130_fd_sc_hd__fill_2
XFILLER_133_573 VGND VGND VPWR VPWR sky130_fd_sc_hd__decap_3
XFILLER_105_275 VGND VGND VPWR VPWR sky130_fd_sc_hd__decap_4
XFILLER_79_638 VGND VGND VPWR VPWR sky130_fd_sc_hd__decap_8
X_10172_ net588 net423 net418 net579 VGND VGND VPWR VPWR _03923_ sky130_fd_sc_hd__a22oi_1
XFILLER_78_115 VGND VGND VPWR VPWR sky130_fd_sc_hd__fill_1
XFILLER_120_223 VPWR VGND VPWR VGND sky130_ef_sc_hd__decap_12
XFILLER_78_148 VGND VGND VPWR VPWR sky130_fd_sc_hd__decap_8
XFILLER_120_289 VGND VGND VPWR VPWR sky130_fd_sc_hd__fill_2
X_13931_ clknet_leaf_5_clk _00016_ VGND VGND VPWR VPWR u_interface.u_gelu_fp32.u_synth_top.s1_hits\[3\]
+ sky130_fd_sc_hd__dfxtp_1
XFILLER_87_671 VGND VGND VPWR VPWR sky130_fd_sc_hd__fill_1
Xfanout161 _06275_ VGND VGND VPWR VPWR net161 sky130_fd_sc_hd__buf_2
Xfanout183 _05024_ VGND VGND VPWR VPWR net183 sky130_fd_sc_hd__clkbuf_2
XTAP_TAPCELL_ROW_89_1756 VGND VPWR sky130_fd_sc_hd__tapvpwrvgnd_1
Xfanout194 _03752_ VGND VGND VPWR VPWR net194 sky130_fd_sc_hd__clkbuf_2
XTAP_TAPCELL_ROW_89_1767 VGND VPWR sky130_fd_sc_hd__tapvpwrvgnd_1
XFILLER_74_343 VGND VGND VPWR VPWR sky130_fd_sc_hd__decap_3
X_13862_ clknet_leaf_89_clk _00872_ VGND VGND VPWR VPWR u_interface.u_gelu_fp32.u_synth_top.s3_b\[18\]
+ sky130_fd_sc_hd__dfxtp_1
XFILLER_47_557 VGND VGND VPWR VPWR sky130_fd_sc_hd__decap_3
X_12813_ net778 net103 VGND VGND VPWR VPWR _00971_ sky130_fd_sc_hd__and2_1
XFILLER_15_410 VGND VGND VPWR VPWR sky130_fd_sc_hd__fill_1
XFILLER_28_793 VPWR VGND VPWR VGND sky130_ef_sc_hd__decap_12
X_13793_ clknet_leaf_80_clk _00803_ VGND VGND VPWR VPWR u_interface.u_gelu_fp32.s2_data\[27\]
+ sky130_fd_sc_hd__dfxtp_1
X_12744_ _06391_ _06385_ _06378_ _06370_ net332 net328 VGND VGND VPWR VPWR _06392_
+ sky130_fd_sc_hd__mux4_1
XFILLER_15_421 VPWR VGND VPWR VGND sky130_ef_sc_hd__decap_12
XFILLER_43_785 VGND VGND VPWR VPWR sky130_fd_sc_hd__fill_1
XFILLER_30_402 VPWR VGND VPWR VGND sky130_ef_sc_hd__decap_12
XFILLER_129_802 VGND VGND VPWR VPWR sky130_fd_sc_hd__fill_1
XTAP_TAPCELL_ROW_100_1934 VGND VPWR sky130_fd_sc_hd__tapvpwrvgnd_1
XFILLER_70_593 VGND VGND VPWR VPWR sky130_fd_sc_hd__decap_8
X_12675_ u_interface.u_gelu_fp32.u_q16_to_fp32.s1_mag\[30\] net1362 net797 VGND VGND
+ VPWR VPWR _00911_ sky130_fd_sc_hd__mux2_1
X_11626_ net625 net387 VGND VGND VPWR VPWR _05364_ sky130_fd_sc_hd__and2b_1
XTAP_TAPCELL_ROW_41_986 VGND VPWR sky130_fd_sc_hd__tapvpwrvgnd_1
XFILLER_155_120 VGND VGND VPWR VPWR sky130_fd_sc_hd__fill_2
XFILLER_129_868 VGND VGND VPWR VPWR sky130_fd_sc_hd__decap_6
X_11557_ _05220_ _05295_ VGND VGND VPWR VPWR _05296_ sky130_fd_sc_hd__xnor2_1
XFILLER_11_671 VGND VGND VPWR VPWR sky130_fd_sc_hd__fill_1
XTAP_TAPCELL_ROW_41_997 VGND VPWR sky130_fd_sc_hd__tapvpwrvgnd_1
XFILLER_155_164 VGND VGND VPWR VPWR sky130_fd_sc_hd__fill_1
XFILLER_116_507 VPWR VGND VPWR VGND sky130_ef_sc_hd__decap_12
X_10508_ _04254_ _04255_ _04223_ VGND VGND VPWR VPWR _04256_ sky130_fd_sc_hd__a21o_1
Xhold609 u_interface.fifo_data\[7\]\[30\] VGND VGND VPWR VPWR net1474 sky130_fd_sc_hd__dlygate4sd3_1
XFILLER_7_653 VPWR VGND VPWR VGND sky130_ef_sc_hd__decap_12
XFILLER_6_141 VPWR VGND VPWR VGND sky130_ef_sc_hd__decap_12
XFILLER_155_197 VGND VGND VPWR VPWR sky130_fd_sc_hd__fill_2
XFILLER_143_337 VGND VGND VPWR VPWR sky130_fd_sc_hd__decap_8
XFILLER_143_326 VGND VGND VPWR VPWR sky130_fd_sc_hd__fill_1
XTAP_TAPCELL_ROW_133_2466 VGND VPWR sky130_fd_sc_hd__tapvpwrvgnd_1
X_11488_ _04701_ _04930_ _05226_ VGND VGND VPWR VPWR _05227_ sky130_fd_sc_hd__a21o_1
XFILLER_7_697 VPWR VGND VPWR VGND sky130_ef_sc_hd__decap_12
X_10439_ _04070_ _04072_ VGND VGND VPWR VPWR _04188_ sky130_fd_sc_hd__nand2b_1
X_13227_ clknet_leaf_70_clk _00237_ VGND VGND VPWR VPWR u_interface.fifo_data\[11\]\[5\]
+ sky130_fd_sc_hd__dfxtp_1
XFILLER_152_893 VGND VGND VPWR VPWR sky130_fd_sc_hd__decap_6
X_13158_ clknet_leaf_62_clk _00168_ VGND VGND VPWR VPWR u_interface.fifo_data\[9\]\[0\]
+ sky130_fd_sc_hd__dfxtp_1
X_13089_ clknet_leaf_38_clk _00099_ VGND VGND VPWR VPWR u_interface.fifo_data\[15\]\[10\]
+ sky130_fd_sc_hd__dfxtp_1
X_12109_ _05821_ _05840_ VGND VGND VPWR VPWR _05841_ sky130_fd_sc_hd__xnor2_1
XFILLER_97_479 VPWR VGND VPWR VGND sky130_ef_sc_hd__decap_12
XFILLER_66_811 VGND VGND VPWR VPWR sky130_fd_sc_hd__fill_1
XTAP_TAPCELL_ROW_53_1181 VGND VPWR sky130_fd_sc_hd__tapvpwrvgnd_1
XFILLER_26_3 VPWR VGND VPWR VGND sky130_ef_sc_hd__decap_12
XFILLER_38_502 VGND VGND VPWR VPWR sky130_fd_sc_hd__decap_3
XFILLER_38_513 VGND VGND VPWR VPWR sky130_fd_sc_hd__decap_8
XFILLER_84_129 VGND VGND VPWR VPWR sky130_fd_sc_hd__decap_8
XFILLER_65_310 VPWR VGND VPWR VGND sky130_ef_sc_hd__decap_12
XFILLER_93_652 VGND VGND VPWR VPWR sky130_fd_sc_hd__decap_4
X_07650_ u_interface.u_gelu_fp32.u_q16_to_fp32.s2_mag\[11\] u_interface.u_gelu_fp32.u_q16_to_fp32.s2_mag\[10\]
+ u_interface.u_gelu_fp32.u_q16_to_fp32.s2_mag\[9\] u_interface.u_gelu_fp32.u_q16_to_fp32.s2_mag\[8\]
+ net338 net333 VGND VGND VPWR VPWR _01735_ sky130_fd_sc_hd__mux4_1
XFILLER_66_866 VGND VGND VPWR VPWR sky130_fd_sc_hd__fill_2
XTAP_TAPCELL_ROW_0_317 VGND VPWR sky130_fd_sc_hd__tapvpwrvgnd_1
XTAP_TAPCELL_ROW_0_328 VGND VPWR sky130_fd_sc_hd__tapvpwrvgnd_1
X_07581_ net810 net1734 net303 _01687_ VGND VGND VPWR VPWR _00459_ sky130_fd_sc_hd__a22o_1
X_06601_ u_interface.u_gelu_fp32.s1_data\[17\] _01148_ _01149_ _01171_ _01180_ VGND
+ VGND VPWR VPWR _01182_ sky130_fd_sc_hd__o2111ai_1
XFILLER_92_173 VGND VGND VPWR VPWR sky130_fd_sc_hd__decap_6
XFILLER_80_324 VGND VGND VPWR VPWR sky130_fd_sc_hd__fill_2
XTAP_TAPCELL_ROW_0_339 VGND VPWR sky130_fd_sc_hd__tapvpwrvgnd_1
X_09320_ net606 net513 net517 net615 VGND VGND VPWR VPWR _03079_ sky130_fd_sc_hd__a22oi_1
X_06532_ u_interface.u_gelu_fp32.u_synth_top.s1_hits\[7\] u_interface.u_gelu_fp32.u_synth_top.s1_hits\[9\]
+ _01103_ _01129_ VGND VGND VPWR VPWR _01131_ sky130_fd_sc_hd__or4_1
X_09251_ _02986_ _02987_ _02989_ VGND VGND VPWR VPWR _03010_ sky130_fd_sc_hd__a21oi_1
X_08202_ u_interface.u_gelu_fp32.u_fp32_to_q16.s3_mag\[24\] u_interface.u_gelu_fp32.u_fp32_to_q16.s3_mag\[23\]
+ _01888_ u_interface.u_gelu_fp32.u_fp32_to_q16.s3_mag\[25\] VGND VGND VPWR VPWR _02034_
+ sky130_fd_sc_hd__a31o_1
X_09182_ _02925_ _02939_ _02940_ VGND VGND VPWR VPWR _02941_ sky130_fd_sc_hd__nand3_1
XFILLER_119_345 VGND VGND VPWR VPWR sky130_fd_sc_hd__fill_1
X_08133_ u_interface.u_gelu_fp32.u_fp32_to_q16.s3_mag\[14\] _01882_ VGND VGND VPWR
+ VPWR _01976_ sky130_fd_sc_hd__nor2_1
X_08064_ _01917_ _01918_ VGND VGND VPWR VPWR _01919_ sky130_fd_sc_hd__xnor2_1
XFILLER_119_378 VPWR VGND VPWR VGND sky130_ef_sc_hd__decap_12
X_07015_ _01504_ _01509_ VGND VGND VPWR VPWR _01526_ sky130_fd_sc_hd__nor2_2
XTAP_TAPCELL_ROW_73_1502 VGND VPWR sky130_fd_sc_hd__tapvpwrvgnd_1
XFILLER_68_29 VGND VGND VPWR VPWR sky130_fd_sc_hd__fill_1
X_08966_ net622 net497 VGND VGND VPWR VPWR _02725_ sky130_fd_sc_hd__nand2_1
XFILLER_69_660 VGND VGND VPWR VPWR sky130_fd_sc_hd__decap_4
X_07917_ u_interface.u_gelu_fp32.u_fp32_to_q16.s1_exp\[3\] _01810_ VGND VGND VPWR
+ VPWR _01811_ sky130_fd_sc_hd__and2_1
X_08897_ _02622_ _02655_ VGND VGND VPWR VPWR _02656_ sky130_fd_sc_hd__nor2_1
XFILLER_56_321 VPWR VGND VPWR VGND sky130_ef_sc_hd__decap_12
X_07848_ net356 net1589 net284 VGND VGND VPWR VPWR _00609_ sky130_fd_sc_hd__mux2_1
XTAP_TAPCELL_ROW_104_2001 VGND VPWR sky130_fd_sc_hd__tapvpwrvgnd_1
XFILLER_16_218 VPWR VGND VPWR VGND sky130_ef_sc_hd__decap_12
XFILLER_17_55 VGND VGND VPWR VPWR sky130_fd_sc_hd__fill_1
X_09518_ _03273_ _03274_ VGND VGND VPWR VPWR _03275_ sky130_fd_sc_hd__nor2_1
XFILLER_72_869 VGND VGND VPWR VPWR sky130_fd_sc_hd__decap_4
X_07779_ net1028 net366 net233 VGND VGND VPWR VPWR _00540_ sky130_fd_sc_hd__mux2_1
XFILLER_25_741 VPWR VGND VPWR VGND sky130_ef_sc_hd__decap_12
XTAP_TAPCELL_ROW_27_769 VGND VPWR sky130_fd_sc_hd__tapvpwrvgnd_1
XTAP_TAPCELL_ROW_84_1686 VGND VPWR sky130_fd_sc_hd__tapvpwrvgnd_1
XTAP_TAPCELL_ROW_84_1675 VGND VPWR sky130_fd_sc_hd__tapvpwrvgnd_1
X_10790_ _04410_ _04413_ _04533_ _04534_ VGND VGND VPWR VPWR _04536_ sky130_fd_sc_hd__a211o_1
XFILLER_52_560 VGND VGND VPWR VPWR sky130_fd_sc_hd__decap_8
XFILLER_25_785 VPWR VGND VPWR VGND sky130_ef_sc_hd__decap_12
X_09449_ _02656_ _03204_ _03205_ VGND VGND VPWR VPWR _03207_ sky130_fd_sc_hd__and3_1
XFILLER_149_21 VPWR VGND VPWR VGND sky130_ef_sc_hd__decap_12
XFILLER_130_3 VGND VGND VPWR VPWR sky130_fd_sc_hd__decap_8
X_12460_ _06139_ _06019_ VGND VGND VPWR VPWR _06186_ sky130_fd_sc_hd__and2b_1
XFILLER_33_65 VGND VGND VPWR VPWR sky130_fd_sc_hd__fill_1
X_11411_ net695 net429 net424 net686 VGND VGND VPWR VPWR _05151_ sky130_fd_sc_hd__a22o_1
X_12391_ _06052_ _06055_ _06118_ VGND VGND VPWR VPWR _06119_ sky130_fd_sc_hd__and3_1
X_14130_ clknet_leaf_30_clk _01056_ VGND VGND VPWR VPWR u_interface.in_flight_count\[3\]
+ sky130_fd_sc_hd__dfxtp_1
XFILLER_4_601 VPWR VGND VPWR VGND sky130_ef_sc_hd__decap_12
XFILLER_20_490 VGND VGND VPWR VPWR sky130_fd_sc_hd__decap_4
X_11342_ net602 net388 VGND VGND VPWR VPWR _05083_ sky130_fd_sc_hd__and2b_1
XFILLER_152_101 VGND VGND VPWR VPWR sky130_fd_sc_hd__fill_2
XFILLER_125_337 VGND VGND VPWR VPWR sky130_fd_sc_hd__decap_4
XFILLER_3_111 VGND VGND VPWR VPWR sky130_fd_sc_hd__fill_1
XFILLER_140_307 VGND VGND VPWR VPWR sky130_fd_sc_hd__fill_1
XFILLER_125_359 VGND VGND VPWR VPWR sky130_fd_sc_hd__decap_6
XTAP_TAPCELL_ROW_115_2174 VGND VPWR sky130_fd_sc_hd__tapvpwrvgnd_1
X_14061_ clknet_leaf_56_clk _00987_ VGND VGND VPWR VPWR u_interface.u_gelu_fp32.u_q16_to_fp32.s2_clz\[0\]
+ sky130_fd_sc_hd__dfxtp_1
X_11273_ _05013_ _05014_ VGND VGND VPWR VPWR _05015_ sky130_fd_sc_hd__nor2_1
XFILLER_4_645 VPWR VGND VPWR VGND sky130_ef_sc_hd__decap_12
X_13012_ net1194 net565 net224 VGND VGND VPWR VPWR _01095_ sky130_fd_sc_hd__mux2_1
XFILLER_106_562 VGND VGND VPWR VPWR sky130_fd_sc_hd__decap_4
X_10224_ net196 _03960_ _03961_ VGND VGND VPWR VPWR _03974_ sky130_fd_sc_hd__o21bai_1
XPHY_EDGE_ROW_18_Left_174 VGND VGND VPWR VPWR sky130_fd_sc_hd__decap_3
X_10155_ net453 net457 net645 net653 VGND VGND VPWR VPWR _03906_ sky130_fd_sc_hd__nand4_1
XTAP_TAPCELL_ROW_7_450 VGND VPWR sky130_fd_sc_hd__tapvpwrvgnd_1
Xhold6 u_interface.u_gelu_fp32.u_synth_top.s1_x\[5\] VGND VGND VPWR VPWR net871 sky130_fd_sc_hd__dlygate4sd3_1
X_10086_ _03684_ _03835_ _03836_ VGND VGND VPWR VPWR _03838_ sky130_fd_sc_hd__nand3_1
Xclkbuf_leaf_86_clk clknet_3_1__leaf_clk VGND VGND VPWR VPWR clknet_leaf_86_clk sky130_fd_sc_hd__clkbuf_8
XFILLER_0_895 VGND VGND VPWR VPWR sky130_fd_sc_hd__fill_1
X_13914_ clknet_leaf_6_clk net896 VGND VGND VPWR VPWR u_interface.u_gelu_fp32.u_synth_top.s1_x\[18\]
+ sky130_fd_sc_hd__dfxtp_1
XFILLER_47_354 VGND VGND VPWR VPWR sky130_fd_sc_hd__decap_3
X_13845_ clknet_leaf_25_clk _00855_ VGND VGND VPWR VPWR u_interface.u_gelu_fp32.u_synth_top.s3_b\[1\]
+ sky130_fd_sc_hd__dfxtp_1
XFILLER_47_376 VPWR VGND VPWR VGND sky130_ef_sc_hd__decap_12
XFILLER_35_516 VGND VGND VPWR VPWR sky130_fd_sc_hd__fill_2
XPHY_EDGE_ROW_27_Left_183 VGND VGND VPWR VPWR sky130_fd_sc_hd__decap_3
XFILLER_90_699 VGND VGND VPWR VPWR sky130_fd_sc_hd__fill_1
X_13776_ clknet_leaf_58_clk _00786_ VGND VGND VPWR VPWR u_interface.u_gelu_fp32.s2_data\[10\]
+ sky130_fd_sc_hd__dfxtp_1
XFILLER_71_880 VGND VGND VPWR VPWR sky130_fd_sc_hd__fill_2
X_10988_ _04728_ _04729_ _04731_ VGND VGND VPWR VPWR _04732_ sky130_fd_sc_hd__or3_1
XFILLER_71_891 VGND VGND VPWR VPWR sky130_fd_sc_hd__decap_4
X_12727_ _06378_ _06370_ _06364_ _06356_ net335 net328 VGND VGND VPWR VPWR _06379_
+ sky130_fd_sc_hd__mux4_1
XFILLER_90_82 VGND VGND VPWR VPWR sky130_fd_sc_hd__fill_2
X_12658_ u_interface.u_gelu_fp32.u_q16_to_fp32.s1_mag\[13\] net1694 net802 VGND VGND
+ VPWR VPWR _00894_ sky130_fd_sc_hd__mux2_1
XFILLER_31_777 VGND VGND VPWR VPWR sky130_fd_sc_hd__decap_6
XFILLER_30_287 VGND VGND VPWR VPWR sky130_fd_sc_hd__fill_1
X_11609_ net659 net406 _05269_ _05267_ VGND VGND VPWR VPWR _05347_ sky130_fd_sc_hd__a31o_1
Xclkbuf_leaf_10_clk clknet_3_2__leaf_clk VGND VGND VPWR VPWR clknet_leaf_10_clk sky130_fd_sc_hd__clkbuf_8
X_12589_ u_interface.u_gelu_fp32.u_q16_to_fp32.s1_mag\[27\] u_interface.u_gelu_fp32.u_q16_to_fp32.s1_mag\[26\]
+ u_interface.u_gelu_fp32.u_q16_to_fp32.s1_mag\[30\] VGND VGND VPWR VPWR _06292_ sky130_fd_sc_hd__or3_1
XFILLER_128_186 VGND VGND VPWR VPWR sky130_fd_sc_hd__decap_8
XFILLER_117_849 VGND VGND VPWR VPWR sky130_fd_sc_hd__decap_3
Xhold406 u_interface.fifo_data\[12\]\[24\] VGND VGND VPWR VPWR net1271 sky130_fd_sc_hd__dlygate4sd3_1
Xhold417 u_interface.fifo_data\[4\]\[8\] VGND VGND VPWR VPWR net1282 sky130_fd_sc_hd__dlygate4sd3_1
Xhold439 u_interface.fifo_data\[2\]\[22\] VGND VGND VPWR VPWR net1304 sky130_fd_sc_hd__dlygate4sd3_1
Xhold428 u_interface.fifo_data\[12\]\[14\] VGND VGND VPWR VPWR net1293 sky130_fd_sc_hd__dlygate4sd3_1
XTAP_TAPCELL_ROW_55_1210 VGND VPWR sky130_fd_sc_hd__tapvpwrvgnd_1
XPHY_EDGE_ROW_36_Left_192 VGND VGND VPWR VPWR sky130_fd_sc_hd__decap_3
XFILLER_98_733 VGND VGND VPWR VPWR sky130_fd_sc_hd__fill_1
XTAP_TAPCELL_ROW_55_1221 VGND VPWR sky130_fd_sc_hd__tapvpwrvgnd_1
X_08820_ _02518_ _02577_ _02576_ _02559_ VGND VGND VPWR VPWR _02579_ sky130_fd_sc_hd__o211a_1
XFILLER_112_521 VGND VGND VPWR VPWR sky130_fd_sc_hd__decap_8
XTAP_TAPCELL_ROW_5_409 VGND VPWR sky130_fd_sc_hd__tapvpwrvgnd_1
XFILLER_140_863 VGND VGND VPWR VPWR sky130_fd_sc_hd__decap_4
XFILLER_85_405 VGND VGND VPWR VPWR sky130_fd_sc_hd__fill_2
XTAP_TAPCELL_ROW_146_2668 VGND VPWR sky130_fd_sc_hd__tapvpwrvgnd_1
X_08751_ net622 net629 net487 net492 VGND VGND VPWR VPWR _02510_ sky130_fd_sc_hd__and4_1
XFILLER_85_449 VGND VGND VPWR VPWR sky130_fd_sc_hd__fill_2
XFILLER_85_438 VGND VGND VPWR VPWR sky130_fd_sc_hd__fill_1
Xclkbuf_leaf_77_clk clknet_3_4__leaf_clk VGND VGND VPWR VPWR clknet_leaf_77_clk sky130_fd_sc_hd__clkbuf_8
XTAP_TAPCELL_ROW_146_2679 VGND VPWR sky130_fd_sc_hd__tapvpwrvgnd_1
X_08682_ _02439_ _02440_ VGND VGND VPWR VPWR _02441_ sky130_fd_sc_hd__or2_1
X_07702_ _01186_ _01187_ _01441_ VGND VGND VPWR VPWR _00504_ sky130_fd_sc_hd__or3_1
X_07633_ _01722_ VGND VGND VPWR VPWR _01723_ sky130_fd_sc_hd__inv_2
XFILLER_54_836 VGND VGND VPWR VPWR sky130_fd_sc_hd__decap_8
XFILLER_38_365 VPWR VGND VPWR VGND sky130_ef_sc_hd__decap_12
X_07564_ net547 net551 net557 _01556_ VGND VGND VPWR VPWR _01677_ sky130_fd_sc_hd__or4_1
XFILLER_80_154 VGND VGND VPWR VPWR sky130_fd_sc_hd__fill_1
XTAP_TAPCELL_ROW_24_717 VGND VPWR sky130_fd_sc_hd__tapvpwrvgnd_1
X_09303_ _02920_ _03061_ VGND VGND VPWR VPWR _03062_ sky130_fd_sc_hd__nor2_1
X_07495_ net816 net1552 _01542_ _01627_ VGND VGND VPWR VPWR _00433_ sky130_fd_sc_hd__a22o_1
X_06515_ u_interface.u_gelu_fp32.u_q16_to_fp32.s2_clz\[3\] VGND VGND VPWR VPWR _01115_
+ sky130_fd_sc_hd__inv_2
XTAP_TAPCELL_ROW_66_1394 VGND VPWR sky130_fd_sc_hd__tapvpwrvgnd_1
X_09234_ _02986_ _02991_ _02992_ VGND VGND VPWR VPWR _02993_ sky130_fd_sc_hd__nand3b_1
XFILLER_139_418 VPWR VGND VPWR VGND sky130_ef_sc_hd__decap_12
XFILLER_10_917 VGND VGND VPWR VPWR sky130_fd_sc_hd__fill_1
XPHY_EDGE_ROW_3_Right_3 VGND VGND VPWR VPWR sky130_fd_sc_hd__decap_3
XFILLER_22_755 VGND VGND VPWR VPWR sky130_fd_sc_hd__fill_1
X_09165_ _02880_ _02923_ _02921_ _02920_ VGND VGND VPWR VPWR _02924_ sky130_fd_sc_hd__and4bb_1
XFILLER_21_276 VGND VGND VPWR VPWR sky130_fd_sc_hd__decap_4
X_08116_ u_interface.u_gelu_fp32.u_fp32_to_q16.s3_mag\[11\] _01879_ VGND VGND VPWR
+ VPWR _01962_ sky130_fd_sc_hd__xnor2_1
XFILLER_147_473 VPWR VGND VPWR VGND sky130_ef_sc_hd__decap_12
X_09096_ _02801_ _02822_ _02853_ VGND VGND VPWR VPWR _02855_ sky130_fd_sc_hd__a21oi_1
XFILLER_135_646 VGND VGND VPWR VPWR sky130_fd_sc_hd__fill_2
XFILLER_134_101 VGND VGND VPWR VPWR sky130_fd_sc_hd__decap_4
X_08047_ u_interface.u_gelu_fp32.u_fp32_to_q16.s3_frac\[17\] u_interface.u_gelu_fp32.u_fp32_to_q16.s3_frac\[16\]
+ u_interface.u_gelu_fp32.u_fp32_to_q16.s3_frac\[19\] u_interface.u_gelu_fp32.u_fp32_to_q16.s3_frac\[18\]
+ VGND VGND VPWR VPWR _01904_ sky130_fd_sc_hd__or4_1
XFILLER_122_329 VGND VGND VPWR VPWR sky130_fd_sc_hd__decap_3
XFILLER_122_307 VGND VGND VPWR VPWR sky130_fd_sc_hd__fill_1
XFILLER_1_615 VGND VGND VPWR VPWR sky130_fd_sc_hd__fill_1
XFILLER_88_221 VGND VGND VPWR VPWR sky130_fd_sc_hd__fill_1
XTAP_TAPCELL_ROW_110_2093 VGND VPWR sky130_fd_sc_hd__tapvpwrvgnd_1
XFILLER_76_405 VGND VGND VPWR VPWR sky130_fd_sc_hd__fill_1
X_09998_ _03171_ _03749_ VGND VGND VPWR VPWR _03750_ sky130_fd_sc_hd__and2_1
XFILLER_0_169 VPWR VGND VPWR VGND sky130_ef_sc_hd__decap_12
X_08949_ _02599_ _02705_ _02706_ VGND VGND VPWR VPWR _02708_ sky130_fd_sc_hd__nor3_2
XTAP_TAPCELL_ROW_86_1704 VGND VPWR sky130_fd_sc_hd__tapvpwrvgnd_1
Xclkbuf_leaf_68_clk clknet_3_5__leaf_clk VGND VGND VPWR VPWR clknet_leaf_68_clk sky130_fd_sc_hd__clkbuf_8
X_11960_ _05692_ _05693_ VGND VGND VPWR VPWR _05694_ sky130_fd_sc_hd__nand2_1
XFILLER_28_65 VPWR VGND VPWR VGND sky130_ef_sc_hd__decap_12
XFILLER_151_77 VGND VGND VPWR VPWR sky130_fd_sc_hd__fill_1
XTAP_TAPCELL_ROW_86_1715 VGND VPWR sky130_fd_sc_hd__tapvpwrvgnd_1
X_10911_ _04542_ _04544_ VGND VGND VPWR VPWR _04656_ sky130_fd_sc_hd__or2_1
XFILLER_44_335 VPWR VGND VPWR VGND sky130_ef_sc_hd__decap_12
X_11891_ _05499_ _05547_ _05546_ VGND VGND VPWR VPWR _05626_ sky130_fd_sc_hd__a21oi_1
X_13630_ clknet_leaf_34_clk _00640_ VGND VGND VPWR VPWR u_interface.fifo_data\[13\]\[13\]
+ sky130_fd_sc_hd__dfxtp_1
XFILLER_72_699 VGND VGND VPWR VPWR sky130_fd_sc_hd__fill_1
XFILLER_71_165 VGND VGND VPWR VPWR sky130_fd_sc_hd__decap_3
X_10842_ _04578_ _04586_ VGND VGND VPWR VPWR _04587_ sky130_fd_sc_hd__xnor2_1
X_10773_ net594 net409 _04395_ _04394_ VGND VGND VPWR VPWR _04519_ sky130_fd_sc_hd__a31o_1
X_13561_ clknet_leaf_73_clk _00571_ VGND VGND VPWR VPWR u_interface.fifo_data\[4\]\[8\]
+ sky130_fd_sc_hd__dfxtp_1
XFILLER_40_530 VGND VGND VPWR VPWR sky130_fd_sc_hd__fill_2
XFILLER_44_97 VGND VGND VPWR VPWR sky130_fd_sc_hd__decap_8
X_12512_ _06235_ _06236_ VGND VGND VPWR VPWR _06237_ sky130_fd_sc_hd__and2_1
XFILLER_12_243 VGND VGND VPWR VPWR sky130_fd_sc_hd__decap_8
XFILLER_13_777 VGND VGND VPWR VPWR sky130_fd_sc_hd__decap_6
XTAP_TAPCELL_ROW_117_2214 VGND VPWR sky130_fd_sc_hd__tapvpwrvgnd_1
XTAP_TAPCELL_ROW_117_2203 VGND VPWR sky130_fd_sc_hd__tapvpwrvgnd_1
X_13492_ clknet_leaf_2_clk _00502_ VGND VGND VPWR VPWR u_interface.u_gelu_fp32.u_synth_top.s2_b\[1\]
+ sky130_fd_sc_hd__dfxtp_1
XFILLER_100_81 VGND VGND VPWR VPWR sky130_fd_sc_hd__decap_3
XFILLER_8_214 VPWR VGND VPWR VGND sky130_ef_sc_hd__decap_12
X_12443_ _06168_ _06169_ VGND VGND VPWR VPWR _06170_ sky130_fd_sc_hd__or2_1
X_12374_ _06014_ _06035_ _06036_ VGND VGND VPWR VPWR _06102_ sky130_fd_sc_hd__o21a_1
XFILLER_153_432 VPWR VGND VPWR VGND sky130_ef_sc_hd__decap_12
XTAP_TAPCELL_ROW_130_2414 VGND VPWR sky130_fd_sc_hd__tapvpwrvgnd_1
XFILLER_126_679 VGND VGND VPWR VPWR sky130_fd_sc_hd__decap_6
X_14113_ clknet_leaf_27_clk _01039_ VGND VGND VPWR VPWR u_interface.meta_tlast_pipe\[6\]
+ sky130_fd_sc_hd__dfxtp_1
XTAP_TAPCELL_ROW_97_1888 VGND VPWR sky130_fd_sc_hd__tapvpwrvgnd_1
XTAP_TAPCELL_ROW_10_499 VGND VPWR sky130_fd_sc_hd__tapvpwrvgnd_1
XTAP_TAPCELL_ROW_10_488 VGND VPWR sky130_fd_sc_hd__tapvpwrvgnd_1
X_11325_ net667 net421 VGND VGND VPWR VPWR _05066_ sky130_fd_sc_hd__nand2_1
X_14044_ clknet_leaf_17_clk _00970_ VGND VGND VPWR VPWR u_interface.u_gelu_fp32.u_fp32_to_q16.s1_mant\[6\]
+ sky130_fd_sc_hd__dfxtp_1
XFILLER_125_167 VGND VGND VPWR VPWR sky130_fd_sc_hd__fill_1
XFILLER_113_329 VGND VGND VPWR VPWR sky130_fd_sc_hd__decap_6
X_11256_ _04997_ _04996_ VGND VGND VPWR VPWR _04998_ sky130_fd_sc_hd__and2b_1
XFILLER_5_69 VPWR VGND VPWR VGND sky130_ef_sc_hd__decap_12
XFILLER_4_475 VGND VGND VPWR VPWR sky130_fd_sc_hd__fill_1
XFILLER_140_137 VGND VGND VPWR VPWR sky130_fd_sc_hd__decap_3
XFILLER_122_830 VGND VGND VPWR VPWR sky130_fd_sc_hd__decap_6
X_10207_ _03782_ _03784_ _03955_ _03956_ VGND VGND VPWR VPWR _03958_ sky130_fd_sc_hd__a211oi_1
XFILLER_79_276 VGND VGND VPWR VPWR sky130_fd_sc_hd__decap_4
X_11187_ net703 net448 _04833_ _04832_ VGND VGND VPWR VPWR _04929_ sky130_fd_sc_hd__a31oi_2
X_10138_ net474 net478 net699 net707 VGND VGND VPWR VPWR _03889_ sky130_fd_sc_hd__and4_1
XTAP_TAPCELL_ROW_50_1140 VGND VPWR sky130_fd_sc_hd__tapvpwrvgnd_1
XFILLER_0_681 VGND VGND VPWR VPWR sky130_fd_sc_hd__fill_1
XFILLER_0_692 VGND VGND VPWR VPWR sky130_fd_sc_hd__decap_8
XFILLER_39_129 VPWR VGND VPWR VGND sky130_ef_sc_hd__decap_12
XTAP_TAPCELL_ROW_128_2387 VGND VPWR sky130_fd_sc_hd__tapvpwrvgnd_1
XTAP_TAPCELL_ROW_128_2376 VGND VPWR sky130_fd_sc_hd__tapvpwrvgnd_1
X_10069_ _03810_ _03820_ VGND VGND VPWR VPWR _03821_ sky130_fd_sc_hd__xnor2_1
Xclkbuf_leaf_59_clk clknet_3_4__leaf_clk VGND VGND VPWR VPWR clknet_leaf_59_clk sky130_fd_sc_hd__clkbuf_8
XFILLER_48_641 VGND VGND VPWR VPWR sky130_fd_sc_hd__decap_3
XFILLER_75_482 VGND VGND VPWR VPWR sky130_fd_sc_hd__decap_8
XFILLER_75_460 VGND VGND VPWR VPWR sky130_fd_sc_hd__fill_2
XFILLER_90_430 VGND VGND VPWR VPWR sky130_fd_sc_hd__decap_6
XFILLER_75_493 VGND VGND VPWR VPWR sky130_fd_sc_hd__decap_8
XTAP_TAPCELL_ROW_141_2598 VGND VPWR sky130_fd_sc_hd__tapvpwrvgnd_1
XTAP_TAPCELL_ROW_141_2587 VGND VPWR sky130_fd_sc_hd__tapvpwrvgnd_1
XFILLER_51_828 VPWR VGND VPWR VGND sky130_ef_sc_hd__decap_12
X_13828_ clknet_leaf_79_clk _00838_ VGND VGND VPWR VPWR u_interface.u_gelu_fp32.u_synth_top.s3_mult\[46\]
+ sky130_fd_sc_hd__dfxtp_1
XFILLER_90_496 VGND VGND VPWR VPWR sky130_fd_sc_hd__decap_6
XFILLER_50_327 VPWR VGND VPWR VGND sky130_ef_sc_hd__decap_12
X_13759_ clknet_leaf_82_clk _00769_ VGND VGND VPWR VPWR u_interface.u_gelu_fp32.u_q16_to_fp32.s1_mag\[25\]
+ sky130_fd_sc_hd__dfxtp_1
XFILLER_16_582 VGND VGND VPWR VPWR sky130_fd_sc_hd__decap_6
XFILLER_93_3 VPWR VGND VPWR VGND sky130_ef_sc_hd__decap_12
X_07280_ net1505 net367 net245 VGND VGND VPWR VPWR _00310_ sky130_fd_sc_hd__mux2_1
XFILLER_144_421 VPWR VGND VPWR VGND sky130_ef_sc_hd__decap_12
XPHY_EDGE_ROW_44_Left_200 VGND VGND VPWR VPWR sky130_fd_sc_hd__decap_3
XFILLER_8_781 VPWR VGND VPWR VGND sky130_ef_sc_hd__decap_12
Xhold214 u_interface.fifo_data\[1\]\[16\] VGND VGND VPWR VPWR net1079 sky130_fd_sc_hd__dlygate4sd3_1
Xhold225 u_interface.fifo_data\[5\]\[11\] VGND VGND VPWR VPWR net1090 sky130_fd_sc_hd__dlygate4sd3_1
Xhold203 u_interface.fifo_data\[5\]\[18\] VGND VGND VPWR VPWR net1068 sky130_fd_sc_hd__dlygate4sd3_1
Xhold269 u_interface.u_gelu_fp32.u_fp32_to_q16.s1_mant\[2\] VGND VGND VPWR VPWR net1134
+ sky130_fd_sc_hd__dlygate4sd3_1
XFILLER_144_498 VPWR VGND VPWR VGND sky130_ef_sc_hd__decap_12
XFILLER_144_487 VGND VGND VPWR VPWR sky130_fd_sc_hd__fill_1
Xhold247 u_interface.fifo_data\[10\]\[13\] VGND VGND VPWR VPWR net1112 sky130_fd_sc_hd__dlygate4sd3_1
XFILLER_116_178 VGND VGND VPWR VPWR sky130_fd_sc_hd__decap_8
Xhold258 u_interface.fifo_data\[9\]\[18\] VGND VGND VPWR VPWR net1123 sky130_fd_sc_hd__dlygate4sd3_1
X_09921_ _03673_ VGND VGND VPWR VPWR _03674_ sky130_fd_sc_hd__inv_2
Xhold236 u_interface.fifo_data\[12\]\[9\] VGND VGND VPWR VPWR net1101 sky130_fd_sc_hd__dlygate4sd3_1
XTAP_TAPCELL_ROW_148_2708 VGND VPWR sky130_fd_sc_hd__tapvpwrvgnd_1
Xfanout705 net707 VGND VGND VPWR VPWR net705 sky130_fd_sc_hd__clkbuf_4
Xfanout727 net728 VGND VGND VPWR VPWR net727 sky130_fd_sc_hd__clkbuf_4
XFILLER_140_671 VGND VGND VPWR VPWR sky130_fd_sc_hd__decap_3
Xfanout749 net754 VGND VGND VPWR VPWR net749 sky130_fd_sc_hd__clkbuf_4
X_09852_ _03603_ _03604_ _03605_ VGND VGND VPWR VPWR _03606_ sky130_fd_sc_hd__a21oi_1
XFILLER_98_552 VGND VGND VPWR VPWR sky130_fd_sc_hd__fill_1
Xfanout716 u_interface.u_gelu_fp32.u_synth_top.s2_m\[16\] VGND VGND VPWR VPWR net716
+ sky130_fd_sc_hd__clkbuf_4
Xfanout738 net739 VGND VGND VPWR VPWR net738 sky130_fd_sc_hd__clkbuf_4
X_08803_ net590 net476 net480 net598 VGND VGND VPWR VPWR _02562_ sky130_fd_sc_hd__a22o_1
XFILLER_112_384 VPWR VGND VPWR VGND sky130_ef_sc_hd__decap_12
XFILLER_105_37 VPWR VGND VPWR VGND sky130_ef_sc_hd__decap_12
X_09783_ net216 _03536_ VGND VGND VPWR VPWR _03537_ sky130_fd_sc_hd__xor2_1
XFILLER_58_449 VGND VGND VPWR VPWR sky130_fd_sc_hd__fill_1
X_06995_ net1088 net327 net247 VGND VGND VPWR VPWR _00047_ sky130_fd_sc_hd__mux2_1
X_08734_ net637 net646 net488 net493 VGND VGND VPWR VPWR _02493_ sky130_fd_sc_hd__nand4_2
XTAP_TAPCELL_ROW_68_1423 VGND VPWR sky130_fd_sc_hd__tapvpwrvgnd_1
X_08665_ _02267_ _02428_ VGND VGND VPWR VPWR _02429_ sky130_fd_sc_hd__xor2_1
X_07616_ net331 _01708_ VGND VGND VPWR VPWR _01709_ sky130_fd_sc_hd__nand2b_1
X_08596_ net154 _02378_ net801 VGND VGND VPWR VPWR _00784_ sky130_fd_sc_hd__a21oi_1
X_07547_ net811 net1773 net304 _01664_ VGND VGND VPWR VPWR _00448_ sky130_fd_sc_hd__a22o_1
XTAP_TAPCELL_ROW_81_1634 VGND VPWR sky130_fd_sc_hd__tapvpwrvgnd_1
XFILLER_54_699 VGND VGND VPWR VPWR sky130_fd_sc_hd__fill_1
XFILLER_22_530 VGND VGND VPWR VPWR sky130_fd_sc_hd__fill_2
X_07478_ net550 net557 _01561_ VGND VGND VPWR VPWR _01612_ sky130_fd_sc_hd__and3_1
XFILLER_10_725 VPWR VGND VPWR VGND sky130_ef_sc_hd__decap_12
X_09217_ _02931_ _02967_ _02972_ VGND VGND VPWR VPWR _02976_ sky130_fd_sc_hd__a21o_1
XFILLER_10_769 VPWR VGND VPWR VGND sky130_ef_sc_hd__decap_12
X_09148_ _02872_ _02905_ _02906_ VGND VGND VPWR VPWR _02907_ sky130_fd_sc_hd__or3_1
XFILLER_147_281 VPWR VGND VPWR VGND sky130_ef_sc_hd__decap_12
XFILLER_5_217 VGND VGND VPWR VPWR sky130_fd_sc_hd__decap_6
X_09079_ net622 net501 net507 net630 VGND VGND VPWR VPWR _02838_ sky130_fd_sc_hd__a22oi_2
XTAP_TAPCELL_ROW_79_1596 VGND VPWR sky130_fd_sc_hd__tapvpwrvgnd_1
XFILLER_135_476 VGND VGND VPWR VPWR sky130_fd_sc_hd__fill_2
XFILLER_135_465 VGND VGND VPWR VPWR sky130_fd_sc_hd__fill_2
XTAP_TAPCELL_ROW_112_2133 VGND VPWR sky130_fd_sc_hd__tapvpwrvgnd_1
XTAP_TAPCELL_ROW_112_2122 VGND VPWR sky130_fd_sc_hd__tapvpwrvgnd_1
X_11110_ net651 net422 VGND VGND VPWR VPWR _04853_ sky130_fd_sc_hd__nand2_1
XFILLER_30_77 VGND VGND VPWR VPWR sky130_fd_sc_hd__decap_6
Xhold781 u_interface.u_gelu_fp32.u_fp32_to_q16.s3_mag\[5\] VGND VGND VPWR VPWR net1646
+ sky130_fd_sc_hd__dlygate4sd3_1
Xhold770 u_interface.u_gelu_fp32.u_q16_to_fp32.s2_mag\[28\] VGND VGND VPWR VPWR net1635
+ sky130_fd_sc_hd__dlygate4sd3_1
X_12090_ _05821_ VGND VGND VPWR VPWR _05822_ sky130_fd_sc_hd__inv_2
XFILLER_104_863 VGND VGND VPWR VPWR sky130_fd_sc_hd__decap_4
Xhold792 _00887_ VGND VGND VPWR VPWR net1657 sky130_fd_sc_hd__dlygate4sd3_1
X_11041_ _04784_ _04783_ VGND VGND VPWR VPWR _04785_ sky130_fd_sc_hd__and2b_1
XFILLER_49_405 VGND VGND VPWR VPWR sky130_fd_sc_hd__decap_4
XFILLER_131_671 VGND VGND VPWR VPWR sky130_fd_sc_hd__fill_1
XFILLER_49_449 VGND VGND VPWR VPWR sky130_fd_sc_hd__decap_4
XFILLER_49_416 VGND VGND VPWR VPWR sky130_fd_sc_hd__fill_1
XFILLER_64_419 VGND VGND VPWR VPWR sky130_fd_sc_hd__fill_1
X_12992_ net1034 net366 net221 VGND VGND VPWR VPWR _01075_ sky130_fd_sc_hd__mux2_1
XFILLER_18_825 VPWR VGND VPWR VGND sky130_ef_sc_hd__decap_12
XFILLER_91_249 VGND VGND VPWR VPWR sky130_fd_sc_hd__decap_6
XFILLER_17_335 VGND VGND VPWR VPWR sky130_fd_sc_hd__fill_1
XFILLER_18_869 VPWR VGND VPWR VGND sky130_ef_sc_hd__decap_12
X_11943_ _05667_ _05676_ VGND VGND VPWR VPWR _05677_ sky130_fd_sc_hd__xor2_1
XFILLER_55_63 VGND VGND VPWR VPWR sky130_fd_sc_hd__fill_1
XFILLER_44_165 VGND VGND VPWR VPWR sky130_fd_sc_hd__fill_1
X_11874_ _05606_ _05607_ VGND VGND VPWR VPWR _05609_ sky130_fd_sc_hd__xnor2_1
X_13613_ clknet_leaf_40_clk _00623_ VGND VGND VPWR VPWR u_interface.fifo_data\[3\]\[28\]
+ sky130_fd_sc_hd__dfxtp_1
X_10825_ _04568_ _04569_ _04558_ VGND VGND VPWR VPWR _04570_ sky130_fd_sc_hd__a21o_1
XFILLER_32_327 VGND VGND VPWR VPWR sky130_fd_sc_hd__fill_2
XFILLER_33_839 VGND VGND VPWR VPWR sky130_fd_sc_hd__fill_1
XFILLER_13_541 VPWR VGND VPWR VGND sky130_ef_sc_hd__decap_12
XTAP_TAPCELL_ROW_15_569 VGND VPWR sky130_fd_sc_hd__tapvpwrvgnd_1
XFILLER_25_390 VGND VGND VPWR VPWR sky130_fd_sc_hd__fill_2
XFILLER_41_850 VGND VGND VPWR VPWR sky130_fd_sc_hd__decap_4
X_13544_ clknet_leaf_44_clk _00554_ VGND VGND VPWR VPWR u_interface.fifo_data\[5\]\[23\]
+ sky130_fd_sc_hd__dfxtp_1
XTAP_TAPCELL_ROW_99_1917 VGND VPWR sky130_fd_sc_hd__tapvpwrvgnd_1
X_10756_ _04499_ _04500_ _04501_ VGND VGND VPWR VPWR _04502_ sky130_fd_sc_hd__a21o_1
XFILLER_13_585 VPWR VGND VPWR VGND sky130_ef_sc_hd__decap_12
X_13475_ clknet_leaf_60_clk _00485_ VGND VGND VPWR VPWR u_interface.u_gelu_fp32.u_q16_to_fp32.s3_norm_mag\[15\]
+ sky130_fd_sc_hd__dfxtp_1
X_10687_ _04431_ _04432_ VGND VGND VPWR VPWR _04434_ sky130_fd_sc_hd__and2b_1
X_12426_ _06135_ _06152_ VGND VGND VPWR VPWR _06153_ sky130_fd_sc_hd__xnor2_1
XFILLER_141_413 VGND VGND VPWR VPWR sky130_fd_sc_hd__fill_2
XFILLER_126_465 VGND VGND VPWR VPWR sky130_fd_sc_hd__decap_8
X_12357_ _06082_ _06083_ VGND VGND VPWR VPWR _06085_ sky130_fd_sc_hd__xnor2_1
XFILLER_141_446 VGND VGND VPWR VPWR sky130_fd_sc_hd__fill_2
XFILLER_141_424 VGND VGND VPWR VPWR sky130_fd_sc_hd__decap_3
X_11308_ _05047_ _05048_ VGND VGND VPWR VPWR _05049_ sky130_fd_sc_hd__or2_1
X_12288_ _05743_ _05744_ _06015_ VGND VGND VPWR VPWR _06017_ sky130_fd_sc_hd__and3_1
X_14027_ clknet_leaf_26_clk _00953_ VGND VGND VPWR VPWR u_interface.core_data_out\[13\]
+ sky130_fd_sc_hd__dfxtp_1
X_11239_ net625 net404 net400 net617 VGND VGND VPWR VPWR _04981_ sky130_fd_sc_hd__a22oi_1
XFILLER_68_747 VGND VGND VPWR VPWR sky130_fd_sc_hd__fill_1
XTAP_TAPCELL_ROW_143_2616 VGND VPWR sky130_fd_sc_hd__tapvpwrvgnd_1
XTAP_TAPCELL_ROW_143_2627 VGND VPWR sky130_fd_sc_hd__tapvpwrvgnd_1
XFILLER_95_577 VGND VGND VPWR VPWR sky130_fd_sc_hd__decap_4
X_06780_ _01331_ _01333_ _01336_ net317 VGND VGND VPWR VPWR net118 sky130_fd_sc_hd__a22o_1
XFILLER_67_268 VGND VGND VPWR VPWR sky130_fd_sc_hd__decap_6
XFILLER_64_920 VGND VGND VPWR VPWR sky130_fd_sc_hd__fill_1
XFILLER_48_493 VGND VGND VPWR VPWR sky130_fd_sc_hd__decap_6
X_08450_ _02238_ _02240_ _02176_ VGND VGND VPWR VPWR _02241_ sky130_fd_sc_hd__a21o_1
X_07401_ net553 net554 net560 VGND VGND VPWR VPWR _01538_ sky130_fd_sc_hd__or3_1
X_08381_ u_interface.u_gelu_fp32.u_synth_top.s3_mult\[33\] u_interface.u_gelu_fp32.u_synth_top.s3_b\[17\]
+ VGND VGND VPWR VPWR _02172_ sky130_fd_sc_hd__or2_1
X_07332_ net1418 net566 net255 VGND VGND VPWR VPWR _00362_ sky130_fd_sc_hd__mux2_1
XTAP_TAPCELL_ROW_63_1342 VGND VPWR sky130_fd_sc_hd__tapvpwrvgnd_1
XFILLER_23_349 VGND VGND VPWR VPWR sky130_fd_sc_hd__decap_4
XFILLER_32_861 VGND VGND VPWR VPWR sky130_fd_sc_hd__decap_6
XFILLER_31_360 VGND VGND VPWR VPWR sky130_fd_sc_hd__decap_3
XTAP_TAPCELL_ROW_34_878 VGND VPWR sky130_fd_sc_hd__tapvpwrvgnd_1
XFILLER_137_708 VGND VGND VPWR VPWR sky130_fd_sc_hd__fill_1
X_07263_ net1291 net569 net250 VGND VGND VPWR VPWR _00295_ sky130_fd_sc_hd__mux2_1
X_09002_ _02707_ _02708_ _02758_ _02760_ VGND VGND VPWR VPWR _02761_ sky130_fd_sc_hd__o211ai_2
X_07194_ net380 net1569 net257 VGND VGND VPWR VPWR _00234_ sky130_fd_sc_hd__mux2_1
Xgelu_top_852 VGND VGND VPWR VPWR gelu_top_852/HI s_axil_rdata[20] sky130_fd_sc_hd__conb_1
XFILLER_145_741 VGND VGND VPWR VPWR sky130_fd_sc_hd__fill_2
XFILLER_129_281 VGND VGND VPWR VPWR sky130_fd_sc_hd__decap_3
XFILLER_117_432 VGND VGND VPWR VPWR sky130_fd_sc_hd__fill_1
Xgelu_top_841 VGND VGND VPWR VPWR gelu_top_841/HI s_axil_rdata[9] sky130_fd_sc_hd__conb_1
Xgelu_top_863 VGND VGND VPWR VPWR gelu_top_863/HI s_axil_rdata[31] sky130_fd_sc_hd__conb_1
XFILLER_144_251 VGND VGND VPWR VPWR sky130_fd_sc_hd__fill_1
XFILLER_2_209 VPWR VGND VPWR VGND sky130_ef_sc_hd__decap_12
XFILLER_144_295 VPWR VGND VPWR VGND sky130_ef_sc_hd__decap_12
XFILLER_117_498 VGND VGND VPWR VPWR sky130_fd_sc_hd__decap_6
Xfanout513 net514 VGND VGND VPWR VPWR net513 sky130_fd_sc_hd__clkbuf_2
Xfanout502 net503 VGND VGND VPWR VPWR net502 sky130_fd_sc_hd__buf_2
X_09904_ _03368_ _03532_ VGND VGND VPWR VPWR _03657_ sky130_fd_sc_hd__nand2_1
Xfanout524 net525 VGND VGND VPWR VPWR net524 sky130_fd_sc_hd__clkbuf_4
Xfanout557 u_interface.u_gelu_fp32.u_fp32_to_q16.s2_shift\[1\] VGND VGND VPWR VPWR
+ net557 sky130_fd_sc_hd__buf_2
Xfanout546 u_interface.u_gelu_fp32.u_fp32_to_q16.s2_shift\[3\] VGND VGND VPWR VPWR
+ net546 sky130_fd_sc_hd__buf_1
X_09835_ _03435_ _03437_ _03436_ VGND VGND VPWR VPWR _03589_ sky130_fd_sc_hd__a21bo_1
Xfanout535 net536 VGND VGND VPWR VPWR net535 sky130_fd_sc_hd__buf_2
XFILLER_101_833 VGND VGND VPWR VPWR sky130_fd_sc_hd__decap_6
XFILLER_98_371 VGND VGND VPWR VPWR sky130_fd_sc_hd__decap_8
XFILLER_98_360 VGND VGND VPWR VPWR sky130_fd_sc_hd__decap_4
Xfanout568 u_interface.core_data_out\[28\] VGND VGND VPWR VPWR net568 sky130_fd_sc_hd__buf_1
Xfanout579 net580 VGND VGND VPWR VPWR net579 sky130_fd_sc_hd__buf_2
X_06978_ net1080 net327 net271 VGND VGND VPWR VPWR _00041_ sky130_fd_sc_hd__mux2_1
XFILLER_132_35 VGND VGND VPWR VPWR sky130_fd_sc_hd__fill_1
X_09766_ _03519_ _03520_ VGND VGND VPWR VPWR _03521_ sky130_fd_sc_hd__nor2_1
XFILLER_100_365 VGND VGND VPWR VPWR sky130_fd_sc_hd__decap_6
XFILLER_46_408 VGND VGND VPWR VPWR sky130_fd_sc_hd__fill_2
X_08717_ _02473_ _02474_ _02475_ VGND VGND VPWR VPWR _02476_ sky130_fd_sc_hd__or3_1
X_09697_ _03450_ _03451_ _03447_ VGND VGND VPWR VPWR _03452_ sky130_fd_sc_hd__a21oi_1
XFILLER_54_441 VGND VGND VPWR VPWR sky130_fd_sc_hd__fill_1
X_08648_ _02258_ _02415_ VGND VGND VPWR VPWR _02416_ sky130_fd_sc_hd__xnor2_1
XFILLER_81_260 VGND VGND VPWR VPWR sky130_fd_sc_hd__fill_2
XFILLER_14_305 VGND VGND VPWR VPWR sky130_fd_sc_hd__decap_3
XFILLER_15_839 VGND VGND VPWR VPWR sky130_fd_sc_hd__fill_1
XFILLER_26_187 VGND VGND VPWR VPWR sky130_fd_sc_hd__decap_4
XFILLER_41_113 VPWR VGND VPWR VGND sky130_ef_sc_hd__decap_12
XFILLER_42_625 VGND VGND VPWR VPWR sky130_fd_sc_hd__decap_8
X_08579_ _02207_ _02208_ _02217_ VGND VGND VPWR VPWR _02367_ sky130_fd_sc_hd__a21o_1
XFILLER_14_349 VGND VGND VPWR VPWR sky130_fd_sc_hd__decap_8
XFILLER_25_55 VGND VGND VPWR VPWR sky130_fd_sc_hd__fill_1
X_10610_ net460 net695 _04354_ _04355_ VGND VGND VPWR VPWR _04357_ sky130_fd_sc_hd__nand4_1
XFILLER_22_360 VGND VGND VPWR VPWR sky130_fd_sc_hd__decap_4
X_11590_ _05320_ _05327_ VGND VGND VPWR VPWR _05328_ sky130_fd_sc_hd__xnor2_1
X_10541_ _04286_ _04287_ VGND VGND VPWR VPWR _04289_ sky130_fd_sc_hd__xnor2_1
XFILLER_10_533 VPWR VGND VPWR VGND sky130_ef_sc_hd__decap_12
XTAP_TAPCELL_ROW_12_528 VGND VPWR sky130_fd_sc_hd__tapvpwrvgnd_1
XFILLER_22_382 VGND VGND VPWR VPWR sky130_fd_sc_hd__decap_4
X_13260_ clknet_leaf_73_clk _00270_ VGND VGND VPWR VPWR u_interface.fifo_data\[0\]\[2\]
+ sky130_fd_sc_hd__dfxtp_1
XFILLER_136_752 VGND VGND VPWR VPWR sky130_fd_sc_hd__decap_4
XFILLER_108_421 VPWR VGND VPWR VGND sky130_ef_sc_hd__decap_12
X_10472_ _04202_ _04217_ _04218_ VGND VGND VPWR VPWR _04220_ sky130_fd_sc_hd__nand3_2
X_12211_ _05939_ _05940_ VGND VGND VPWR VPWR _05941_ sky130_fd_sc_hd__nor2_1
X_13191_ clknet_leaf_52_clk _00201_ VGND VGND VPWR VPWR u_interface.fifo_data\[12\]\[1\]
+ sky130_fd_sc_hd__dfxtp_1
XTAP_TAPCELL_ROW_94_1847 VGND VPWR sky130_fd_sc_hd__tapvpwrvgnd_1
XTAP_TAPCELL_ROW_94_1836 VGND VPWR sky130_fd_sc_hd__tapvpwrvgnd_1
X_12142_ net201 _05872_ VGND VGND VPWR VPWR _05873_ sky130_fd_sc_hd__nor2_1
X_12073_ net202 _05737_ _05736_ VGND VGND VPWR VPWR _05805_ sky130_fd_sc_hd__o21ba_1
X_11024_ _04516_ _04638_ _04641_ VGND VGND VPWR VPWR _04768_ sky130_fd_sc_hd__o21ai_1
XFILLER_49_213 VGND VGND VPWR VPWR sky130_fd_sc_hd__decap_8
XFILLER_2_15 VPWR VGND VPWR VGND sky130_ef_sc_hd__decap_12
XFILLER_89_393 VPWR VGND VPWR VGND sky130_ef_sc_hd__decap_12
XTAP_TAPCELL_ROW_125_2335 VGND VPWR sky130_fd_sc_hd__tapvpwrvgnd_1
X_12975_ u_interface.fifo_count\[4\] _06468_ _06492_ net790 VGND VGND VPWR VPWR _01063_
+ sky130_fd_sc_hd__o211a_1
XFILLER_64_249 VGND VGND VPWR VPWR sky130_fd_sc_hd__decap_3
XFILLER_64_227 VGND VGND VPWR VPWR sky130_fd_sc_hd__fill_2
X_11926_ _05658_ _05659_ VGND VGND VPWR VPWR _05660_ sky130_fd_sc_hd__nor2_1
XFILLER_122_90 VGND VGND VPWR VPWR sky130_fd_sc_hd__decap_8
XFILLER_45_485 VPWR VGND VPWR VGND sky130_ef_sc_hd__decap_12
XFILLER_17_176 VPWR VGND VPWR VGND sky130_ef_sc_hd__decap_12
XFILLER_18_699 VGND VGND VPWR VPWR sky130_fd_sc_hd__fill_1
X_11857_ net717 net420 VGND VGND VPWR VPWR _05592_ sky130_fd_sc_hd__and2_1
XFILLER_21_809 VPWR VGND VPWR VGND sky130_ef_sc_hd__decap_12
XTAP_TAPCELL_ROW_103_1987 VGND VPWR sky130_fd_sc_hd__tapvpwrvgnd_1
XTAP_TAPCELL_ROW_103_1976 VGND VPWR sky130_fd_sc_hd__tapvpwrvgnd_1
X_10808_ _04552_ _04553_ VGND VGND VPWR VPWR _04554_ sky130_fd_sc_hd__or2_1
XFILLER_60_477 VGND VGND VPWR VPWR sky130_fd_sc_hd__decap_4
XTAP_TAPCELL_ROW_45_1061 VGND VPWR sky130_fd_sc_hd__tapvpwrvgnd_1
XTAP_TAPCELL_ROW_45_1050 VGND VPWR sky130_fd_sc_hd__tapvpwrvgnd_1
XFILLER_14_861 VGND VGND VPWR VPWR sky130_fd_sc_hd__decap_6
X_11788_ net666 net675 net401 net397 VGND VGND VPWR VPWR _05524_ sky130_fd_sc_hd__and4_1
XTAP_TAPCELL_ROW_31_826 VGND VPWR sky130_fd_sc_hd__tapvpwrvgnd_1
X_10739_ _04468_ _04480_ _04481_ VGND VGND VPWR VPWR _04485_ sky130_fd_sc_hd__or3_1
X_13527_ clknet_leaf_71_clk _00537_ VGND VGND VPWR VPWR u_interface.fifo_data\[5\]\[6\]
+ sky130_fd_sc_hd__dfxtp_1
XFILLER_13_393 VGND VGND VPWR VPWR sky130_fd_sc_hd__decap_8
XTAP_TAPCELL_ROW_31_837 VGND VPWR sky130_fd_sc_hd__tapvpwrvgnd_1
X_13458_ clknet_leaf_13_clk _00468_ VGND VGND VPWR VPWR u_interface.u_gelu_fp32.u_fp32_to_q16.s3_mag\[29\]
+ sky130_fd_sc_hd__dfxtp_1
Xoutput116 net116 VGND VGND VPWR VPWR m_axis_tdata[16] sky130_fd_sc_hd__buf_2
XFILLER_154_571 VGND VGND VPWR VPWR sky130_fd_sc_hd__fill_2
XFILLER_56_3 VPWR VGND VPWR VGND sky130_ef_sc_hd__decap_12
X_13389_ clknet_leaf_73_clk _00399_ VGND VGND VPWR VPWR u_interface.fifo_data\[6\]\[2\]
+ sky130_fd_sc_hd__dfxtp_1
X_12409_ _06135_ VGND VGND VPWR VPWR _06136_ sky130_fd_sc_hd__inv_2
Xoutput149 net149 VGND VGND VPWR VPWR s_axil_wready sky130_fd_sc_hd__buf_2
Xoutput127 net127 VGND VGND VPWR VPWR m_axis_tdata[26] sky130_fd_sc_hd__buf_2
Xoutput138 net138 VGND VGND VPWR VPWR m_axis_tdata[7] sky130_fd_sc_hd__buf_2
XFILLER_142_755 VGND VGND VPWR VPWR sky130_fd_sc_hd__fill_1
X_07950_ net813 _01825_ VGND VGND VPWR VPWR _00679_ sky130_fd_sc_hd__nor2_1
XFILLER_114_468 VGND VGND VPWR VPWR sky130_fd_sc_hd__decap_8
XFILLER_141_265 VGND VGND VPWR VPWR sky130_fd_sc_hd__decap_4
X_06901_ u_interface.u_gelu_fp32.u_synth_top.s1_hits\[17\] u_interface.u_gelu_fp32.u_synth_top.s1_hits\[18\]
+ _01187_ _01441_ VGND VGND VPWR VPWR _01442_ sky130_fd_sc_hd__nor4_1
XFILLER_68_511 VGND VGND VPWR VPWR sky130_fd_sc_hd__fill_1
X_07881_ net1360 net355 net266 VGND VGND VPWR VPWR _00642_ sky130_fd_sc_hd__mux2_1
XFILLER_29_909 VGND VGND VPWR VPWR sky130_fd_sc_hd__decap_8
XFILLER_110_685 VGND VGND VPWR VPWR sky130_fd_sc_hd__fill_2
X_09620_ net215 _03375_ VGND VGND VPWR VPWR _03376_ sky130_fd_sc_hd__xnor2_1
X_06832_ net322 _01379_ net728 VGND VGND VPWR VPWR _01382_ sky130_fd_sc_hd__o21a_1
XFILLER_83_503 VGND VGND VPWR VPWR sky130_fd_sc_hd__fill_1
XFILLER_28_408 VGND VGND VPWR VPWR sky130_fd_sc_hd__fill_2
X_06763_ _01320_ _01321_ net735 VGND VGND VPWR VPWR _01322_ sky130_fd_sc_hd__mux2_1
X_09551_ _03267_ _03268_ _03306_ VGND VGND VPWR VPWR _03308_ sky130_fd_sc_hd__nand3_2
XFILLER_110_696 VGND VGND VPWR VPWR sky130_fd_sc_hd__decap_4
XTAP_TAPCELL_ROW_39_959 VGND VPWR sky130_fd_sc_hd__tapvpwrvgnd_1
XFILLER_48_290 VPWR VGND VPWR VGND sky130_ef_sc_hd__decap_12
X_08502_ net521 u_interface.u_gelu_fp32.u_synth_top.s3_mult\[50\] VGND VGND VPWR VPWR
+ _02293_ sky130_fd_sc_hd__or2_1
XFILLER_36_430 VPWR VGND VPWR VGND sky130_ef_sc_hd__decap_12
X_09482_ net215 _03238_ VGND VGND VPWR VPWR _03239_ sky130_fd_sc_hd__xor2_1
XFILLER_51_422 VGND VGND VPWR VPWR sky130_fd_sc_hd__fill_1
XFILLER_23_113 VPWR VGND VPWR VGND sky130_ef_sc_hd__decap_12
XFILLER_36_474 VGND VGND VPWR VPWR sky130_fd_sc_hd__fill_2
X_06694_ u_interface.fifo_data\[12\]\[8\] u_interface.fifo_data\[13\]\[8\] u_interface.fifo_data\[14\]\[8\]
+ u_interface.fifo_data\[15\]\[8\] net757 net740 VGND VGND VPWR VPWR _01261_ sky130_fd_sc_hd__mux4_1
X_08433_ _02197_ _02223_ _02196_ VGND VGND VPWR VPWR _02224_ sky130_fd_sc_hd__a21boi_1
XFILLER_63_293 VGND VGND VPWR VPWR sky130_fd_sc_hd__fill_1
XFILLER_51_433 VGND VGND VPWR VPWR sky130_fd_sc_hd__decap_4
XFILLER_24_669 VPWR VGND VPWR VGND sky130_ef_sc_hd__decap_12
X_08364_ u_interface.u_gelu_fp32.u_synth_top.s3_mult\[63\] net525 VGND VGND VPWR VPWR
+ _02155_ sky130_fd_sc_hd__and2_1
XFILLER_149_365 VGND VGND VPWR VPWR sky130_fd_sc_hd__fill_1
X_07315_ net1159 net361 net254 VGND VGND VPWR VPWR _00345_ sky130_fd_sc_hd__mux2_1
XFILLER_149_376 VGND VGND VPWR VPWR sky130_fd_sc_hd__decap_6
XFILLER_137_527 VPWR VGND VPWR VGND sky130_ef_sc_hd__decap_12
X_08295_ u_interface.u_gelu_fp32.s2_data\[13\] _02101_ VGND VGND VPWR VPWR _02104_
+ sky130_fd_sc_hd__or2_1
X_07246_ net1032 net364 net251 VGND VGND VPWR VPWR _00278_ sky130_fd_sc_hd__mux2_1
XFILLER_152_519 VGND VGND VPWR VPWR sky130_fd_sc_hd__fill_1
X_07177_ net967 net351 net264 VGND VGND VPWR VPWR _00217_ sky130_fd_sc_hd__mux2_1
XFILLER_11_57 VPWR VGND VPWR VGND sky130_ef_sc_hd__decap_12
XFILLER_127_57 VGND VGND VPWR VPWR sky130_fd_sc_hd__fill_2
XFILLER_105_424 VGND VGND VPWR VPWR sky130_fd_sc_hd__decap_8
XTAP_TAPCELL_ROW_76_1555 VGND VPWR sky130_fd_sc_hd__tapvpwrvgnd_1
XTAP_TAPCELL_ROW_76_1544 VGND VPWR sky130_fd_sc_hd__tapvpwrvgnd_1
XFILLER_3_529 VPWR VGND VPWR VGND sky130_ef_sc_hd__decap_12
XFILLER_105_468 VGND VGND VPWR VPWR sky130_fd_sc_hd__decap_6
Xfanout310 net312 VGND VGND VPWR VPWR net310 sky130_fd_sc_hd__buf_2
Xfanout321 _01107_ VGND VGND VPWR VPWR net321 sky130_fd_sc_hd__buf_2
Xfanout332 net335 VGND VGND VPWR VPWR net332 sky130_fd_sc_hd__clkbuf_4
Xfanout365 u_interface.core_data_out\[10\] VGND VGND VPWR VPWR net365 sky130_fd_sc_hd__buf_1
Xfanout354 u_interface.core_data_out\[15\] VGND VGND VPWR VPWR net354 sky130_fd_sc_hd__clkbuf_2
Xfanout343 u_interface.core_data_out\[21\] VGND VGND VPWR VPWR net343 sky130_fd_sc_hd__buf_1
X_09818_ _03570_ _03571_ VGND VGND VPWR VPWR _03572_ sky130_fd_sc_hd__and2b_1
Xfanout376 u_interface.core_data_out\[4\] VGND VGND VPWR VPWR net376 sky130_fd_sc_hd__clkbuf_2
Xfanout387 net388 VGND VGND VPWR VPWR net387 sky130_fd_sc_hd__buf_2
Xfanout398 net399 VGND VGND VPWR VPWR net398 sky130_fd_sc_hd__clkbuf_2
XTAP_TAPCELL_ROW_107_2054 VGND VPWR sky130_fd_sc_hd__tapvpwrvgnd_1
XTAP_TAPCELL_ROW_107_2043 VGND VPWR sky130_fd_sc_hd__tapvpwrvgnd_1
X_09749_ _03502_ _03503_ _03359_ VGND VGND VPWR VPWR _03504_ sky130_fd_sc_hd__a21o_1
XTAP_TAPCELL_ROW_17_609 VGND VPWR sky130_fd_sc_hd__tapvpwrvgnd_1
XFILLER_36_54 VPWR VGND VPWR VGND sky130_ef_sc_hd__decap_12
X_12760_ u_interface.u_gelu_fp32.u_q16_to_fp32.s3_norm_mag\[8\] _06396_ net297 net1760
+ VGND VGND VPWR VPWR _00940_ sky130_fd_sc_hd__o211a_1
XTAP_TAPCELL_ROW_120_2254 VGND VPWR sky130_fd_sc_hd__tapvpwrvgnd_1
X_12691_ net807 u_interface.u_gelu_fp32.u_q16_to_fp32.s3_norm_mag\[18\] _01707_ _06344_
+ VGND VGND VPWR VPWR _06351_ sky130_fd_sc_hd__a22o_1
X_11711_ _05445_ _05446_ VGND VGND VPWR VPWR _05448_ sky130_fd_sc_hd__xnor2_1
X_11642_ _05345_ _05379_ VGND VGND VPWR VPWR _05380_ sky130_fd_sc_hd__xnor2_1
XFILLER_42_477 VPWR VGND VPWR VGND sky130_ef_sc_hd__decap_12
XFILLER_52_75 VGND VGND VPWR VPWR sky130_fd_sc_hd__decap_8
XFILLER_52_53 VGND VGND VPWR VPWR sky130_fd_sc_hd__fill_2
Xinput18 s_axil_araddr[23] VGND VGND VPWR VPWR net18 sky130_fd_sc_hd__clkbuf_1
XFILLER_128_516 VGND VGND VPWR VPWR sky130_fd_sc_hd__fill_2
X_11573_ _04912_ _05311_ _05310_ VGND VGND VPWR VPWR _05312_ sky130_fd_sc_hd__o21ai_2
XFILLER_11_853 VPWR VGND VPWR VGND sky130_ef_sc_hd__decap_12
X_13312_ clknet_leaf_76_clk _00322_ VGND VGND VPWR VPWR u_interface.fifo_data\[8\]\[21\]
+ sky130_fd_sc_hd__dfxtp_1
Xinput29 s_axil_araddr[4] VGND VGND VPWR VPWR net29 sky130_fd_sc_hd__clkbuf_1
X_10524_ _04270_ _04271_ _04263_ VGND VGND VPWR VPWR _04272_ sky130_fd_sc_hd__a21o_1
XFILLER_10_385 VPWR VGND VPWR VGND sky130_ef_sc_hd__decap_12
XFILLER_11_897 VPWR VGND VPWR VGND sky130_ef_sc_hd__decap_12
XFILLER_155_379 VGND VGND VPWR VPWR sky130_fd_sc_hd__fill_2
X_10455_ _04087_ _04094_ _04095_ VGND VGND VPWR VPWR _04203_ sky130_fd_sc_hd__a21bo_1
X_13243_ clknet_leaf_77_clk _00253_ VGND VGND VPWR VPWR u_interface.fifo_data\[11\]\[21\]
+ sky130_fd_sc_hd__dfxtp_1
X_13174_ clknet_leaf_31_clk _00184_ VGND VGND VPWR VPWR u_interface.fifo_data\[9\]\[16\]
+ sky130_fd_sc_hd__dfxtp_1
XFILLER_124_733 VGND VGND VPWR VPWR sky130_fd_sc_hd__decap_6
XFILLER_123_221 VGND VGND VPWR VPWR sky130_fd_sc_hd__decap_3
XFILLER_151_552 VGND VGND VPWR VPWR sky130_fd_sc_hd__decap_8
XFILLER_124_766 VGND VGND VPWR VPWR sky130_fd_sc_hd__decap_4
XFILLER_97_617 VGND VGND VPWR VPWR sky130_fd_sc_hd__fill_1
X_10386_ _04131_ _04132_ _04133_ VGND VGND VPWR VPWR _04135_ sky130_fd_sc_hd__and3_1
X_12125_ _05800_ _05856_ VGND VGND VPWR VPWR _05857_ sky130_fd_sc_hd__xnor2_1
XFILLER_77_50 VGND VGND VPWR VPWR sky130_fd_sc_hd__decap_6
X_12056_ net193 _05788_ VGND VGND VPWR VPWR _05789_ sky130_fd_sc_hd__or2_1
X_11007_ _04741_ _04749_ VGND VGND VPWR VPWR _04751_ sky130_fd_sc_hd__xnor2_1
XFILLER_93_856 VGND VGND VPWR VPWR sky130_fd_sc_hd__decap_6
XFILLER_93_845 VGND VGND VPWR VPWR sky130_fd_sc_hd__fill_2
XFILLER_65_569 VPWR VGND VPWR VGND sky130_ef_sc_hd__decap_12
XTAP_TAPCELL_ROW_36_907 VGND VPWR sky130_fd_sc_hd__tapvpwrvgnd_1
XTAP_TAPCELL_ROW_36_918 VGND VPWR sky130_fd_sc_hd__tapvpwrvgnd_1
X_12958_ _06476_ _06477_ _06472_ _06473_ VGND VGND VPWR VPWR _06478_ sky130_fd_sc_hd__o211a_1
XFILLER_18_463 VPWR VGND VPWR VGND sky130_ef_sc_hd__decap_12
X_12889_ net785 net922 VGND VGND VPWR VPWR _01031_ sky130_fd_sc_hd__and2_1
X_11909_ _05310_ _05643_ VGND VGND VPWR VPWR _05644_ sky130_fd_sc_hd__or2_1
XTAP_TAPCELL_ROW_60_1301 VGND VPWR sky130_fd_sc_hd__tapvpwrvgnd_1
XFILLER_21_617 VPWR VGND VPWR VGND sky130_ef_sc_hd__decap_12
XTAP_TAPCELL_ROW_138_2548 VGND VPWR sky130_fd_sc_hd__tapvpwrvgnd_1
XTAP_TAPCELL_ROW_138_2537 VGND VPWR sky130_fd_sc_hd__tapvpwrvgnd_1
XFILLER_60_296 VPWR VGND VPWR VGND sky130_ef_sc_hd__decap_12
X_07100_ net1027 net347 net228 VGND VGND VPWR VPWR _00140_ sky130_fd_sc_hd__mux2_1
XFILLER_119_527 VGND VGND VPWR VPWR sky130_fd_sc_hd__fill_1
XFILLER_9_161 VGND VGND VPWR VPWR sky130_fd_sc_hd__decap_6
X_08080_ _01876_ _01931_ VGND VGND VPWR VPWR _01932_ sky130_fd_sc_hd__or2_1
XTAP_TAPCELL_ROW_151_2759 VGND VPWR sky130_fd_sc_hd__tapvpwrvgnd_1
XTAP_TAPCELL_ROW_151_2748 VGND VPWR sky130_fd_sc_hd__tapvpwrvgnd_1
X_07031_ net1285 net357 net271 VGND VGND VPWR VPWR _00071_ sky130_fd_sc_hd__mux2_1
XFILLER_127_571 VGND VGND VPWR VPWR sky130_fd_sc_hd__fill_2
XTAP_TAPCELL_ROW_58_1263 VGND VPWR sky130_fd_sc_hd__tapvpwrvgnd_1
XPHY_EDGE_ROW_143_Right_143 VGND VGND VPWR VPWR sky130_fd_sc_hd__decap_3
X_08982_ net637 net502 net508 net646 VGND VGND VPWR VPWR _02741_ sky130_fd_sc_hd__a22oi_1
XFILLER_142_585 VGND VGND VPWR VPWR sky130_fd_sc_hd__decap_3
X_07933_ net817 net560 _01826_ VGND VGND VPWR VPWR _00673_ sky130_fd_sc_hd__a21o_1
XFILLER_114_298 VGND VGND VPWR VPWR sky130_fd_sc_hd__fill_1
XTAP_TAPCELL_ROW_71_1474 VGND VPWR sky130_fd_sc_hd__tapvpwrvgnd_1
XFILLER_69_897 VGND VGND VPWR VPWR sky130_fd_sc_hd__decap_3
XFILLER_69_875 VGND VGND VPWR VPWR sky130_fd_sc_hd__decap_6
X_07864_ net563 net1528 net282 VGND VGND VPWR VPWR _00625_ sky130_fd_sc_hd__mux2_1
X_06815_ net322 _01366_ VGND VGND VPWR VPWR _01367_ sky130_fd_sc_hd__or2_1
X_09603_ _03280_ _03298_ _03357_ _03358_ VGND VGND VPWR VPWR _03359_ sky130_fd_sc_hd__o211a_1
XFILLER_68_396 VGND VGND VPWR VPWR sky130_fd_sc_hd__fill_1
X_07795_ net1059 net573 net236 VGND VGND VPWR VPWR _00556_ sky130_fd_sc_hd__mux2_1
XFILLER_28_249 VGND VGND VPWR VPWR sky130_fd_sc_hd__decap_3
X_06746_ u_interface.fifo_data\[4\]\[14\] u_interface.fifo_data\[5\]\[14\] u_interface.fifo_data\[6\]\[14\]
+ u_interface.fifo_data\[7\]\[14\] net764 net747 VGND VGND VPWR VPWR _01307_ sky130_fd_sc_hd__mux4_1
X_09534_ _03287_ _03288_ _03289_ VGND VGND VPWR VPWR _03291_ sky130_fd_sc_hd__nand3_1
XFILLER_24_400 VGND VGND VPWR VPWR sky130_fd_sc_hd__decap_4
XFILLER_37_794 VGND VGND VPWR VPWR sky130_fd_sc_hd__decap_6
X_09465_ _02814_ _03133_ VGND VGND VPWR VPWR _03223_ sky130_fd_sc_hd__nand2_1
X_06677_ u_interface.fifo_data\[8\]\[6\] u_interface.fifo_data\[9\]\[6\] u_interface.fifo_data\[10\]\[6\]
+ u_interface.fifo_data\[11\]\[6\] net755 net738 VGND VGND VPWR VPWR _01246_ sky130_fd_sc_hd__mux4_1
X_08416_ u_interface.u_gelu_fp32.u_synth_top.s3_mult\[19\] u_interface.u_gelu_fp32.u_synth_top.s3_b\[3\]
+ VGND VGND VPWR VPWR _02207_ sky130_fd_sc_hd__nand2_1
XFILLER_11_105 VGND VGND VPWR VPWR sky130_fd_sc_hd__decap_6
X_09396_ _03152_ _03153_ VGND VGND VPWR VPWR _03154_ sky130_fd_sc_hd__nor2_1
X_08347_ u_interface.u_gelu_fp32.s2_data\[26\] _02140_ VGND VGND VPWR VPWR _02143_
+ sky130_fd_sc_hd__or2_1
XFILLER_11_149 VPWR VGND VPWR VGND sky130_ef_sc_hd__decap_12
XFILLER_137_335 VGND VGND VPWR VPWR sky130_fd_sc_hd__fill_1
X_08278_ _02090_ _02091_ VGND VGND VPWR VPWR _00753_ sky130_fd_sc_hd__nor2_1
XTAP_TAPCELL_ROW_22_689 VGND VPWR sky130_fd_sc_hd__tapvpwrvgnd_1
X_07229_ net1731 _01528_ net790 VGND VGND VPWR VPWR _01531_ sky130_fd_sc_hd__o21ai_1
XFILLER_152_305 VGND VGND VPWR VPWR sky130_fd_sc_hd__decap_3
XFILLER_4_805 VGND VGND VPWR VPWR sky130_fd_sc_hd__decap_6
X_10240_ _03987_ _03988_ _03989_ VGND VGND VPWR VPWR _03990_ sky130_fd_sc_hd__a21o_1
XFILLER_4_849 VPWR VGND VPWR VGND sky130_ef_sc_hd__decap_12
XFILLER_3_337 VPWR VGND VPWR VGND sky130_ef_sc_hd__decap_12
XFILLER_106_799 VGND VGND VPWR VPWR sky130_fd_sc_hd__decap_3
X_10171_ _03887_ _03919_ _03920_ VGND VGND VPWR VPWR _03922_ sky130_fd_sc_hd__nand3_1
XFILLER_120_235 VGND VGND VPWR VPWR sky130_fd_sc_hd__decap_6
XPHY_EDGE_ROW_110_Right_110 VGND VGND VPWR VPWR sky130_fd_sc_hd__decap_3
Xfanout162 net164 VGND VGND VPWR VPWR net162 sky130_fd_sc_hd__buf_2
X_13930_ clknet_leaf_5_clk _00015_ VGND VGND VPWR VPWR u_interface.u_gelu_fp32.u_synth_top.s1_hits\[2\]
+ sky130_fd_sc_hd__dfxtp_1
XFILLER_47_503 VGND VGND VPWR VPWR sky130_fd_sc_hd__fill_1
Xfanout151 _06250_ VGND VGND VPWR VPWR net151 sky130_fd_sc_hd__clkbuf_2
XTAP_TAPCELL_ROW_89_1757 VGND VPWR sky130_fd_sc_hd__tapvpwrvgnd_1
Xfanout195 _03752_ VGND VGND VPWR VPWR net195 sky130_fd_sc_hd__clkbuf_4
Xfanout184 _05024_ VGND VGND VPWR VPWR net184 sky130_fd_sc_hd__clkbuf_4
X_13861_ clknet_leaf_89_clk _00871_ VGND VGND VPWR VPWR u_interface.u_gelu_fp32.u_synth_top.s3_b\[17\]
+ sky130_fd_sc_hd__dfxtp_1
X_12812_ net778 net102 VGND VGND VPWR VPWR _00970_ sky130_fd_sc_hd__and2_1
XFILLER_90_837 VGND VGND VPWR VPWR sky130_fd_sc_hd__fill_2
X_13792_ clknet_leaf_82_clk _00802_ VGND VGND VPWR VPWR u_interface.u_gelu_fp32.s2_data\[26\]
+ sky130_fd_sc_hd__dfxtp_1
XTAP_TAPCELL_ROW_2_370 VGND VPWR sky130_fd_sc_hd__tapvpwrvgnd_1
X_12743_ u_interface.u_gelu_fp32.u_q16_to_fp32.s2_mag\[30\] u_interface.u_gelu_fp32.u_q16_to_fp32.s2_mag\[29\]
+ net336 VGND VGND VPWR VPWR _06391_ sky130_fd_sc_hd__mux2_1
XFILLER_15_433 VGND VGND VPWR VPWR sky130_fd_sc_hd__decap_4
XFILLER_43_764 VPWR VGND VPWR VGND sky130_ef_sc_hd__decap_12
XTAP_TAPCELL_ROW_100_1935 VGND VPWR sky130_fd_sc_hd__tapvpwrvgnd_1
XFILLER_63_96 VGND VGND VPWR VPWR sky130_fd_sc_hd__fill_1
X_12674_ u_interface.u_gelu_fp32.u_q16_to_fp32.s1_mag\[29\] net1631 net798 VGND VGND
+ VPWR VPWR _00910_ sky130_fd_sc_hd__mux2_1
XFILLER_30_414 VGND VGND VPWR VPWR sky130_fd_sc_hd__decap_6
XFILLER_30_425 VGND VGND VPWR VPWR sky130_fd_sc_hd__fill_1
X_11625_ net642 net393 VGND VGND VPWR VPWR _05363_ sky130_fd_sc_hd__nand2_1
X_11556_ _05292_ _05293_ VGND VGND VPWR VPWR _05295_ sky130_fd_sc_hd__xnor2_1
XTAP_TAPCELL_ROW_41_987 VGND VPWR sky130_fd_sc_hd__tapvpwrvgnd_1
XTAP_TAPCELL_ROW_41_998 VGND VPWR sky130_fd_sc_hd__tapvpwrvgnd_1
XFILLER_116_519 VPWR VGND VPWR VGND sky130_ef_sc_hd__decap_12
X_10507_ _04170_ _04172_ _04252_ _04253_ VGND VGND VPWR VPWR _04255_ sky130_fd_sc_hd__a211o_1
XFILLER_7_665 VGND VGND VPWR VPWR sky130_fd_sc_hd__decap_6
XFILLER_6_153 VPWR VGND VPWR VGND sky130_ef_sc_hd__decap_12
XTAP_TAPCELL_ROW_133_2467 VGND VPWR sky130_fd_sc_hd__tapvpwrvgnd_1
XTAP_TAPCELL_ROW_133_2456 VGND VPWR sky130_fd_sc_hd__tapvpwrvgnd_1
X_13226_ clknet_leaf_48_clk _00236_ VGND VGND VPWR VPWR u_interface.fifo_data\[11\]\[4\]
+ sky130_fd_sc_hd__dfxtp_1
X_11487_ net460 _04816_ VGND VGND VPWR VPWR _05226_ sky130_fd_sc_hd__and2_1
X_10438_ _04185_ _04186_ VGND VGND VPWR VPWR _04187_ sky130_fd_sc_hd__nand2_1
XFILLER_6_197 VPWR VGND VPWR VGND sky130_ef_sc_hd__decap_12
XFILLER_152_883 VGND VGND VPWR VPWR sky130_fd_sc_hd__fill_1
X_13157_ clknet_leaf_36_clk _00167_ VGND VGND VPWR VPWR u_interface.fifo_tlast\[15\]
+ sky130_fd_sc_hd__dfxtp_1
X_10369_ _04115_ _04116_ _04117_ VGND VGND VPWR VPWR _04118_ sky130_fd_sc_hd__a21oi_1
XFILLER_151_393 VGND VGND VPWR VPWR sky130_fd_sc_hd__decap_8
XFILLER_69_149 VGND VGND VPWR VPWR sky130_fd_sc_hd__decap_4
X_13088_ clknet_leaf_71_clk _00098_ VGND VGND VPWR VPWR u_interface.fifo_data\[15\]\[9\]
+ sky130_fd_sc_hd__dfxtp_1
X_12108_ _05837_ _05838_ VGND VGND VPWR VPWR _05840_ sky130_fd_sc_hd__xnor2_1
XTAP_TAPCELL_ROW_53_1182 VGND VPWR sky130_fd_sc_hd__tapvpwrvgnd_1
X_12039_ _05769_ _05770_ VGND VGND VPWR VPWR _05772_ sky130_fd_sc_hd__xnor2_1
XFILLER_65_322 VPWR VGND VPWR VGND sky130_ef_sc_hd__decap_12
XFILLER_19_3 VPWR VGND VPWR VGND sky130_ef_sc_hd__decap_12
XFILLER_92_141 VGND VGND VPWR VPWR sky130_fd_sc_hd__decap_8
XFILLER_92_130 VGND VGND VPWR VPWR sky130_fd_sc_hd__fill_1
XFILLER_66_878 VGND VGND VPWR VPWR sky130_fd_sc_hd__decap_4
XTAP_TAPCELL_ROW_0_318 VGND VPWR sky130_fd_sc_hd__tapvpwrvgnd_1
X_07580_ net308 _01631_ VGND VGND VPWR VPWR _01687_ sky130_fd_sc_hd__and2_1
X_06600_ _01181_ VGND VGND VPWR VPWR _00016_ sky130_fd_sc_hd__inv_2
XFILLER_93_686 VPWR VGND VPWR VGND sky130_ef_sc_hd__decap_12
XFILLER_65_399 VPWR VGND VPWR VGND sky130_ef_sc_hd__decap_12
XFILLER_65_388 VGND VGND VPWR VPWR sky130_fd_sc_hd__decap_4
XFILLER_53_517 VGND VGND VPWR VPWR sky130_fd_sc_hd__fill_1
XTAP_TAPCELL_ROW_0_329 VGND VPWR sky130_fd_sc_hd__tapvpwrvgnd_1
XFILLER_19_783 VGND VGND VPWR VPWR sky130_fd_sc_hd__fill_1
X_06531_ u_interface.u_gelu_fp32.u_synth_top.s1_hits\[7\] u_interface.u_gelu_fp32.u_synth_top.s1_hits\[9\]
+ _01129_ _01103_ VGND VGND VPWR VPWR _01130_ sky130_fd_sc_hd__o31ai_2
X_09250_ _02995_ _02997_ VGND VGND VPWR VPWR _03009_ sky130_fd_sc_hd__xnor2_1
XFILLER_80_369 VGND VGND VPWR VPWR sky130_fd_sc_hd__decap_8
XFILLER_61_561 VGND VGND VPWR VPWR sky130_fd_sc_hd__fill_1
XFILLER_33_241 VGND VGND VPWR VPWR sky130_fd_sc_hd__fill_1
X_08201_ net289 _02033_ VGND VGND VPWR VPWR _00734_ sky130_fd_sc_hd__nor2_1
XFILLER_21_425 VGND VGND VPWR VPWR sky130_fd_sc_hd__fill_1
X_09181_ _02895_ _02926_ _02938_ VGND VGND VPWR VPWR _02940_ sky130_fd_sc_hd__nand3_1
XFILLER_21_447 VGND VGND VPWR VPWR sky130_fd_sc_hd__fill_1
XFILLER_146_121 VGND VGND VPWR VPWR sky130_fd_sc_hd__fill_1
XFILLER_119_335 VGND VGND VPWR VPWR sky130_fd_sc_hd__fill_1
X_08132_ net291 _01975_ VGND VGND VPWR VPWR _00723_ sky130_fd_sc_hd__nor2_1
X_08063_ _01909_ _01913_ net314 VGND VGND VPWR VPWR _01918_ sky130_fd_sc_hd__a21oi_1
X_07014_ net1457 net327 net209 VGND VGND VPWR VPWR _00055_ sky130_fd_sc_hd__mux2_1
XFILLER_108_26 VGND VGND VPWR VPWR sky130_fd_sc_hd__fill_2
XFILLER_115_541 VGND VGND VPWR VPWR sky130_fd_sc_hd__decap_6
XTAP_TAPCELL_ROW_73_1503 VGND VPWR sky130_fd_sc_hd__tapvpwrvgnd_1
XFILLER_88_403 VPWR VGND VPWR VGND sky130_ef_sc_hd__decap_12
X_08965_ net604 net613 net487 net493 VGND VGND VPWR VPWR _02724_ sky130_fd_sc_hd__and4_1
XFILLER_130_533 VGND VGND VPWR VPWR sky130_fd_sc_hd__decap_3
XFILLER_130_522 VGND VGND VPWR VPWR sky130_fd_sc_hd__fill_1
X_07916_ u_interface.u_gelu_fp32.u_fp32_to_q16.s1_exp\[2\] u_interface.u_gelu_fp32.u_fp32_to_q16.s1_exp\[1\]
+ u_interface.u_gelu_fp32.u_fp32_to_q16.s1_exp\[0\] VGND VGND VPWR VPWR _01810_ sky130_fd_sc_hd__and3_1
XFILLER_29_503 VGND VGND VPWR VPWR sky130_fd_sc_hd__fill_1
X_08896_ _02653_ _02654_ VGND VGND VPWR VPWR _02655_ sky130_fd_sc_hd__nand2_1
XFILLER_68_182 VPWR VGND VPWR VGND sky130_ef_sc_hd__decap_12
X_07847_ net358 net1527 net284 VGND VGND VPWR VPWR _00608_ sky130_fd_sc_hd__mux2_1
XFILLER_84_642 VGND VGND VPWR VPWR sky130_fd_sc_hd__fill_2
XFILLER_56_344 VGND VGND VPWR VPWR sky130_fd_sc_hd__fill_1
XFILLER_17_709 VPWR VGND VPWR VGND sky130_ef_sc_hd__decap_12
XTAP_TAPCELL_ROW_104_2002 VGND VPWR sky130_fd_sc_hd__tapvpwrvgnd_1
X_07778_ net1494 net368 net233 VGND VGND VPWR VPWR _00539_ sky130_fd_sc_hd__mux2_1
XFILLER_140_46 VGND VGND VPWR VPWR sky130_fd_sc_hd__fill_1
X_09517_ net454 net601 net607 net458 VGND VGND VPWR VPWR _03274_ sky130_fd_sc_hd__a22oi_1
X_06729_ u_interface.fifo_data\[0\]\[12\] u_interface.fifo_data\[1\]\[12\] u_interface.fifo_data\[2\]\[12\]
+ u_interface.fifo_data\[3\]\[12\] net762 net745 VGND VGND VPWR VPWR _01292_ sky130_fd_sc_hd__mux4_1
XFILLER_25_753 VPWR VGND VPWR VGND sky130_ef_sc_hd__decap_12
XTAP_TAPCELL_ROW_84_1687 VGND VPWR sky130_fd_sc_hd__tapvpwrvgnd_1
XTAP_TAPCELL_ROW_84_1676 VGND VPWR sky130_fd_sc_hd__tapvpwrvgnd_1
X_09448_ _03204_ _03205_ _02656_ VGND VGND VPWR VPWR _03206_ sky130_fd_sc_hd__a21oi_1
XFILLER_12_425 VGND VGND VPWR VPWR sky130_fd_sc_hd__fill_1
XFILLER_25_797 VPWR VGND VPWR VGND sky130_ef_sc_hd__decap_12
XFILLER_149_33 VPWR VGND VPWR VGND sky130_ef_sc_hd__decap_12
X_09379_ net477 net637 net647 net481 VGND VGND VPWR VPWR _03137_ sky130_fd_sc_hd__a22o_1
X_12390_ _06116_ _06117_ VGND VGND VPWR VPWR _06118_ sky130_fd_sc_hd__nand2_1
X_11410_ net686 net695 net429 net424 VGND VGND VPWR VPWR _05150_ sky130_fd_sc_hd__nand4_1
XFILLER_138_655 VGND VGND VPWR VPWR sky130_fd_sc_hd__decap_3
XFILLER_123_3 VPWR VGND VPWR VGND sky130_ef_sc_hd__decap_12
X_11341_ net617 u_interface.u_gelu_fp32.u_synth_top.s2_dx\[29\] VGND VGND VPWR VPWR
+ _05082_ sky130_fd_sc_hd__nand2_1
XFILLER_153_625 VGND VGND VPWR VPWR sky130_fd_sc_hd__fill_2
XFILLER_4_613 VPWR VGND VPWR VGND sky130_ef_sc_hd__decap_12
X_14060_ clknet_leaf_17_clk _00986_ VGND VGND VPWR VPWR u_interface.u_gelu_fp32.u_fp32_to_q16.s1_mant\[22\]
+ sky130_fd_sc_hd__dfxtp_1
XFILLER_152_157 VGND VGND VPWR VPWR sky130_fd_sc_hd__fill_1
XTAP_TAPCELL_ROW_115_2175 VGND VPWR sky130_fd_sc_hd__tapvpwrvgnd_1
X_11272_ _04794_ _04896_ _04895_ VGND VGND VPWR VPWR _05014_ sky130_fd_sc_hd__a21oi_1
XFILLER_4_657 VPWR VGND VPWR VGND sky130_ef_sc_hd__decap_12
X_13011_ net1008 net567 net224 VGND VGND VPWR VPWR _01094_ sky130_fd_sc_hd__mux2_1
X_10223_ _03966_ _03971_ _03973_ VGND VGND VPWR VPWR _00816_ sky130_fd_sc_hd__o21a_1
XFILLER_79_414 VGND VGND VPWR VPWR sky130_fd_sc_hd__fill_2
XFILLER_3_167 VGND VGND VPWR VPWR sky130_fd_sc_hd__fill_1
XFILLER_133_393 VGND VGND VPWR VPWR sky130_fd_sc_hd__fill_1
X_10154_ net627 net450 _03788_ _03787_ VGND VGND VPWR VPWR _03905_ sky130_fd_sc_hd__a31o_1
XFILLER_79_436 VPWR VGND VPWR VGND sky130_ef_sc_hd__decap_12
XTAP_TAPCELL_ROW_7_451 VGND VPWR sky130_fd_sc_hd__tapvpwrvgnd_1
XTAP_TAPCELL_ROW_7_440 VGND VPWR sky130_fd_sc_hd__tapvpwrvgnd_1
XFILLER_0_841 VPWR VGND VPWR VGND sky130_ef_sc_hd__decap_12
XFILLER_94_417 VGND VGND VPWR VPWR sky130_fd_sc_hd__decap_3
Xhold7 u_interface.u_gelu_fp32.u_synth_top.s1_x\[7\] VGND VGND VPWR VPWR net872 sky130_fd_sc_hd__dlygate4sd3_1
X_10085_ _03835_ _03836_ _03684_ VGND VGND VPWR VPWR _03837_ sky130_fd_sc_hd__a21o_1
XFILLER_58_85 VGND VGND VPWR VPWR sky130_fd_sc_hd__decap_8
X_13913_ clknet_leaf_5_clk net978 VGND VGND VPWR VPWR u_interface.u_gelu_fp32.u_synth_top.s1_x\[17\]
+ sky130_fd_sc_hd__dfxtp_1
X_13844_ clknet_leaf_25_clk _00854_ VGND VGND VPWR VPWR u_interface.u_gelu_fp32.u_synth_top.s3_b\[0\]
+ sky130_fd_sc_hd__dfxtp_1
XFILLER_75_686 VGND VGND VPWR VPWR sky130_fd_sc_hd__decap_4
XFILLER_47_388 VGND VGND VPWR VPWR sky130_fd_sc_hd__decap_4
XFILLER_74_185 VGND VGND VPWR VPWR sky130_fd_sc_hd__decap_8
X_13775_ clknet_leaf_58_clk _00785_ VGND VGND VPWR VPWR u_interface.u_gelu_fp32.s2_data\[9\]
+ sky130_fd_sc_hd__dfxtp_1
X_10987_ _04604_ _04606_ _04605_ VGND VGND VPWR VPWR _04731_ sky130_fd_sc_hd__o21ba_1
XFILLER_43_561 VPWR VGND VPWR VGND sky130_ef_sc_hd__decap_12
X_12726_ u_interface.u_gelu_fp32.u_q16_to_fp32.s2_mag\[26\] u_interface.u_gelu_fp32.u_q16_to_fp32.s2_mag\[25\]
+ net336 VGND VGND VPWR VPWR _06378_ sky130_fd_sc_hd__mux2_1
X_12657_ net1553 u_interface.u_gelu_fp32.u_q16_to_fp32.s2_mag\[12\] net802 VGND VGND
+ VPWR VPWR _00893_ sky130_fd_sc_hd__mux2_1
X_11608_ _05257_ _05260_ VGND VGND VPWR VPWR _05346_ sky130_fd_sc_hd__nand2_1
X_12588_ _06280_ _06291_ net829 VGND VGND VPWR VPWR _00873_ sky130_fd_sc_hd__a21oi_1
XFILLER_129_666 VGND VGND VPWR VPWR sky130_fd_sc_hd__decap_6
XFILLER_143_113 VGND VGND VPWR VPWR sky130_fd_sc_hd__fill_1
Xhold407 u_interface.fifo_data\[12\]\[13\] VGND VGND VPWR VPWR net1272 sky130_fd_sc_hd__dlygate4sd3_1
XFILLER_116_305 VGND VGND VPWR VPWR sky130_fd_sc_hd__decap_3
X_11539_ _05276_ _05277_ VGND VGND VPWR VPWR _05278_ sky130_fd_sc_hd__and2_1
Xhold418 u_interface.fifo_data\[13\]\[31\] VGND VGND VPWR VPWR net1283 sky130_fd_sc_hd__dlygate4sd3_1
XFILLER_144_658 VGND VGND VPWR VPWR sky130_fd_sc_hd__fill_2
XFILLER_99_70 VGND VGND VPWR VPWR sky130_fd_sc_hd__fill_2
Xhold429 u_interface.fifo_data\[4\]\[3\] VGND VGND VPWR VPWR net1294 sky130_fd_sc_hd__dlygate4sd3_1
X_13209_ clknet_leaf_42_clk _00219_ VGND VGND VPWR VPWR u_interface.fifo_data\[12\]\[19\]
+ sky130_fd_sc_hd__dfxtp_1
XTAP_TAPCELL_ROW_55_1222 VGND VPWR sky130_fd_sc_hd__tapvpwrvgnd_1
XTAP_TAPCELL_ROW_55_1211 VGND VPWR sky130_fd_sc_hd__tapvpwrvgnd_1
XFILLER_112_533 VPWR VGND VPWR VGND sky130_ef_sc_hd__decap_12
XFILLER_97_277 VGND VGND VPWR VPWR sky130_fd_sc_hd__decap_3
X_08750_ _02490_ _02507_ _02508_ VGND VGND VPWR VPWR _02509_ sky130_fd_sc_hd__nand3_2
XTAP_TAPCELL_ROW_146_2669 VGND VPWR sky130_fd_sc_hd__tapvpwrvgnd_1
X_08681_ net696 net515 net705 net519 VGND VGND VPWR VPWR _02440_ sky130_fd_sc_hd__a22oi_1
X_07701_ u_interface.u_gelu_fp32.u_synth_top.s1_hits\[7\] _01761_ _01763_ VGND VGND
+ VPWR VPWR _00503_ sky130_fd_sc_hd__or3_1
XFILLER_93_483 VPWR VGND VPWR VGND sky130_ef_sc_hd__decap_12
XFILLER_93_472 VGND VGND VPWR VPWR sky130_fd_sc_hd__fill_1
X_07632_ _01721_ _01706_ net331 VGND VGND VPWR VPWR _01722_ sky130_fd_sc_hd__mux2_1
XFILLER_81_612 VGND VGND VPWR VPWR sky130_fd_sc_hd__decap_4
XFILLER_38_377 VPWR VGND VPWR VGND sky130_ef_sc_hd__decap_12
XFILLER_80_122 VGND VGND VPWR VPWR sky130_fd_sc_hd__decap_6
XFILLER_65_185 VGND VGND VPWR VPWR sky130_fd_sc_hd__decap_8
X_09302_ net583 net492 net496 net591 VGND VGND VPWR VPWR _03061_ sky130_fd_sc_hd__a22oi_1
X_07563_ net811 net1718 net304 _01676_ VGND VGND VPWR VPWR _00452_ sky130_fd_sc_hd__a22o_1
XFILLER_0_81 VGND VGND VPWR VPWR sky130_fd_sc_hd__decap_3
XFILLER_22_701 VPWR VGND VPWR VGND sky130_ef_sc_hd__decap_12
XTAP_TAPCELL_ROW_24_718 VGND VPWR sky130_fd_sc_hd__tapvpwrvgnd_1
X_07494_ _01620_ _01626_ net310 VGND VGND VPWR VPWR _01627_ sky130_fd_sc_hd__mux2_1
X_06514_ u_interface.u_gelu_fp32.u_q16_to_fp32.s2_mag\[0\] VGND VGND VPWR VPWR _01114_
+ sky130_fd_sc_hd__inv_2
XTAP_TAPCELL_ROW_66_1395 VGND VPWR sky130_fd_sc_hd__tapvpwrvgnd_1
XTAP_TAPCELL_ROW_66_1384 VGND VPWR sky130_fd_sc_hd__tapvpwrvgnd_1
X_09233_ _02949_ _02963_ _02990_ VGND VGND VPWR VPWR _02992_ sky130_fd_sc_hd__o21bai_1
XFILLER_21_255 VGND VGND VPWR VPWR sky130_fd_sc_hd__fill_2
X_09164_ _02825_ _02879_ _02878_ VGND VGND VPWR VPWR _02923_ sky130_fd_sc_hd__a21oi_1
X_08115_ net291 _01961_ VGND VGND VPWR VPWR _00720_ sky130_fd_sc_hd__nor2_1
XFILLER_147_485 VGND VGND VPWR VPWR sky130_fd_sc_hd__decap_6
X_09095_ _02801_ _02822_ _02853_ VGND VGND VPWR VPWR _02854_ sky130_fd_sc_hd__and3_1
XFILLER_135_625 VGND VGND VPWR VPWR sky130_fd_sc_hd__decap_6
XFILLER_135_614 VGND VGND VPWR VPWR sky130_fd_sc_hd__fill_2
XFILLER_108_828 VGND VGND VPWR VPWR sky130_fd_sc_hd__decap_8
XFILLER_107_305 VPWR VGND VPWR VGND sky130_ef_sc_hd__decap_12
X_08046_ u_interface.u_gelu_fp32.u_fp32_to_q16.s3_frac\[21\] u_interface.u_gelu_fp32.u_fp32_to_q16.s3_frac\[20\]
+ u_interface.u_gelu_fp32.u_fp32_to_q16.s3_frac\[23\] u_interface.u_gelu_fp32.u_fp32_to_q16.s3_frac\[22\]
+ VGND VGND VPWR VPWR _01903_ sky130_fd_sc_hd__or4_1
XFILLER_89_701 VGND VGND VPWR VPWR sky130_fd_sc_hd__decap_4
XFILLER_135_46 VGND VGND VPWR VPWR sky130_fd_sc_hd__decap_8
XFILLER_115_371 VGND VGND VPWR VPWR sky130_fd_sc_hd__fill_1
XFILLER_135_57 VPWR VGND VPWR VGND sky130_ef_sc_hd__decap_12
XFILLER_131_886 VGND VGND VPWR VPWR sky130_fd_sc_hd__fill_1
XTAP_TAPCELL_ROW_110_2094 VGND VPWR sky130_fd_sc_hd__tapvpwrvgnd_1
XFILLER_77_918 VGND VGND VPWR VPWR sky130_fd_sc_hd__decap_3
X_09997_ _03657_ _03655_ net215 VGND VGND VPWR VPWR _03749_ sky130_fd_sc_hd__mux2_1
X_08948_ _02705_ _02706_ _02599_ VGND VGND VPWR VPWR _02707_ sky130_fd_sc_hd__o21a_1
XFILLER_48_119 VGND VGND VPWR VPWR sky130_fd_sc_hd__decap_6
X_08879_ net476 net629 net481 net637 VGND VGND VPWR VPWR _02638_ sky130_fd_sc_hd__and4_1
XTAP_TAPCELL_ROW_86_1705 VGND VPWR sky130_fd_sc_hd__tapvpwrvgnd_1
XTAP_TAPCELL_ROW_86_1716 VGND VPWR sky130_fd_sc_hd__tapvpwrvgnd_1
X_10910_ _04570_ _04571_ _04652_ _04653_ VGND VGND VPWR VPWR _04655_ sky130_fd_sc_hd__nand4_1
XFILLER_56_141 VPWR VGND VPWR VGND sky130_ef_sc_hd__decap_12
XFILLER_28_77 VGND VGND VPWR VPWR sky130_fd_sc_hd__decap_6
XFILLER_29_366 VGND VGND VPWR VPWR sky130_fd_sc_hd__decap_4
XFILLER_29_377 VPWR VGND VPWR VGND sky130_ef_sc_hd__decap_12
XFILLER_71_100 VPWR VGND VPWR VGND sky130_ef_sc_hd__decap_12
XFILLER_44_347 VGND VGND VPWR VPWR sky130_fd_sc_hd__decap_8
XFILLER_17_539 VGND VGND VPWR VPWR sky130_fd_sc_hd__decap_8
X_11890_ _05576_ _05624_ VGND VGND VPWR VPWR _05625_ sky130_fd_sc_hd__xnor2_1
X_10841_ _04579_ _04584_ VGND VGND VPWR VPWR _04586_ sky130_fd_sc_hd__xor2_1
XFILLER_25_561 VGND VGND VPWR VPWR sky130_fd_sc_hd__decap_4
X_13560_ clknet_leaf_41_clk _00570_ VGND VGND VPWR VPWR u_interface.fifo_data\[4\]\[7\]
+ sky130_fd_sc_hd__dfxtp_1
X_10772_ _04399_ _04402_ VGND VGND VPWR VPWR _04518_ sky130_fd_sc_hd__nand2_1
XFILLER_40_520 VGND VGND VPWR VPWR sky130_fd_sc_hd__decap_4
X_13491_ clknet_leaf_2_clk _00501_ VGND VGND VPWR VPWR u_interface.u_gelu_fp32.u_synth_top.s2_b\[2\]
+ sky130_fd_sc_hd__dfxtp_1
XFILLER_9_727 VGND VGND VPWR VPWR sky130_fd_sc_hd__fill_1
X_12511_ _06184_ _06202_ _06201_ VGND VGND VPWR VPWR _06236_ sky130_fd_sc_hd__o21a_1
XFILLER_139_920 VGND VGND VPWR VPWR sky130_fd_sc_hd__fill_1
XTAP_TAPCELL_ROW_117_2215 VGND VPWR sky130_fd_sc_hd__tapvpwrvgnd_1
XTAP_TAPCELL_ROW_117_2204 VGND VPWR sky130_fd_sc_hd__tapvpwrvgnd_1
XFILLER_8_226 VPWR VGND VPWR VGND sky130_ef_sc_hd__decap_12
X_12442_ _06066_ _06114_ _06117_ VGND VGND VPWR VPWR _06169_ sky130_fd_sc_hd__o21a_1
XFILLER_153_411 VGND VGND VPWR VPWR sky130_fd_sc_hd__decap_8
XFILLER_138_496 VGND VGND VPWR VPWR sky130_fd_sc_hd__fill_1
XFILLER_125_113 VGND VGND VPWR VPWR sky130_fd_sc_hd__fill_1
X_12373_ _06081_ _06099_ VGND VGND VPWR VPWR _06101_ sky130_fd_sc_hd__xor2_1
XFILLER_153_444 VGND VGND VPWR VPWR sky130_fd_sc_hd__decap_4
XTAP_TAPCELL_ROW_130_2415 VGND VPWR sky130_fd_sc_hd__tapvpwrvgnd_1
X_14112_ clknet_leaf_27_clk _01038_ VGND VGND VPWR VPWR u_interface.meta_tlast_pipe\[5\]
+ sky130_fd_sc_hd__dfxtp_1
XFILLER_125_146 VGND VGND VPWR VPWR sky130_fd_sc_hd__decap_6
XTAP_TAPCELL_ROW_97_1889 VGND VPWR sky130_fd_sc_hd__tapvpwrvgnd_1
XTAP_TAPCELL_ROW_10_489 VGND VPWR sky130_fd_sc_hd__tapvpwrvgnd_1
XFILLER_5_15 VPWR VGND VPWR VGND sky130_ef_sc_hd__decap_12
XFILLER_4_421 VPWR VGND VPWR VGND sky130_ef_sc_hd__decap_12
X_11324_ net634 net406 _04982_ _04980_ VGND VGND VPWR VPWR _05065_ sky130_fd_sc_hd__a31o_1
X_14043_ clknet_leaf_20_clk _00969_ VGND VGND VPWR VPWR u_interface.u_gelu_fp32.u_fp32_to_q16.s1_mant\[5\]
+ sky130_fd_sc_hd__dfxtp_1
X_11255_ _04860_ _04861_ _04880_ _04879_ _04878_ VGND VGND VPWR VPWR _04997_ sky130_fd_sc_hd__o32a_1
XFILLER_153_499 VGND VGND VPWR VPWR sky130_fd_sc_hd__decap_4
XFILLER_140_149 VGND VGND VPWR VPWR sky130_fd_sc_hd__fill_1
XFILLER_106_382 VGND VGND VPWR VPWR sky130_fd_sc_hd__fill_1
X_10206_ _03955_ _03956_ _03782_ _03784_ VGND VGND VPWR VPWR _03957_ sky130_fd_sc_hd__o211ai_1
XFILLER_79_233 VGND VGND VPWR VPWR sky130_fd_sc_hd__decap_6
XFILLER_121_330 VGND VGND VPWR VPWR sky130_fd_sc_hd__fill_2
XFILLER_95_715 VGND VGND VPWR VPWR sky130_fd_sc_hd__fill_1
X_11186_ _04817_ _04819_ VGND VGND VPWR VPWR _04928_ sky130_fd_sc_hd__nand2_1
X_10137_ net482 net715 VGND VGND VPWR VPWR _03888_ sky130_fd_sc_hd__nand2_1
XTAP_TAPCELL_ROW_50_1130 VGND VPWR sky130_fd_sc_hd__tapvpwrvgnd_1
XTAP_TAPCELL_ROW_128_2377 VGND VPWR sky130_fd_sc_hd__tapvpwrvgnd_1
X_10068_ _03817_ _03819_ VGND VGND VPWR VPWR _03820_ sky130_fd_sc_hd__nor2_1
XTAP_TAPCELL_ROW_50_1141 VGND VPWR sky130_fd_sc_hd__tapvpwrvgnd_1
XPHY_EDGE_ROW_13_Right_13 VGND VGND VPWR VPWR sky130_fd_sc_hd__decap_3
XTAP_TAPCELL_ROW_128_2388 VGND VPWR sky130_fd_sc_hd__tapvpwrvgnd_1
XFILLER_63_612 VGND VGND VPWR VPWR sky130_fd_sc_hd__decap_4
XTAP_TAPCELL_ROW_141_2588 VGND VPWR sky130_fd_sc_hd__tapvpwrvgnd_1
XFILLER_90_475 VGND VGND VPWR VPWR sky130_fd_sc_hd__fill_1
X_13827_ clknet_leaf_79_clk _00837_ VGND VGND VPWR VPWR u_interface.u_gelu_fp32.u_synth_top.s3_mult\[45\]
+ sky130_fd_sc_hd__dfxtp_1
XTAP_TAPCELL_ROW_141_2599 VGND VPWR sky130_fd_sc_hd__tapvpwrvgnd_1
X_13758_ clknet_leaf_82_clk _00768_ VGND VGND VPWR VPWR u_interface.u_gelu_fp32.u_q16_to_fp32.s1_mag\[24\]
+ sky130_fd_sc_hd__dfxtp_1
XFILLER_50_339 VGND VGND VPWR VPWR sky130_fd_sc_hd__decap_6
X_12709_ _06364_ _06356_ _06349_ _06341_ net335 net328 VGND VGND VPWR VPWR _06365_
+ sky130_fd_sc_hd__mux4_1
XFILLER_43_391 VGND VGND VPWR VPWR sky130_fd_sc_hd__fill_1
X_13689_ clknet_leaf_13_clk _00699_ VGND VGND VPWR VPWR u_interface.u_gelu_fp32.u_fp32_to_q16.s3_frac\[25\]
+ sky130_fd_sc_hd__dfxtp_1
XFILLER_86_3 VPWR VGND VPWR VGND sky130_ef_sc_hd__decap_12
XFILLER_129_452 VPWR VGND VPWR VGND sky130_ef_sc_hd__decap_12
XPHY_EDGE_ROW_22_Right_22 VGND VGND VPWR VPWR sky130_fd_sc_hd__decap_3
XFILLER_117_625 VGND VGND VPWR VPWR sky130_fd_sc_hd__fill_2
Xhold215 u_interface.fifo_tuser\[14\] VGND VGND VPWR VPWR net1080 sky130_fd_sc_hd__dlygate4sd3_1
Xhold226 u_interface.fifo_data\[9\]\[2\] VGND VGND VPWR VPWR net1091 sky130_fd_sc_hd__dlygate4sd3_1
XFILLER_8_793 VPWR VGND VPWR VGND sky130_ef_sc_hd__decap_12
XFILLER_7_281 VGND VGND VPWR VPWR sky130_fd_sc_hd__fill_2
Xhold204 u_interface.fifo_data\[12\]\[2\] VGND VGND VPWR VPWR net1069 sky130_fd_sc_hd__dlygate4sd3_1
Xhold259 u_interface.fifo_data\[8\]\[22\] VGND VGND VPWR VPWR net1124 sky130_fd_sc_hd__dlygate4sd3_1
Xhold248 u_interface.fifo_data\[4\]\[28\] VGND VGND VPWR VPWR net1113 sky130_fd_sc_hd__dlygate4sd3_1
X_09920_ _03669_ _03672_ VGND VGND VPWR VPWR _03673_ sky130_fd_sc_hd__xnor2_1
Xhold237 u_interface.fifo_data\[15\]\[0\] VGND VGND VPWR VPWR net1102 sky130_fd_sc_hd__dlygate4sd3_1
XTAP_TAPCELL_ROW_148_2709 VGND VPWR sky130_fd_sc_hd__tapvpwrvgnd_1
Xfanout706 net708 VGND VGND VPWR VPWR net706 sky130_fd_sc_hd__buf_1
Xfanout728 _00003_ VGND VGND VPWR VPWR net728 sky130_fd_sc_hd__buf_4
X_09851_ _03446_ _03453_ _03454_ VGND VGND VPWR VPWR _03605_ sky130_fd_sc_hd__a21o_1
Xfanout739 net742 VGND VGND VPWR VPWR net739 sky130_fd_sc_hd__clkbuf_4
Xfanout717 net721 VGND VGND VPWR VPWR net717 sky130_fd_sc_hd__clkbuf_4
X_06994_ _01506_ _01509_ VGND VGND VPWR VPWR _01514_ sky130_fd_sc_hd__nor2_2
X_08802_ net606 net485 VGND VGND VPWR VPWR _02561_ sky130_fd_sc_hd__nand2_1
XFILLER_113_897 VGND VGND VPWR VPWR sky130_fd_sc_hd__fill_1
X_09782_ _03534_ _03535_ VGND VGND VPWR VPWR _03536_ sky130_fd_sc_hd__xnor2_1
XFILLER_100_514 VPWR VGND VPWR VGND sky130_ef_sc_hd__decap_12
XFILLER_85_225 VGND VGND VPWR VPWR sky130_fd_sc_hd__decap_4
XPHY_EDGE_ROW_31_Right_31 VGND VGND VPWR VPWR sky130_fd_sc_hd__decap_3
X_08733_ net621 net484 _02483_ _02482_ VGND VGND VPWR VPWR _02492_ sky130_fd_sc_hd__a31o_1
XFILLER_112_396 VGND VGND VPWR VPWR sky130_fd_sc_hd__decap_6
XFILLER_105_49 VGND VGND VPWR VPWR sky130_fd_sc_hd__decap_6
XFILLER_85_236 VGND VGND VPWR VPWR sky130_fd_sc_hd__decap_8
XPHY_EDGE_ROW_0_Left_156 VGND VGND VPWR VPWR sky130_fd_sc_hd__decap_3
XTAP_TAPCELL_ROW_68_1424 VGND VPWR sky130_fd_sc_hd__tapvpwrvgnd_1
XFILLER_38_141 VGND VGND VPWR VPWR sky130_fd_sc_hd__decap_6
X_08664_ _02272_ _02425_ _02271_ VGND VGND VPWR VPWR _02428_ sky130_fd_sc_hd__a21o_1
XFILLER_39_697 VGND VGND VPWR VPWR sky130_fd_sc_hd__fill_1
X_07615_ u_interface.u_gelu_fp32.u_q16_to_fp32.s2_mag\[3\] u_interface.u_gelu_fp32.u_q16_to_fp32.s2_mag\[2\]
+ u_interface.u_gelu_fp32.u_q16_to_fp32.s2_mag\[1\] u_interface.u_gelu_fp32.u_q16_to_fp32.s2_mag\[0\]
+ net338 net334 VGND VGND VPWR VPWR _01708_ sky130_fd_sc_hd__mux4_1
X_08595_ net158 _02377_ VGND VGND VPWR VPWR _02378_ sky130_fd_sc_hd__nand2_1
XFILLER_54_678 VGND VGND VPWR VPWR sky130_fd_sc_hd__decap_4
XFILLER_26_358 VGND VGND VPWR VPWR sky130_fd_sc_hd__decap_6
X_07546_ net310 _01661_ _01663_ VGND VGND VPWR VPWR _01664_ sky130_fd_sc_hd__o21ai_1
XTAP_TAPCELL_ROW_81_1635 VGND VPWR sky130_fd_sc_hd__tapvpwrvgnd_1
XFILLER_81_497 VGND VGND VPWR VPWR sky130_fd_sc_hd__decap_3
XTAP_TAPCELL_ROW_81_1624 VGND VPWR sky130_fd_sc_hd__tapvpwrvgnd_1
X_09216_ _02965_ _02974_ VGND VGND VPWR VPWR _02975_ sky130_fd_sc_hd__nor2_1
X_07477_ net557 _01561_ VGND VGND VPWR VPWR _01611_ sky130_fd_sc_hd__and2_1
XPHY_EDGE_ROW_40_Right_40 VGND VGND VPWR VPWR sky130_fd_sc_hd__decap_3
XFILLER_139_249 VGND VGND VPWR VPWR sky130_fd_sc_hd__decap_3
XFILLER_10_737 VPWR VGND VPWR VGND sky130_ef_sc_hd__decap_12
XFILLER_154_208 VGND VGND VPWR VPWR sky130_fd_sc_hd__decap_3
X_09147_ _02852_ _02873_ _02882_ _02903_ VGND VGND VPWR VPWR _02906_ sky130_fd_sc_hd__a211oi_1
XFILLER_108_625 VGND VGND VPWR VPWR sky130_fd_sc_hd__decap_3
XFILLER_147_293 VGND VGND VPWR VPWR sky130_fd_sc_hd__decap_8
X_09078_ net638 net512 VGND VGND VPWR VPWR _02837_ sky130_fd_sc_hd__nand2_1
XFILLER_107_146 VGND VGND VPWR VPWR sky130_fd_sc_hd__fill_1
XFILLER_123_617 VPWR VGND VPWR VGND sky130_ef_sc_hd__decap_12
XTAP_TAPCELL_ROW_112_2134 VGND VPWR sky130_fd_sc_hd__tapvpwrvgnd_1
XTAP_TAPCELL_ROW_112_2123 VGND VPWR sky130_fd_sc_hd__tapvpwrvgnd_1
X_08029_ u_interface.u_gelu_fp32.u_fp32_to_q16.s3_mag\[19\] u_interface.u_gelu_fp32.u_fp32_to_q16.s3_mag\[18\]
+ _01885_ VGND VGND VPWR VPWR _01886_ sky130_fd_sc_hd__and3_1
XTAP_TAPCELL_ROW_79_1597 VGND VPWR sky130_fd_sc_hd__tapvpwrvgnd_1
Xhold760 u_interface.u_gelu_fp32.u_fp32_to_q16.s1_mant\[8\] VGND VGND VPWR VPWR net1625
+ sky130_fd_sc_hd__dlygate4sd3_1
Xhold782 u_interface.u_gelu_fp32.u_q16_to_fp32.s3_norm_mag\[13\] VGND VGND VPWR VPWR
+ net1647 sky130_fd_sc_hd__dlygate4sd3_1
Xhold771 _00909_ VGND VGND VPWR VPWR net1636 sky130_fd_sc_hd__dlygate4sd3_1
Xhold793 u_interface.u_gelu_fp32.u_fp32_to_q16.s3_mag\[7\] VGND VGND VPWR VPWR net1658
+ sky130_fd_sc_hd__dlygate4sd3_1
XFILLER_103_330 VGND VGND VPWR VPWR sky130_fd_sc_hd__decap_6
XFILLER_77_715 VGND VGND VPWR VPWR sky130_fd_sc_hd__decap_8
X_11040_ _04658_ _04660_ VGND VGND VPWR VPWR _04784_ sky130_fd_sc_hd__nor2_1
XFILLER_39_65 VGND VGND VPWR VPWR sky130_fd_sc_hd__decap_3
XFILLER_76_236 VGND VGND VPWR VPWR sky130_fd_sc_hd__fill_1
X_12991_ net1117 net369 net221 VGND VGND VPWR VPWR _01074_ sky130_fd_sc_hd__mux2_1
XFILLER_45_601 VGND VGND VPWR VPWR sky130_fd_sc_hd__decap_3
XFILLER_84_291 VPWR VGND VPWR VGND sky130_ef_sc_hd__decap_12
XFILLER_45_623 VGND VGND VPWR VPWR sky130_fd_sc_hd__fill_1
XFILLER_18_837 VPWR VGND VPWR VGND sky130_ef_sc_hd__decap_12
X_11942_ _05674_ _05675_ VGND VGND VPWR VPWR _05676_ sky130_fd_sc_hd__nor2_1
XFILLER_45_667 VGND VGND VPWR VPWR sky130_fd_sc_hd__decap_4
X_11873_ net658 net389 _05606_ VGND VGND VPWR VPWR _05608_ sky130_fd_sc_hd__and3_1
XTAP_TAPCELL_ROW_123_2296 VGND VPWR sky130_fd_sc_hd__tapvpwrvgnd_1
X_13612_ clknet_leaf_66_clk _00622_ VGND VGND VPWR VPWR u_interface.fifo_data\[3\]\[27\]
+ sky130_fd_sc_hd__dfxtp_1
X_10824_ _04487_ _04489_ _04567_ VGND VGND VPWR VPWR _04569_ sky130_fd_sc_hd__o21ai_1
XFILLER_26_881 VPWR VGND VPWR VGND sky130_ef_sc_hd__decap_12
XFILLER_32_306 VGND VGND VPWR VPWR sky130_fd_sc_hd__fill_2
X_13543_ clknet_leaf_35_clk _00553_ VGND VGND VPWR VPWR u_interface.fifo_data\[5\]\[22\]
+ sky130_fd_sc_hd__dfxtp_1
XFILLER_111_81 VGND VGND VPWR VPWR sky130_fd_sc_hd__decap_6
XFILLER_13_553 VGND VGND VPWR VPWR sky130_fd_sc_hd__decap_6
XTAP_TAPCELL_ROW_99_1918 VGND VPWR sky130_fd_sc_hd__tapvpwrvgnd_1
XFILLER_71_41 VGND VGND VPWR VPWR sky130_fd_sc_hd__decap_8
X_10755_ _04379_ _04381_ _04380_ VGND VGND VPWR VPWR _04501_ sky130_fd_sc_hd__a21bo_1
XFILLER_40_361 VGND VGND VPWR VPWR sky130_fd_sc_hd__decap_3
XFILLER_41_895 VGND VGND VPWR VPWR sky130_fd_sc_hd__fill_1
X_13474_ clknet_leaf_64_clk _00484_ VGND VGND VPWR VPWR u_interface.u_gelu_fp32.u_q16_to_fp32.s3_norm_mag\[14\]
+ sky130_fd_sc_hd__dfxtp_1
X_10686_ _04432_ _04431_ VGND VGND VPWR VPWR _04433_ sky130_fd_sc_hd__and2b_1
XFILLER_13_597 VPWR VGND VPWR VGND sky130_ef_sc_hd__decap_12
XFILLER_138_271 VGND VGND VPWR VPWR sky130_fd_sc_hd__decap_8
XFILLER_126_411 VGND VGND VPWR VPWR sky130_fd_sc_hd__decap_8
X_12425_ _06149_ _06150_ VGND VGND VPWR VPWR _06152_ sky130_fd_sc_hd__xnor2_1
XFILLER_154_753 VGND VGND VPWR VPWR sky130_fd_sc_hd__decap_3
X_12356_ net718 net390 _06083_ VGND VGND VPWR VPWR _06084_ sky130_fd_sc_hd__and3_1
XFILLER_5_741 VPWR VGND VPWR VGND sky130_ef_sc_hd__decap_12
XFILLER_126_477 VGND VGND VPWR VPWR sky130_fd_sc_hd__decap_3
X_11307_ net711 net444 net439 net703 VGND VGND VPWR VPWR _05048_ sky130_fd_sc_hd__a22oi_1
XFILLER_4_251 VGND VGND VPWR VPWR sky130_fd_sc_hd__fill_1
XFILLER_5_785 VPWR VGND VPWR VGND sky130_ef_sc_hd__decap_12
X_12287_ _05745_ _06015_ VGND VGND VPWR VPWR _06016_ sky130_fd_sc_hd__nor2_1
X_14026_ clknet_leaf_64_clk _00952_ VGND VGND VPWR VPWR u_interface.core_data_out\[12\]
+ sky130_fd_sc_hd__dfxtp_1
X_11238_ net617 net625 net404 net400 VGND VGND VPWR VPWR _04980_ sky130_fd_sc_hd__and4_1
XFILLER_95_512 VPWR VGND VPWR VGND sky130_ef_sc_hd__decap_12
X_11169_ _04908_ _04909_ _04911_ VGND VGND VPWR VPWR _04912_ sky130_fd_sc_hd__and3_2
XFILLER_96_93 VPWR VGND VPWR VGND sky130_ef_sc_hd__decap_12
XFILLER_96_82 VGND VGND VPWR VPWR sky130_fd_sc_hd__fill_2
XTAP_TAPCELL_ROW_143_2628 VGND VPWR sky130_fd_sc_hd__tapvpwrvgnd_1
XTAP_TAPCELL_ROW_143_2617 VGND VPWR sky130_fd_sc_hd__tapvpwrvgnd_1
XFILLER_36_601 VPWR VGND VPWR VGND sky130_ef_sc_hd__decap_12
XFILLER_36_645 VPWR VGND VPWR VGND sky130_ef_sc_hd__decap_12
XFILLER_35_133 VGND VGND VPWR VPWR sky130_fd_sc_hd__fill_1
XFILLER_36_678 VGND VGND VPWR VPWR sky130_fd_sc_hd__decap_3
X_07400_ net555 net559 VGND VGND VPWR VPWR _01537_ sky130_fd_sc_hd__nor2_1
X_08380_ u_interface.u_gelu_fp32.u_synth_top.s3_mult\[33\] u_interface.u_gelu_fp32.u_synth_top.s3_b\[17\]
+ VGND VGND VPWR VPWR _02171_ sky130_fd_sc_hd__nand2_1
XFILLER_51_626 VGND VGND VPWR VPWR sky130_fd_sc_hd__decap_3
X_07331_ net1042 net567 net256 VGND VGND VPWR VPWR _00361_ sky130_fd_sc_hd__mux2_1
XTAP_TAPCELL_ROW_63_1343 VGND VPWR sky130_fd_sc_hd__tapvpwrvgnd_1
XTAP_TAPCELL_ROW_34_879 VGND VPWR sky130_fd_sc_hd__tapvpwrvgnd_1
X_07262_ net1361 net571 net251 VGND VGND VPWR VPWR _00294_ sky130_fd_sc_hd__mux2_1
X_09001_ _02754_ _02758_ _02759_ VGND VGND VPWR VPWR _02760_ sky130_fd_sc_hd__nand3b_2
XFILLER_117_411 VGND VGND VPWR VPWR sky130_fd_sc_hd__decap_8
X_07193_ net382 net1503 net259 VGND VGND VPWR VPWR _00233_ sky130_fd_sc_hd__mux2_1
Xgelu_top_842 VGND VGND VPWR VPWR gelu_top_842/HI s_axil_rdata[10] sky130_fd_sc_hd__conb_1
Xgelu_top_853 VGND VGND VPWR VPWR gelu_top_853/HI s_axil_rdata[21] sky130_fd_sc_hd__conb_1
Xgelu_top_831 VGND VGND VPWR VPWR gelu_top_831/HI s_axil_bresp[0] sky130_fd_sc_hd__conb_1
Xgelu_top_864 VGND VGND VPWR VPWR gelu_top_864/HI s_axil_rresp[0] sky130_fd_sc_hd__conb_1
XFILLER_105_617 VGND VGND VPWR VPWR sky130_fd_sc_hd__decap_6
XFILLER_132_425 VGND VGND VPWR VPWR sky130_fd_sc_hd__fill_1
XFILLER_105_639 VGND VGND VPWR VPWR sky130_fd_sc_hd__decap_6
Xfanout503 net504 VGND VGND VPWR VPWR net503 sky130_fd_sc_hd__buf_2
Xfanout514 u_interface.u_gelu_fp32.u_synth_top.s2_dx\[1\] VGND VGND VPWR VPWR net514
+ sky130_fd_sc_hd__dlymetal6s2s_1
XFILLER_99_862 VGND VGND VPWR VPWR sky130_fd_sc_hd__decap_6
X_09903_ net215 _03536_ _03654_ VGND VGND VPWR VPWR _03656_ sky130_fd_sc_hd__a21oi_1
Xfanout547 net548 VGND VGND VPWR VPWR net547 sky130_fd_sc_hd__buf_2
XFILLER_116_59 VGND VGND VPWR VPWR sky130_fd_sc_hd__decap_3
XFILLER_99_895 VGND VGND VPWR VPWR sky130_fd_sc_hd__fill_1
XFILLER_98_383 VPWR VGND VPWR VGND sky130_ef_sc_hd__decap_12
X_09834_ _03584_ _03585_ _03586_ VGND VGND VPWR VPWR _03588_ sky130_fd_sc_hd__nand3_1
Xfanout536 net1756 VGND VGND VPWR VPWR net536 sky130_fd_sc_hd__buf_1
XFILLER_86_501 VGND VGND VPWR VPWR sky130_fd_sc_hd__decap_3
XFILLER_58_203 VPWR VGND VPWR VGND sky130_ef_sc_hd__decap_12
Xfanout525 u_interface.u_gelu_fp32.u_synth_top.s3_b\[18\] VGND VGND VPWR VPWR net525
+ sky130_fd_sc_hd__dlymetal6s2s_1
Xfanout558 net559 VGND VGND VPWR VPWR net558 sky130_fd_sc_hd__clkbuf_4
Xfanout569 u_interface.core_data_out\[27\] VGND VGND VPWR VPWR net569 sky130_fd_sc_hd__clkbuf_2
XFILLER_58_236 VPWR VGND VPWR VGND sky130_ef_sc_hd__decap_12
X_06977_ _01501_ _01502_ VGND VGND VPWR VPWR _01503_ sky130_fd_sc_hd__nor2_2
X_09765_ _03412_ _03414_ VGND VGND VPWR VPWR _03520_ sky130_fd_sc_hd__nor2_1
XFILLER_101_889 VGND VGND VPWR VPWR sky130_fd_sc_hd__decap_6
XFILLER_74_729 VGND VGND VPWR VPWR sky130_fd_sc_hd__decap_3
X_08716_ net582 net467 net471 net592 VGND VGND VPWR VPWR _02475_ sky130_fd_sc_hd__a22oi_2
X_09696_ net462 net631 _03448_ _03449_ VGND VGND VPWR VPWR _03451_ sky130_fd_sc_hd__nand4_2
XFILLER_92_29 VGND VGND VPWR VPWR sky130_fd_sc_hd__decap_6
X_08647_ _02261_ _02412_ _02259_ VGND VGND VPWR VPWR _02415_ sky130_fd_sc_hd__o21ai_1
XFILLER_54_475 VGND VGND VPWR VPWR sky130_fd_sc_hd__fill_1
X_08578_ net154 _02366_ net824 VGND VGND VPWR VPWR _00778_ sky130_fd_sc_hd__a21oi_1
XFILLER_41_125 VPWR VGND VPWR VGND sky130_ef_sc_hd__decap_12
X_07529_ net815 net1600 net300 _01657_ VGND VGND VPWR VPWR _00437_ sky130_fd_sc_hd__a22o_1
XFILLER_41_169 VGND VGND VPWR VPWR sky130_fd_sc_hd__decap_8
X_10540_ _04287_ _04286_ VGND VGND VPWR VPWR _04288_ sky130_fd_sc_hd__and2b_1
XTAP_TAPCELL_ROW_12_529 VGND VPWR sky130_fd_sc_hd__tapvpwrvgnd_1
XFILLER_23_895 VGND VGND VPWR VPWR sky130_fd_sc_hd__fill_1
X_10471_ _04217_ _04218_ _04202_ VGND VGND VPWR VPWR _04219_ sky130_fd_sc_hd__a21o_1
XFILLER_10_545 VPWR VGND VPWR VGND sky130_ef_sc_hd__decap_12
XFILLER_136_731 VGND VGND VPWR VPWR sky130_fd_sc_hd__fill_1
XFILLER_108_433 VPWR VGND VPWR VGND sky130_ef_sc_hd__decap_12
XFILLER_10_589 VPWR VGND VPWR VGND sky130_ef_sc_hd__decap_12
X_12210_ _05873_ _05876_ net177 VGND VGND VPWR VPWR _05940_ sky130_fd_sc_hd__o21a_1
XFILLER_123_403 VGND VGND VPWR VPWR sky130_fd_sc_hd__fill_2
XFILLER_108_477 VPWR VGND VPWR VGND sky130_ef_sc_hd__decap_12
XTAP_TAPCELL_ROW_94_1837 VGND VPWR sky130_fd_sc_hd__tapvpwrvgnd_1
X_13190_ clknet_leaf_63_clk _00200_ VGND VGND VPWR VPWR u_interface.fifo_data\[12\]\[0\]
+ sky130_fd_sc_hd__dfxtp_1
XFILLER_108_499 VGND VGND VPWR VPWR sky130_fd_sc_hd__decap_4
X_12141_ _05661_ _05811_ _05812_ VGND VGND VPWR VPWR _05872_ sky130_fd_sc_hd__o21a_1
Xhold590 u_interface.u_gelu_fp32.u_fp32_to_q16.s1_mant\[11\] VGND VGND VPWR VPWR net1455
+ sky130_fd_sc_hd__dlygate4sd3_1
XFILLER_123_447 VGND VGND VPWR VPWR sky130_fd_sc_hd__fill_1
XFILLER_96_309 VPWR VGND VPWR VGND sky130_ef_sc_hd__decap_12
XFILLER_89_350 VPWR VGND VPWR VGND sky130_ef_sc_hd__decap_12
XPHY_EDGE_ROW_63_Left_219 VGND VGND VPWR VPWR sky130_fd_sc_hd__decap_3
XFILLER_2_755 VGND VGND VPWR VPWR sky130_fd_sc_hd__fill_1
X_12072_ net182 _05803_ VGND VGND VPWR VPWR _05804_ sky130_fd_sc_hd__xnor2_1
XFILLER_104_683 VGND VGND VPWR VPWR sky130_fd_sc_hd__fill_1
X_11023_ _04751_ _04766_ VGND VGND VPWR VPWR _04767_ sky130_fd_sc_hd__xnor2_1
XFILLER_49_225 VPWR VGND VPWR VGND sky130_ef_sc_hd__decap_12
XFILLER_2_27 VGND VGND VPWR VPWR sky130_fd_sc_hd__fill_1
XFILLER_18_601 VPWR VGND VPWR VGND sky130_ef_sc_hd__decap_12
X_12974_ _06468_ _06491_ VGND VGND VPWR VPWR _06492_ sky130_fd_sc_hd__nand2_1
XTAP_TAPCELL_ROW_125_2336 VGND VPWR sky130_fd_sc_hd__tapvpwrvgnd_1
XFILLER_92_548 VGND VGND VPWR VPWR sky130_fd_sc_hd__decap_6
XFILLER_66_85 VGND VGND VPWR VPWR sky130_fd_sc_hd__fill_2
XFILLER_17_111 VGND VGND VPWR VPWR sky130_fd_sc_hd__fill_1
XFILLER_18_645 VPWR VGND VPWR VGND sky130_ef_sc_hd__decap_12
X_11925_ _05493_ _05657_ VGND VGND VPWR VPWR _05659_ sky130_fd_sc_hd__nor2_1
XFILLER_45_497 VGND VGND VPWR VPWR sky130_fd_sc_hd__decap_6
XFILLER_17_188 VPWR VGND VPWR VGND sky130_ef_sc_hd__decap_12
XFILLER_33_615 VGND VGND VPWR VPWR sky130_fd_sc_hd__fill_1
XFILLER_82_62 VPWR VGND VPWR VGND sky130_ef_sc_hd__decap_12
XPHY_EDGE_ROW_72_Left_228 VGND VGND VPWR VPWR sky130_fd_sc_hd__decap_3
X_11856_ _05589_ _05590_ VGND VGND VPWR VPWR _05591_ sky130_fd_sc_hd__nor2_1
XFILLER_32_125 VGND VGND VPWR VPWR sky130_fd_sc_hd__fill_1
XFILLER_32_147 VGND VGND VPWR VPWR sky130_fd_sc_hd__decap_8
XTAP_TAPCELL_ROW_103_1988 VGND VPWR sky130_fd_sc_hd__tapvpwrvgnd_1
XTAP_TAPCELL_ROW_103_1977 VGND VPWR sky130_fd_sc_hd__tapvpwrvgnd_1
X_10807_ _04428_ _04430_ _04551_ VGND VGND VPWR VPWR _04553_ sky130_fd_sc_hd__o21a_1
XTAP_TAPCELL_ROW_45_1062 VGND VPWR sky130_fd_sc_hd__tapvpwrvgnd_1
XTAP_TAPCELL_ROW_45_1051 VGND VPWR sky130_fd_sc_hd__tapvpwrvgnd_1
XFILLER_20_309 VPWR VGND VPWR VGND sky130_ef_sc_hd__decap_12
X_11787_ net685 net407 VGND VGND VPWR VPWR _05523_ sky130_fd_sc_hd__nand2_1
XTAP_TAPCELL_ROW_31_827 VGND VPWR sky130_fd_sc_hd__tapvpwrvgnd_1
X_10738_ _04468_ _04480_ _04481_ VGND VGND VPWR VPWR _04484_ sky130_fd_sc_hd__nor3_1
X_13526_ clknet_leaf_70_clk _00536_ VGND VGND VPWR VPWR u_interface.fifo_data\[5\]\[5\]
+ sky130_fd_sc_hd__dfxtp_1
XTAP_TAPCELL_ROW_31_838 VGND VPWR sky130_fd_sc_hd__tapvpwrvgnd_1
X_13457_ clknet_leaf_13_clk _00467_ VGND VGND VPWR VPWR u_interface.u_gelu_fp32.u_fp32_to_q16.s3_mag\[28\]
+ sky130_fd_sc_hd__dfxtp_1
XPHY_EDGE_ROW_124_Right_124 VGND VGND VPWR VPWR sky130_fd_sc_hd__decap_3
X_10669_ _04371_ _04372_ _04414_ _04415_ VGND VGND VPWR VPWR _04416_ sky130_fd_sc_hd__a2bb2o_1
X_12408_ _06133_ _06134_ VGND VGND VPWR VPWR _06135_ sky130_fd_sc_hd__nor2_2
XTAP_TAPCELL_ROW_153_2790 VGND VPWR sky130_fd_sc_hd__tapvpwrvgnd_1
X_13388_ clknet_leaf_54_clk _00398_ VGND VGND VPWR VPWR u_interface.fifo_data\[6\]\[1\]
+ sky130_fd_sc_hd__dfxtp_1
Xoutput117 net117 VGND VGND VPWR VPWR m_axis_tdata[17] sky130_fd_sc_hd__buf_2
XPHY_EDGE_ROW_81_Left_237 VGND VGND VPWR VPWR sky130_fd_sc_hd__decap_3
Xoutput128 net128 VGND VGND VPWR VPWR m_axis_tdata[27] sky130_fd_sc_hd__buf_2
Xoutput139 net139 VGND VGND VPWR VPWR m_axis_tdata[8] sky130_fd_sc_hd__buf_2
X_12339_ net182 _06003_ _06002_ VGND VGND VPWR VPWR _06067_ sky130_fd_sc_hd__a21o_1
XFILLER_142_778 VGND VGND VPWR VPWR sky130_fd_sc_hd__decap_3
XFILLER_49_3 VPWR VGND VPWR VGND sky130_ef_sc_hd__decap_12
XFILLER_141_288 VGND VGND VPWR VPWR sky130_fd_sc_hd__fill_2
X_14009_ clknet_leaf_55_clk _00935_ VGND VGND VPWR VPWR u_interface.u_gelu_fp32.u_q16_to_fp32.s3_exp\[5\]
+ sky130_fd_sc_hd__dfxtp_1
X_06900_ u_interface.u_gelu_fp32.u_synth_top.s1_hits\[5\] u_interface.u_gelu_fp32.u_synth_top.s1_hits\[6\]
+ VGND VGND VPWR VPWR _01441_ sky130_fd_sc_hd__or2_1
X_07880_ net1225 net357 net267 VGND VGND VPWR VPWR _00641_ sky130_fd_sc_hd__mux2_1
XFILLER_95_342 VGND VGND VPWR VPWR sky130_fd_sc_hd__fill_1
XFILLER_95_320 VPWR VGND VPWR VGND sky130_ef_sc_hd__decap_12
X_06831_ net732 _01380_ VGND VGND VPWR VPWR _01381_ sky130_fd_sc_hd__or2_1
X_06762_ u_interface.fifo_data\[4\]\[16\] u_interface.fifo_data\[5\]\[16\] u_interface.fifo_data\[6\]\[16\]
+ u_interface.fifo_data\[7\]\[16\] net768 net751 VGND VGND VPWR VPWR _01321_ sky130_fd_sc_hd__mux4_1
X_09550_ _03267_ _03268_ _03306_ VGND VGND VPWR VPWR _03307_ sky130_fd_sc_hd__a21o_1
X_09481_ _03235_ _03236_ VGND VGND VPWR VPWR _03238_ sky130_fd_sc_hd__xor2_1
XFILLER_102_17 VGND VGND VPWR VPWR sky130_fd_sc_hd__decap_8
XPHY_EDGE_ROW_90_Left_246 VGND VGND VPWR VPWR sky130_fd_sc_hd__decap_3
XFILLER_83_559 VGND VGND VPWR VPWR sky130_fd_sc_hd__fill_1
XFILLER_70_209 VGND VGND VPWR VPWR sky130_fd_sc_hd__decap_8
XTAP_TAPCELL_ROW_19_640 VGND VPWR sky130_fd_sc_hd__tapvpwrvgnd_1
X_08501_ net523 u_interface.u_gelu_fp32.u_synth_top.s3_mult\[50\] VGND VGND VPWR VPWR
+ _02292_ sky130_fd_sc_hd__nand2_1
XFILLER_36_442 VPWR VGND VPWR VGND sky130_ef_sc_hd__decap_12
X_08432_ _02200_ _02222_ _02199_ VGND VGND VPWR VPWR _02223_ sky130_fd_sc_hd__a21bo_1
X_06693_ u_interface.fifo_data\[8\]\[8\] u_interface.fifo_data\[9\]\[8\] u_interface.fifo_data\[10\]\[8\]
+ u_interface.fifo_data\[11\]\[8\] net757 net740 VGND VGND VPWR VPWR _01260_ sky130_fd_sc_hd__mux4_1
XFILLER_24_604 VPWR VGND VPWR VGND sky130_ef_sc_hd__decap_12
XFILLER_23_125 VPWR VGND VPWR VGND sky130_ef_sc_hd__decap_12
XFILLER_149_311 VPWR VGND VPWR VGND sky130_ef_sc_hd__decap_12
X_08363_ net785 net921 VGND VGND VPWR VPWR _00775_ sky130_fd_sc_hd__and2_1
XFILLER_23_158 VGND VGND VPWR VPWR sky130_fd_sc_hd__fill_2
XFILLER_23_169 VPWR VGND VPWR VGND sky130_ef_sc_hd__decap_12
XFILLER_149_333 VGND VGND VPWR VPWR sky130_fd_sc_hd__decap_3
X_07314_ net1232 net363 net255 VGND VGND VPWR VPWR _00344_ sky130_fd_sc_hd__mux2_1
X_08294_ _02102_ _02103_ VGND VGND VPWR VPWR _00757_ sky130_fd_sc_hd__nor2_1
XFILLER_32_681 VPWR VGND VPWR VGND sky130_ef_sc_hd__decap_12
X_07245_ net1364 net366 net249 VGND VGND VPWR VPWR _00277_ sky130_fd_sc_hd__mux2_1
XFILLER_137_539 VGND VGND VPWR VPWR sky130_fd_sc_hd__decap_4
XFILLER_152_509 VGND VGND VPWR VPWR sky130_fd_sc_hd__fill_2
X_07176_ net1106 net353 net263 VGND VGND VPWR VPWR _00216_ sky130_fd_sc_hd__mux2_1
XFILLER_117_274 VGND VGND VPWR VPWR sky130_fd_sc_hd__decap_6
XTAP_TAPCELL_ROW_76_1556 VGND VPWR sky130_fd_sc_hd__tapvpwrvgnd_1
XTAP_TAPCELL_ROW_76_1545 VGND VPWR sky130_fd_sc_hd__tapvpwrvgnd_1
XFILLER_11_69 VPWR VGND VPWR VGND sky130_ef_sc_hd__decap_12
XFILLER_132_244 VGND VGND VPWR VPWR sky130_fd_sc_hd__decap_8
XFILLER_78_309 VPWR VGND VPWR VGND sky130_ef_sc_hd__decap_12
Xfanout322 _01107_ VGND VGND VPWR VPWR net322 sky130_fd_sc_hd__clkbuf_4
Xfanout311 net312 VGND VGND VPWR VPWR net311 sky130_fd_sc_hd__buf_2
Xfanout300 net301 VGND VGND VPWR VPWR net300 sky130_fd_sc_hd__buf_2
XFILLER_120_417 VGND VGND VPWR VPWR sky130_fd_sc_hd__decap_3
XFILLER_87_810 VGND VGND VPWR VPWR sky130_fd_sc_hd__decap_3
Xfanout355 u_interface.core_data_out\[15\] VGND VGND VPWR VPWR net355 sky130_fd_sc_hd__buf_1
Xfanout333 net335 VGND VGND VPWR VPWR net333 sky130_fd_sc_hd__clkbuf_4
XFILLER_86_331 VPWR VGND VPWR VGND sky130_ef_sc_hd__decap_12
Xfanout344 u_interface.core_data_out\[20\] VGND VGND VPWR VPWR net344 sky130_fd_sc_hd__clkbuf_2
Xfanout366 u_interface.core_data_out\[9\] VGND VGND VPWR VPWR net366 sky130_fd_sc_hd__clkbuf_2
XFILLER_143_57 VGND VGND VPWR VPWR sky130_fd_sc_hd__decap_4
XFILLER_100_141 VGND VGND VPWR VPWR sky130_fd_sc_hd__fill_1
X_09817_ net607 net447 net442 net601 VGND VGND VPWR VPWR _03571_ sky130_fd_sc_hd__a22o_1
Xfanout377 u_interface.core_data_out\[4\] VGND VGND VPWR VPWR net377 sky130_fd_sc_hd__buf_1
Xfanout388 u_interface.u_gelu_fp32.u_synth_top.s2_dx\[31\] VGND VGND VPWR VPWR net388
+ sky130_fd_sc_hd__clkbuf_8
XFILLER_59_567 VGND VGND VPWR VPWR sky130_fd_sc_hd__decap_4
Xfanout399 u_interface.u_gelu_fp32.u_synth_top.s2_dx\[28\] VGND VGND VPWR VPWR net399
+ sky130_fd_sc_hd__clkbuf_2
XPHY_EDGE_ROW_129_Left_285 VGND VGND VPWR VPWR sky130_fd_sc_hd__decap_3
XTAP_TAPCELL_ROW_107_2044 VGND VPWR sky130_fd_sc_hd__tapvpwrvgnd_1
X_09748_ _03482_ _03499_ _03500_ VGND VGND VPWR VPWR _03503_ sky130_fd_sc_hd__or3_2
XFILLER_74_548 VPWR VGND VPWR VGND sky130_ef_sc_hd__decap_12
XFILLER_27_420 VGND VGND VPWR VPWR sky130_fd_sc_hd__decap_4
XTAP_TAPCELL_ROW_107_2055 VGND VPWR sky130_fd_sc_hd__tapvpwrvgnd_1
X_09679_ _03430_ _03433_ VGND VGND VPWR VPWR _03434_ sky130_fd_sc_hd__xnor2_1
XFILLER_54_250 VGND VGND VPWR VPWR sky130_fd_sc_hd__fill_2
XFILLER_15_615 VGND VGND VPWR VPWR sky130_fd_sc_hd__fill_1
X_11710_ net642 net391 _05445_ VGND VGND VPWR VPWR _05447_ sky130_fd_sc_hd__and3_1
XFILLER_27_475 VPWR VGND VPWR VGND sky130_ef_sc_hd__decap_12
XFILLER_36_66 VPWR VGND VPWR VGND sky130_ef_sc_hd__decap_12
XFILLER_153_3 VPWR VGND VPWR VGND sky130_ef_sc_hd__decap_12
XTAP_TAPCELL_ROW_120_2255 VGND VPWR sky130_fd_sc_hd__tapvpwrvgnd_1
X_12690_ _06349_ _06341_ _01745_ _01739_ net333 net329 VGND VGND VPWR VPWR _06350_
+ sky130_fd_sc_hd__mux4_1
XFILLER_27_497 VGND VGND VPWR VPWR sky130_fd_sc_hd__decap_6
XFILLER_36_99 VPWR VGND VPWR VGND sky130_ef_sc_hd__decap_12
X_11641_ _05376_ _05377_ VGND VGND VPWR VPWR _05379_ sky130_fd_sc_hd__xnor2_1
XFILLER_42_467 VGND VGND VPWR VPWR sky130_fd_sc_hd__decap_8
XFILLER_42_489 VGND VGND VPWR VPWR sky130_fd_sc_hd__decap_4
X_11572_ _05118_ _05308_ VGND VGND VPWR VPWR _05311_ sky130_fd_sc_hd__or2_1
XFILLER_11_821 VPWR VGND VPWR VGND sky130_ef_sc_hd__decap_12
Xinput19 s_axil_araddr[24] VGND VGND VPWR VPWR net19 sky130_fd_sc_hd__clkbuf_1
XFILLER_155_314 VGND VGND VPWR VPWR sky130_fd_sc_hd__decap_3
XPHY_EDGE_ROW_138_Left_294 VGND VGND VPWR VPWR sky130_fd_sc_hd__decap_3
X_10523_ _04267_ _04268_ _04269_ VGND VGND VPWR VPWR _04271_ sky130_fd_sc_hd__nand3_1
X_13311_ clknet_leaf_69_clk _00321_ VGND VGND VPWR VPWR u_interface.fifo_data\[8\]\[20\]
+ sky130_fd_sc_hd__dfxtp_1
XFILLER_10_331 VGND VGND VPWR VPWR sky130_fd_sc_hd__decap_4
XFILLER_11_865 VPWR VGND VPWR VGND sky130_ef_sc_hd__decap_12
XFILLER_22_191 VGND VGND VPWR VPWR sky130_fd_sc_hd__decap_4
X_10454_ _04107_ _04138_ _04139_ VGND VGND VPWR VPWR _04202_ sky130_fd_sc_hd__a21bo_1
X_13242_ clknet_leaf_69_clk _00252_ VGND VGND VPWR VPWR u_interface.fifo_data\[11\]\[20\]
+ sky130_fd_sc_hd__dfxtp_1
XFILLER_10_397 VGND VGND VPWR VPWR sky130_fd_sc_hd__decap_8
X_13173_ clknet_leaf_65_clk _00183_ VGND VGND VPWR VPWR u_interface.fifo_data\[9\]\[15\]
+ sky130_fd_sc_hd__dfxtp_1
X_10385_ _04131_ _04132_ _04133_ VGND VGND VPWR VPWR _04134_ sky130_fd_sc_hd__a21oi_1
XFILLER_151_531 VGND VGND VPWR VPWR sky130_fd_sc_hd__fill_1
X_12124_ _05853_ _05854_ VGND VGND VPWR VPWR _05856_ sky130_fd_sc_hd__xor2_1
XFILLER_151_597 VPWR VGND VPWR VGND sky130_ef_sc_hd__decap_12
XFILLER_96_139 VGND VGND VPWR VPWR sky130_fd_sc_hd__fill_1
X_12055_ _05785_ _05786_ VGND VGND VPWR VPWR _05788_ sky130_fd_sc_hd__xnor2_1
XFILLER_78_887 VGND VGND VPWR VPWR sky130_fd_sc_hd__decap_6
XFILLER_77_353 VPWR VGND VPWR VGND sky130_ef_sc_hd__decap_12
X_11006_ _04741_ _04749_ VGND VGND VPWR VPWR _04750_ sky130_fd_sc_hd__nand2b_1
XFILLER_38_718 VGND VGND VPWR VPWR sky130_fd_sc_hd__fill_2
XFILLER_65_537 VPWR VGND VPWR VGND sky130_ef_sc_hd__decap_12
XTAP_TAPCELL_ROW_36_908 VGND VPWR sky130_fd_sc_hd__tapvpwrvgnd_1
XTAP_TAPCELL_ROW_36_919 VGND VPWR sky130_fd_sc_hd__tapvpwrvgnd_1
X_12957_ u_interface.fifo_count\[2\] _06467_ VGND VGND VPWR VPWR _06477_ sky130_fd_sc_hd__nor2_1
XFILLER_80_518 VGND VGND VPWR VPWR sky130_fd_sc_hd__fill_2
XFILLER_45_250 VGND VGND VPWR VPWR sky130_fd_sc_hd__fill_1
XFILLER_18_475 VGND VGND VPWR VPWR sky130_fd_sc_hd__fill_1
X_12888_ net785 net924 VGND VGND VPWR VPWR _01030_ sky130_fd_sc_hd__and2_1
X_11908_ _05480_ _05561_ _05562_ _05483_ VGND VGND VPWR VPWR _05643_ sky130_fd_sc_hd__or4bb_1
XTAP_TAPCELL_ROW_60_1302 VGND VPWR sky130_fd_sc_hd__tapvpwrvgnd_1
XFILLER_60_253 VGND VGND VPWR VPWR sky130_fd_sc_hd__fill_1
XFILLER_21_629 VPWR VGND VPWR VGND sky130_ef_sc_hd__decap_12
X_11839_ net199 _05573_ VGND VGND VPWR VPWR _05574_ sky130_fd_sc_hd__and2_1
XTAP_TAPCELL_ROW_138_2549 VGND VPWR sky130_fd_sc_hd__tapvpwrvgnd_1
XTAP_TAPCELL_ROW_138_2538 VGND VPWR sky130_fd_sc_hd__tapvpwrvgnd_1
XFILLER_14_681 VPWR VGND VPWR VGND sky130_ef_sc_hd__decap_12
XFILLER_20_139 VGND VGND VPWR VPWR sky130_fd_sc_hd__fill_1
XTAP_TAPCELL_ROW_155_2830 VGND VPWR sky130_fd_sc_hd__tapvpwrvgnd_1
X_13509_ clknet_leaf_3_clk net1399 VGND VGND VPWR VPWR u_interface.u_gelu_fp32.u_synth_top.s2_m\[2\]
+ sky130_fd_sc_hd__dfxtp_1
XTAP_TAPCELL_ROW_151_2749 VGND VPWR sky130_fd_sc_hd__tapvpwrvgnd_1
X_07030_ net1131 net359 net271 VGND VGND VPWR VPWR _00070_ sky130_fd_sc_hd__mux2_1
XFILLER_114_211 VGND VGND VPWR VPWR sky130_fd_sc_hd__fill_1
XFILLER_142_531 VGND VGND VPWR VPWR sky130_fd_sc_hd__fill_1
XTAP_TAPCELL_ROW_58_1264 VGND VPWR sky130_fd_sc_hd__tapvpwrvgnd_1
X_08981_ net655 net511 VGND VGND VPWR VPWR _02740_ sky130_fd_sc_hd__nand2_1
XFILLER_142_575 VGND VGND VPWR VPWR sky130_fd_sc_hd__decap_3
X_07932_ u_interface.u_gelu_fp32.u_fp32_to_q16.s1_exp\[0\] _01816_ _01825_ net775
+ VGND VGND VPWR VPWR _01826_ sky130_fd_sc_hd__o211a_1
XTAP_TAPCELL_ROW_71_1464 VGND VPWR sky130_fd_sc_hd__tapvpwrvgnd_1
X_07863_ net565 net1509 net285 VGND VGND VPWR VPWR _00624_ sky130_fd_sc_hd__mux2_1
XFILLER_84_802 VGND VGND VPWR VPWR sky130_fd_sc_hd__decap_8
XTAP_TAPCELL_ROW_71_1475 VGND VPWR sky130_fd_sc_hd__tapvpwrvgnd_1
XFILLER_3_81 VPWR VGND VPWR VGND sky130_ef_sc_hd__decap_12
XFILLER_29_729 VPWR VGND VPWR VGND sky130_ef_sc_hd__decap_12
XFILLER_110_461 VGND VGND VPWR VPWR sky130_fd_sc_hd__fill_1
X_06814_ u_interface.fifo_data\[12\]\[23\] u_interface.fifo_data\[13\]\[23\] u_interface.fifo_data\[14\]\[23\]
+ u_interface.fifo_data\[15\]\[23\] net766 net749 VGND VGND VPWR VPWR _01366_ sky130_fd_sc_hd__mux4_1
X_09602_ _03344_ _03356_ VGND VGND VPWR VPWR _03358_ sky130_fd_sc_hd__or2_2
XFILLER_96_695 VGND VGND VPWR VPWR sky130_fd_sc_hd__decap_4
X_09533_ _03288_ _03289_ _03287_ VGND VGND VPWR VPWR _03290_ sky130_fd_sc_hd__a21o_1
XFILLER_113_49 VGND VGND VPWR VPWR sky130_fd_sc_hd__fill_2
X_07794_ net970 net575 net236 VGND VGND VPWR VPWR _00555_ sky130_fd_sc_hd__mux2_1
XFILLER_83_356 VGND VGND VPWR VPWR sky130_fd_sc_hd__fill_2
XFILLER_56_559 VGND VGND VPWR VPWR sky130_fd_sc_hd__decap_6
X_06745_ u_interface.fifo_data\[0\]\[14\] u_interface.fifo_data\[1\]\[14\] u_interface.fifo_data\[2\]\[14\]
+ u_interface.fifo_data\[3\]\[14\] net763 net746 VGND VGND VPWR VPWR _01306_ sky130_fd_sc_hd__mux4_1
X_09464_ _03220_ _03221_ VGND VGND VPWR VPWR _03222_ sky130_fd_sc_hd__nand2b_1
X_06676_ _01241_ _01242_ _01245_ net316 VGND VGND VPWR VPWR net136 sky130_fd_sc_hd__a22o_1
X_09395_ net454 net589 net601 net458 VGND VGND VPWR VPWR _03153_ sky130_fd_sc_hd__a22oi_1
X_08415_ u_interface.u_gelu_fp32.u_synth_top.s3_mult\[20\] u_interface.u_gelu_fp32.u_synth_top.s3_b\[4\]
+ VGND VGND VPWR VPWR _02206_ sky130_fd_sc_hd__or2_1
X_08346_ _02141_ _02142_ VGND VGND VPWR VPWR _00770_ sky130_fd_sc_hd__nor2_1
XFILLER_138_804 VGND VGND VPWR VPWR sky130_fd_sc_hd__decap_8
XFILLER_149_185 VGND VGND VPWR VPWR sky130_fd_sc_hd__fill_2
X_08277_ net532 net1607 _02089_ net805 VGND VGND VPWR VPWR _02091_ sky130_fd_sc_hd__a31o_1
X_07228_ u_interface.fifo_rd_ptr\[1\] _01528_ VGND VGND VPWR VPWR _01530_ sky130_fd_sc_hd__and2_1
XFILLER_106_723 VGND VGND VPWR VPWR sky130_fd_sc_hd__fill_2
X_07159_ net1337 net561 net217 VGND VGND VPWR VPWR _00199_ sky130_fd_sc_hd__mux2_1
XFILLER_3_305 VPWR VGND VPWR VGND sky130_ef_sc_hd__decap_12
XFILLER_3_349 VPWR VGND VPWR VGND sky130_ef_sc_hd__decap_12
X_10170_ _03919_ _03920_ _03887_ VGND VGND VPWR VPWR _03921_ sky130_fd_sc_hd__a21o_1
XFILLER_105_299 VGND VGND VPWR VPWR sky130_fd_sc_hd__fill_1
XFILLER_78_139 VGND VGND VPWR VPWR sky130_fd_sc_hd__fill_1
Xfanout163 net164 VGND VGND VPWR VPWR net163 sky130_fd_sc_hd__buf_2
XFILLER_86_150 VGND VGND VPWR VPWR sky130_fd_sc_hd__decap_8
Xfanout152 net155 VGND VGND VPWR VPWR net152 sky130_fd_sc_hd__buf_2
XFILLER_74_323 VPWR VGND VPWR VGND sky130_ef_sc_hd__decap_12
XFILLER_74_301 VGND VGND VPWR VPWR sky130_fd_sc_hd__fill_2
Xfanout196 net197 VGND VGND VPWR VPWR net196 sky130_fd_sc_hd__clkbuf_4
XFILLER_59_375 VPWR VGND VPWR VGND sky130_ef_sc_hd__decap_12
Xfanout185 _05024_ VGND VGND VPWR VPWR net185 sky130_fd_sc_hd__clkbuf_2
XTAP_TAPCELL_ROW_89_1758 VGND VPWR sky130_fd_sc_hd__tapvpwrvgnd_1
X_13860_ clknet_leaf_86_clk _00870_ VGND VGND VPWR VPWR u_interface.u_gelu_fp32.u_synth_top.s3_b\[16\]
+ sky130_fd_sc_hd__dfxtp_1
X_12811_ net778 net101 VGND VGND VPWR VPWR _00969_ sky130_fd_sc_hd__and2_1
X_13791_ clknet_leaf_81_clk _00801_ VGND VGND VPWR VPWR u_interface.u_gelu_fp32.s2_data\[25\]
+ sky130_fd_sc_hd__dfxtp_1
XTAP_TAPCELL_ROW_2_360 VGND VPWR sky130_fd_sc_hd__tapvpwrvgnd_1
XTAP_TAPCELL_ROW_2_371 VGND VPWR sky130_fd_sc_hd__tapvpwrvgnd_1
X_12742_ net808 net1778 _01744_ _06343_ _06390_ VGND VGND VPWR VPWR _00928_ sky130_fd_sc_hd__a221o_1
XFILLER_27_294 VGND VGND VPWR VPWR sky130_fd_sc_hd__fill_1
XFILLER_42_220 VPWR VGND VPWR VGND sky130_ef_sc_hd__decap_12
XPHY_EDGE_ROW_69_Right_69 VGND VGND VPWR VPWR sky130_fd_sc_hd__decap_3
X_12673_ u_interface.u_gelu_fp32.u_q16_to_fp32.s1_mag\[28\] net1635 net796 VGND VGND
+ VPWR VPWR _00909_ sky130_fd_sc_hd__mux2_1
XFILLER_43_776 VGND VGND VPWR VPWR sky130_fd_sc_hd__decap_8
XFILLER_42_253 VGND VGND VPWR VPWR sky130_fd_sc_hd__decap_8
XPHY_EDGE_ROW_146_Left_302 VGND VGND VPWR VPWR sky130_fd_sc_hd__decap_3
XTAP_TAPCELL_ROW_100_1936 VGND VPWR sky130_fd_sc_hd__tapvpwrvgnd_1
XFILLER_8_15 VPWR VGND VPWR VGND sky130_ef_sc_hd__decap_12
X_11624_ _05358_ _05361_ VGND VGND VPWR VPWR _05362_ sky130_fd_sc_hd__xnor2_1
XFILLER_42_275 VGND VGND VPWR VPWR sky130_fd_sc_hd__decap_4
XTAP_TAPCELL_ROW_42_1010 VGND VPWR sky130_fd_sc_hd__tapvpwrvgnd_1
X_11555_ _05293_ _05292_ VGND VGND VPWR VPWR _05294_ sky130_fd_sc_hd__nand2b_1
XFILLER_11_673 VPWR VGND VPWR VGND sky130_ef_sc_hd__decap_12
XTAP_TAPCELL_ROW_41_988 VGND VPWR sky130_fd_sc_hd__tapvpwrvgnd_1
XTAP_TAPCELL_ROW_41_999 VGND VPWR sky130_fd_sc_hd__tapvpwrvgnd_1
XFILLER_144_829 VGND VGND VPWR VPWR sky130_fd_sc_hd__fill_1
XFILLER_128_369 VGND VGND VPWR VPWR sky130_fd_sc_hd__fill_1
XFILLER_128_347 VGND VGND VPWR VPWR sky130_fd_sc_hd__decap_4
X_10506_ _04252_ _04253_ _04170_ _04172_ VGND VGND VPWR VPWR _04254_ sky130_fd_sc_hd__o211ai_2
X_11486_ net711 _05146_ _05147_ _05046_ VGND VGND VPWR VPWR _05225_ sky130_fd_sc_hd__o2bb2a_1
XFILLER_10_194 VGND VGND VPWR VPWR sky130_fd_sc_hd__fill_2
XFILLER_6_121 VPWR VGND VPWR VGND sky130_ef_sc_hd__decap_12
XTAP_TAPCELL_ROW_133_2468 VGND VPWR sky130_fd_sc_hd__tapvpwrvgnd_1
XTAP_TAPCELL_ROW_133_2457 VGND VPWR sky130_fd_sc_hd__tapvpwrvgnd_1
X_10437_ _03995_ _03997_ _04183_ _04184_ VGND VGND VPWR VPWR _04186_ sky130_fd_sc_hd__a211o_1
XFILLER_6_165 VPWR VGND VPWR VGND sky130_ef_sc_hd__decap_12
X_13225_ clknet_leaf_73_clk _00235_ VGND VGND VPWR VPWR u_interface.fifo_data\[11\]\[3\]
+ sky130_fd_sc_hd__dfxtp_1
XPHY_EDGE_ROW_78_Right_78 VGND VGND VPWR VPWR sky130_fd_sc_hd__decap_3
X_13156_ clknet_leaf_34_clk _00166_ VGND VGND VPWR VPWR u_interface.fifo_tlast\[1\]
+ sky130_fd_sc_hd__dfxtp_1
XFILLER_111_203 VGND VGND VPWR VPWR sky130_fd_sc_hd__fill_2
X_10368_ _04005_ _04007_ _04006_ VGND VGND VPWR VPWR _04117_ sky130_fd_sc_hd__a21bo_1
XPHY_EDGE_ROW_155_Left_311 VGND VGND VPWR VPWR sky130_fd_sc_hd__decap_3
XFILLER_111_225 VGND VGND VPWR VPWR sky130_fd_sc_hd__fill_1
XFILLER_88_94 VGND VGND VPWR VPWR sky130_fd_sc_hd__fill_1
X_10299_ net603 net610 net432 net427 VGND VGND VPWR VPWR _04049_ sky130_fd_sc_hd__and4_1
X_12107_ _05838_ _05837_ VGND VGND VPWR VPWR _05839_ sky130_fd_sc_hd__and2b_1
X_13087_ clknet_leaf_72_clk _00097_ VGND VGND VPWR VPWR u_interface.fifo_data\[15\]\[8\]
+ sky130_fd_sc_hd__dfxtp_1
XTAP_TAPCELL_ROW_53_1183 VGND VPWR sky130_fd_sc_hd__tapvpwrvgnd_1
X_12038_ _05770_ _05769_ VGND VGND VPWR VPWR _05771_ sky130_fd_sc_hd__and2b_1
XFILLER_78_695 VGND VGND VPWR VPWR sky130_fd_sc_hd__decap_4
XFILLER_77_161 VGND VGND VPWR VPWR sky130_fd_sc_hd__decap_6
XFILLER_65_301 VGND VGND VPWR VPWR sky130_fd_sc_hd__fill_2
XFILLER_93_643 VGND VGND VPWR VPWR sky130_fd_sc_hd__fill_2
XFILLER_65_334 VGND VGND VPWR VPWR sky130_fd_sc_hd__fill_2
XFILLER_93_698 VGND VGND VPWR VPWR sky130_fd_sc_hd__decap_6
XFILLER_93_676 VGND VGND VPWR VPWR sky130_fd_sc_hd__fill_2
X_13989_ clknet_leaf_64_clk _00915_ VGND VGND VPWR VPWR u_interface.u_gelu_fp32.u_q16_to_fp32.s3_norm_mag\[16\]
+ sky130_fd_sc_hd__dfxtp_1
XTAP_TAPCELL_ROW_0_319 VGND VPWR sky130_fd_sc_hd__tapvpwrvgnd_1
XFILLER_18_250 VGND VGND VPWR VPWR sky130_fd_sc_hd__fill_2
X_06530_ u_interface.u_gelu_fp32.u_synth_top.s1_hits\[13\] u_interface.u_gelu_fp32.u_synth_top.s1_hits\[11\]
+ _01128_ VGND VGND VPWR VPWR _01129_ sky130_fd_sc_hd__or3_1
XFILLER_92_197 VGND VGND VPWR VPWR sky130_fd_sc_hd__decap_4
XPHY_EDGE_ROW_87_Right_87 VGND VGND VPWR VPWR sky130_fd_sc_hd__decap_3
XFILLER_22_905 VPWR VGND VPWR VGND sky130_ef_sc_hd__decap_12
X_08200_ net166 _02032_ net162 VGND VGND VPWR VPWR _02033_ sky130_fd_sc_hd__a21oi_1
X_09180_ _02895_ _02926_ _02938_ VGND VGND VPWR VPWR _02939_ sky130_fd_sc_hd__a21o_1
XFILLER_147_601 VPWR VGND VPWR VGND sky130_ef_sc_hd__decap_12
X_08131_ net168 _01973_ _01974_ net163 VGND VGND VPWR VPWR _01975_ sky130_fd_sc_hd__a31oi_1
X_08062_ _01874_ _01916_ VGND VGND VPWR VPWR _01917_ sky130_fd_sc_hd__or2_1
XFILLER_134_317 VGND VGND VPWR VPWR sky130_fd_sc_hd__fill_1
X_07013_ net827 _01524_ VGND VGND VPWR VPWR _01525_ sky130_fd_sc_hd__nor2_2
XPHY_EDGE_ROW_96_Right_96 VGND VGND VPWR VPWR sky130_fd_sc_hd__decap_3
XTAP_TAPCELL_ROW_73_1504 VGND VPWR sky130_fd_sc_hd__tapvpwrvgnd_1
XFILLER_1_809 VPWR VGND VPWR VGND sky130_ef_sc_hd__decap_12
XFILLER_143_895 VGND VGND VPWR VPWR sky130_fd_sc_hd__fill_1
XFILLER_103_715 VGND VGND VPWR VPWR sky130_fd_sc_hd__decap_4
XFILLER_88_415 VGND VGND VPWR VPWR sky130_fd_sc_hd__decap_4
X_08964_ _02570_ _02721_ _02722_ VGND VGND VPWR VPWR _02723_ sky130_fd_sc_hd__nand3_1
XFILLER_130_545 VPWR VGND VPWR VGND sky130_ef_sc_hd__decap_12
XFILLER_102_225 VGND VGND VPWR VPWR sky130_fd_sc_hd__decap_8
XFILLER_88_448 VPWR VGND VPWR VGND sky130_ef_sc_hd__decap_12
X_07915_ u_interface.u_gelu_fp32.u_fp32_to_q16.s1_exp\[1\] u_interface.u_gelu_fp32.u_fp32_to_q16.s1_exp\[0\]
+ VGND VGND VPWR VPWR _01809_ sky130_fd_sc_hd__and2_1
XFILLER_124_37 VGND VGND VPWR VPWR sky130_fd_sc_hd__decap_3
XFILLER_124_15 VGND VGND VPWR VPWR sky130_fd_sc_hd__fill_1
X_08895_ _02636_ _02652_ VGND VGND VPWR VPWR _02654_ sky130_fd_sc_hd__nand2_1
XFILLER_110_280 VGND VGND VPWR VPWR sky130_fd_sc_hd__decap_4
X_07846_ net360 net1508 net283 VGND VGND VPWR VPWR _00607_ sky130_fd_sc_hd__mux2_1
XFILLER_68_194 VGND VGND VPWR VPWR sky130_fd_sc_hd__fill_2
XFILLER_29_559 VGND VGND VPWR VPWR sky130_fd_sc_hd__fill_1
X_07777_ net1305 net370 net235 VGND VGND VPWR VPWR _00538_ sky130_fd_sc_hd__mux2_1
XTAP_TAPCELL_ROW_104_2003 VGND VPWR sky130_fd_sc_hd__tapvpwrvgnd_1
XFILLER_16_209 VGND VGND VPWR VPWR sky130_fd_sc_hd__fill_2
X_09516_ net454 net458 net601 net607 VGND VGND VPWR VPWR _03273_ sky130_fd_sc_hd__and4_1
XFILLER_71_337 VPWR VGND VPWR VGND sky130_ef_sc_hd__decap_12
X_06728_ net321 _01290_ net726 VGND VGND VPWR VPWR _01291_ sky130_fd_sc_hd__o21a_1
XFILLER_17_57 VPWR VGND VPWR VGND sky130_ef_sc_hd__decap_12
XFILLER_25_721 VGND VGND VPWR VPWR sky130_fd_sc_hd__decap_6
X_09447_ _03186_ _03202_ _03203_ VGND VGND VPWR VPWR _03205_ sky130_fd_sc_hd__or3_1
XTAP_TAPCELL_ROW_84_1677 VGND VPWR sky130_fd_sc_hd__tapvpwrvgnd_1
XFILLER_24_231 VGND VGND VPWR VPWR sky130_fd_sc_hd__fill_1
XFILLER_24_253 VPWR VGND VPWR VGND sky130_ef_sc_hd__decap_12
XFILLER_25_765 VPWR VGND VPWR VGND sky130_ef_sc_hd__decap_12
X_06659_ _01229_ _01230_ net729 VGND VGND VPWR VPWR _01231_ sky130_fd_sc_hd__mux2_1
XFILLER_9_909 VPWR VGND VPWR VGND sky130_ef_sc_hd__decap_12
XFILLER_138_601 VPWR VGND VPWR VGND sky130_ef_sc_hd__decap_12
X_09378_ net477 net481 net637 net647 VGND VGND VPWR VPWR _03136_ sky130_fd_sc_hd__and4_1
XFILLER_8_408 VGND VGND VPWR VPWR sky130_fd_sc_hd__decap_6
XFILLER_149_45 VGND VGND VPWR VPWR sky130_fd_sc_hd__decap_8
XFILLER_138_645 VGND VGND VPWR VPWR sky130_fd_sc_hd__fill_2
XFILLER_137_122 VGND VGND VPWR VPWR sky130_fd_sc_hd__fill_1
X_08329_ net529 net1627 _02128_ net796 VGND VGND VPWR VPWR _02130_ sky130_fd_sc_hd__a31o_1
X_11340_ _05077_ _05080_ VGND VGND VPWR VPWR _05081_ sky130_fd_sc_hd__xnor2_1
XFILLER_126_829 VGND VGND VPWR VPWR sky130_fd_sc_hd__decap_8
XFILLER_116_3 VGND VGND VPWR VPWR sky130_fd_sc_hd__decap_6
XFILLER_4_625 VPWR VGND VPWR VGND sky130_ef_sc_hd__decap_12
XTAP_TAPCELL_ROW_115_2176 VGND VPWR sky130_fd_sc_hd__tapvpwrvgnd_1
XFILLER_106_531 VGND VGND VPWR VPWR sky130_fd_sc_hd__fill_1
X_13010_ net1137 net569 net222 VGND VGND VPWR VPWR _01093_ sky130_fd_sc_hd__mux2_1
X_11271_ _04916_ _05012_ VGND VGND VPWR VPWR _05013_ sky130_fd_sc_hd__xnor2_1
XFILLER_3_113 VPWR VGND VPWR VGND sky130_ef_sc_hd__decap_12
XFILLER_140_309 VGND VGND VPWR VPWR sky130_fd_sc_hd__decap_4
XFILLER_133_350 VGND VGND VPWR VPWR sky130_fd_sc_hd__fill_2
X_10222_ net773 _03972_ VGND VGND VPWR VPWR _03973_ sky130_fd_sc_hd__and2_1
XFILLER_4_669 VPWR VGND VPWR VGND sky130_ef_sc_hd__decap_12
X_10153_ _03824_ _03827_ VGND VGND VPWR VPWR _03904_ sky130_fd_sc_hd__nand2_1
XFILLER_79_426 VGND VGND VPWR VPWR sky130_fd_sc_hd__fill_2
XTAP_TAPCELL_ROW_7_441 VGND VPWR sky130_fd_sc_hd__tapvpwrvgnd_1
XFILLER_121_556 VGND VGND VPWR VPWR sky130_fd_sc_hd__fill_1
XTAP_TAPCELL_ROW_7_452 VGND VPWR sky130_fd_sc_hd__tapvpwrvgnd_1
XFILLER_0_853 VPWR VGND VPWR VGND sky130_ef_sc_hd__decap_12
Xhold8 u_interface.u_gelu_fp32.u_synth_top.s1_x\[0\] VGND VGND VPWR VPWR net873 sky130_fd_sc_hd__dlygate4sd3_1
X_10084_ _03821_ _03833_ _03834_ VGND VGND VPWR VPWR _03836_ sky130_fd_sc_hd__or3_1
XFILLER_87_481 VGND VGND VPWR VPWR sky130_fd_sc_hd__decap_3
XFILLER_0_897 VGND VGND VPWR VPWR sky130_fd_sc_hd__fill_2
XFILLER_114_70 VGND VGND VPWR VPWR sky130_fd_sc_hd__decap_6
X_13912_ clknet_leaf_5_clk net954 VGND VGND VPWR VPWR u_interface.u_gelu_fp32.u_synth_top.s1_x\[16\]
+ sky130_fd_sc_hd__dfxtp_1
XFILLER_63_805 VGND VGND VPWR VPWR sky130_fd_sc_hd__fill_1
XFILLER_75_698 VGND VGND VPWR VPWR sky130_fd_sc_hd__fill_1
XFILLER_63_838 VGND VGND VPWR VPWR sky130_fd_sc_hd__fill_2
X_13843_ clknet_leaf_78_clk _00853_ VGND VGND VPWR VPWR u_interface.u_gelu_fp32.u_synth_top.s3_mult\[63\]
+ sky130_fd_sc_hd__dfxtp_1
XFILLER_74_197 VGND VGND VPWR VPWR sky130_fd_sc_hd__decap_6
X_13774_ clknet_leaf_58_clk _00784_ VGND VGND VPWR VPWR u_interface.u_gelu_fp32.s2_data\[8\]
+ sky130_fd_sc_hd__dfxtp_1
X_10986_ _04728_ _04729_ VGND VGND VPWR VPWR _04730_ sky130_fd_sc_hd__nor2_1
X_12725_ _01731_ net288 _06377_ VGND VGND VPWR VPWR _00924_ sky130_fd_sc_hd__a21o_1
XFILLER_43_573 VGND VGND VPWR VPWR sky130_fd_sc_hd__decap_4
X_12656_ net1612 u_interface.u_gelu_fp32.u_q16_to_fp32.s2_mag\[11\] net805 VGND VGND
+ VPWR VPWR _00892_ sky130_fd_sc_hd__mux2_1
XFILLER_30_223 VPWR VGND VPWR VGND sky130_ef_sc_hd__decap_12
X_12587_ _06281_ _06283_ _06285_ _06290_ VGND VGND VPWR VPWR _06291_ sky130_fd_sc_hd__or4_1
X_11607_ _05329_ _05343_ VGND VGND VPWR VPWR _05345_ sky130_fd_sc_hd__xnor2_1
XFILLER_129_656 VGND VGND VPWR VPWR sky130_fd_sc_hd__fill_2
XFILLER_117_818 VPWR VGND VPWR VGND sky130_ef_sc_hd__decap_12
XFILLER_11_481 VPWR VGND VPWR VGND sky130_ef_sc_hd__decap_12
Xhold408 u_interface.fifo_tuser\[5\] VGND VGND VPWR VPWR net1273 sky130_fd_sc_hd__dlygate4sd3_1
X_11538_ net625 net393 _05181_ _05180_ VGND VGND VPWR VPWR _05277_ sky130_fd_sc_hd__a31o_1
Xhold419 u_interface.fifo_data\[14\]\[12\] VGND VGND VPWR VPWR net1284 sky130_fd_sc_hd__dlygate4sd3_1
X_11469_ _05207_ _05208_ VGND VGND VPWR VPWR _05209_ sky130_fd_sc_hd__nor2_1
XFILLER_143_169 VGND VGND VPWR VPWR sky130_fd_sc_hd__decap_3
XFILLER_125_873 VGND VGND VPWR VPWR sky130_fd_sc_hd__decap_4
X_13208_ clknet_leaf_49_clk _00218_ VGND VGND VPWR VPWR u_interface.fifo_data\[12\]\[18\]
+ sky130_fd_sc_hd__dfxtp_1
XTAP_TAPCELL_ROW_55_1223 VGND VPWR sky130_fd_sc_hd__tapvpwrvgnd_1
XTAP_TAPCELL_ROW_55_1212 VGND VPWR sky130_fd_sc_hd__tapvpwrvgnd_1
XFILLER_152_681 VGND VGND VPWR VPWR sky130_fd_sc_hd__fill_2
X_13139_ clknet_leaf_39_clk _00149_ VGND VGND VPWR VPWR u_interface.fifo_data\[2\]\[28\]
+ sky130_fd_sc_hd__dfxtp_1
XFILLER_98_757 VPWR VGND VPWR VGND sky130_ef_sc_hd__decap_12
XFILLER_31_3 VPWR VGND VPWR VGND sky130_ef_sc_hd__decap_12
XFILLER_112_545 VPWR VGND VPWR VGND sky130_ef_sc_hd__decap_12
XFILLER_112_589 VPWR VGND VPWR VGND sky130_ef_sc_hd__decap_12
X_07700_ u_interface.u_gelu_fp32.u_synth_top.s1_hits\[1\] _01128_ _01763_ VGND VGND
+ VPWR VPWR _00502_ sky130_fd_sc_hd__or3_1
XFILLER_39_835 VGND VGND VPWR VPWR sky130_fd_sc_hd__decap_4
X_08680_ net696 net515 net705 net519 VGND VGND VPWR VPWR _02439_ sky130_fd_sc_hd__and4_1
XFILLER_66_654 VPWR VGND VPWR VGND sky130_ef_sc_hd__decap_12
XFILLER_66_643 VGND VGND VPWR VPWR sky130_fd_sc_hd__fill_1
XFILLER_65_120 VGND VGND VPWR VPWR sky130_fd_sc_hd__fill_2
X_07631_ _01720_ VGND VGND VPWR VPWR _01721_ sky130_fd_sc_hd__inv_2
XFILLER_81_602 VGND VGND VPWR VPWR sky130_fd_sc_hd__fill_1
XFILLER_26_529 VGND VGND VPWR VPWR sky130_fd_sc_hd__decap_3
XFILLER_38_389 VPWR VGND VPWR VGND sky130_ef_sc_hd__decap_12
X_07562_ _01674_ _01675_ net311 VGND VGND VPWR VPWR _01676_ sky130_fd_sc_hd__mux2_1
X_09301_ _03057_ _03058_ _03043_ VGND VGND VPWR VPWR _03060_ sky130_fd_sc_hd__a21o_1
X_06513_ u_interface.u_gelu_fp32.u_fp32_to_q16.s2_shift\[4\] VGND VGND VPWR VPWR _01113_
+ sky130_fd_sc_hd__inv_2
XFILLER_34_562 VPWR VGND VPWR VGND sky130_ef_sc_hd__decap_12
X_07493_ _01625_ _01623_ net544 VGND VGND VPWR VPWR _01626_ sky130_fd_sc_hd__mux2_1
XFILLER_80_178 VGND VGND VPWR VPWR sky130_fd_sc_hd__fill_1
XTAP_TAPCELL_ROW_66_1396 VGND VPWR sky130_fd_sc_hd__tapvpwrvgnd_1
XTAP_TAPCELL_ROW_66_1385 VGND VPWR sky130_fd_sc_hd__tapvpwrvgnd_1
XFILLER_22_713 VPWR VGND VPWR VGND sky130_ef_sc_hd__decap_12
XTAP_TAPCELL_ROW_24_719 VGND VPWR sky130_fd_sc_hd__tapvpwrvgnd_1
X_09232_ _02949_ _02963_ _02990_ VGND VGND VPWR VPWR _02991_ sky130_fd_sc_hd__or3b_1
XFILLER_21_223 VGND VGND VPWR VPWR sky130_fd_sc_hd__fill_1
XFILLER_22_757 VPWR VGND VPWR VGND sky130_ef_sc_hd__decap_12
X_09163_ _02920_ _02921_ VGND VGND VPWR VPWR _02922_ sky130_fd_sc_hd__and2_1
XFILLER_119_15 VPWR VGND VPWR VGND sky130_ef_sc_hd__decap_12
X_08114_ net168 _01959_ _01960_ net163 VGND VGND VPWR VPWR _01961_ sky130_fd_sc_hd__a31oi_1
XFILLER_108_807 VGND VGND VPWR VPWR sky130_fd_sc_hd__decap_4
X_09094_ _02832_ _02852_ VGND VGND VPWR VPWR _02853_ sky130_fd_sc_hd__nand2_1
XFILLER_134_114 VPWR VGND VPWR VGND sky130_ef_sc_hd__decap_12
XFILLER_107_317 VGND VGND VPWR VPWR sky130_fd_sc_hd__decap_8
Xhold920 u_interface.fifo_count\[0\] VGND VGND VPWR VPWR net1785 sky130_fd_sc_hd__dlygate4sd3_1
X_08045_ _01898_ _01899_ _01901_ VGND VGND VPWR VPWR _01902_ sky130_fd_sc_hd__or3_1
XFILLER_79_19 VGND VGND VPWR VPWR sky130_fd_sc_hd__fill_1
XFILLER_150_618 VGND VGND VPWR VPWR sky130_fd_sc_hd__decap_4
XFILLER_134_169 VGND VGND VPWR VPWR sky130_fd_sc_hd__decap_3
XFILLER_122_309 VPWR VGND VPWR VGND sky130_ef_sc_hd__decap_12
XFILLER_89_724 VGND VGND VPWR VPWR sky130_fd_sc_hd__decap_4
XFILLER_1_617 VPWR VGND VPWR VGND sky130_ef_sc_hd__decap_12
XFILLER_135_69 VGND VGND VPWR VPWR sky130_fd_sc_hd__decap_4
XFILLER_130_342 VGND VGND VPWR VPWR sky130_fd_sc_hd__decap_3
X_09996_ _03632_ _03734_ _03735_ VGND VGND VPWR VPWR _03748_ sky130_fd_sc_hd__a21bo_1
XTAP_TAPCELL_ROW_4_400 VGND VPWR sky130_fd_sc_hd__tapvpwrvgnd_1
XFILLER_0_138 VGND VGND VPWR VPWR sky130_fd_sc_hd__fill_2
X_08947_ _02629_ _02703_ _02704_ VGND VGND VPWR VPWR _02706_ sky130_fd_sc_hd__and3_1
XTAP_TAPCELL_ROW_110_2095 VGND VPWR sky130_fd_sc_hd__tapvpwrvgnd_1
XFILLER_69_481 VGND VGND VPWR VPWR sky130_fd_sc_hd__fill_1
XFILLER_57_610 VGND VGND VPWR VPWR sky130_fd_sc_hd__decap_6
X_08878_ net484 net647 VGND VGND VPWR VPWR _02637_ sky130_fd_sc_hd__nand2_1
XFILLER_151_57 VPWR VGND VPWR VGND sky130_ef_sc_hd__decap_12
XTAP_TAPCELL_ROW_86_1717 VGND VPWR sky130_fd_sc_hd__tapvpwrvgnd_1
XTAP_TAPCELL_ROW_86_1706 VGND VPWR sky130_fd_sc_hd__tapvpwrvgnd_1
X_07829_ net1417 net569 net230 VGND VGND VPWR VPWR _00590_ sky130_fd_sc_hd__mux2_1
XFILLER_56_153 VPWR VGND VPWR VGND sky130_ef_sc_hd__decap_12
XFILLER_45_838 VGND VGND VPWR VPWR sky130_fd_sc_hd__fill_2
XFILLER_72_624 VPWR VGND VPWR VGND sky130_ef_sc_hd__decap_12
X_10840_ _04579_ _04584_ VGND VGND VPWR VPWR _04585_ sky130_fd_sc_hd__and2_1
XFILLER_29_389 VGND VGND VPWR VPWR sky130_fd_sc_hd__decap_3
XFILLER_71_134 VGND VGND VPWR VPWR sky130_fd_sc_hd__fill_1
XFILLER_44_44 VPWR VGND VPWR VGND sky130_ef_sc_hd__decap_12
X_10771_ _04510_ _04515_ VGND VGND VPWR VPWR _04517_ sky130_fd_sc_hd__xnor2_1
X_13490_ clknet_leaf_24_clk _00500_ VGND VGND VPWR VPWR u_interface.u_gelu_fp32.u_synth_top.s2_b\[3\]
+ sky130_fd_sc_hd__dfxtp_1
X_12510_ _06184_ _06234_ VGND VGND VPWR VPWR _06235_ sky130_fd_sc_hd__xnor2_1
XTAP_TAPCELL_ROW_117_2205 VGND VPWR sky130_fd_sc_hd__tapvpwrvgnd_1
XFILLER_100_72 VGND VGND VPWR VPWR sky130_fd_sc_hd__decap_4
XFILLER_100_61 VGND VGND VPWR VPWR sky130_fd_sc_hd__decap_6
XFILLER_60_21 VGND VGND VPWR VPWR sky130_fd_sc_hd__fill_1
X_12441_ _06166_ _06167_ VGND VGND VPWR VPWR _06168_ sky130_fd_sc_hd__nand2_1
XFILLER_8_238 VPWR VGND VPWR VGND sky130_ef_sc_hd__decap_12
XFILLER_60_76 VGND VGND VPWR VPWR sky130_fd_sc_hd__fill_1
X_12372_ _06081_ _06099_ VGND VGND VPWR VPWR _06100_ sky130_fd_sc_hd__nand2b_1
XTAP_TAPCELL_ROW_130_2416 VGND VPWR sky130_fd_sc_hd__tapvpwrvgnd_1
X_14111_ clknet_leaf_27_clk _01037_ VGND VGND VPWR VPWR u_interface.meta_tlast_pipe\[4\]
+ sky130_fd_sc_hd__dfxtp_1
XFILLER_5_27 VPWR VGND VPWR VGND sky130_ef_sc_hd__decap_12
XFILLER_4_433 VPWR VGND VPWR VGND sky130_ef_sc_hd__decap_12
X_11323_ net659 net420 _04970_ _04969_ VGND VGND VPWR VPWR _05064_ sky130_fd_sc_hd__a31o_1
X_14042_ clknet_leaf_17_clk _00968_ VGND VGND VPWR VPWR u_interface.u_gelu_fp32.u_fp32_to_q16.s1_mant\[4\]
+ sky130_fd_sc_hd__dfxtp_1
XFILLER_109_81 VGND VGND VPWR VPWR sky130_fd_sc_hd__decap_8
X_11254_ _04978_ _04995_ VGND VGND VPWR VPWR _04996_ sky130_fd_sc_hd__xnor2_2
XFILLER_4_477 VPWR VGND VPWR VGND sky130_ef_sc_hd__decap_12
XFILLER_140_117 VGND VGND VPWR VPWR sky130_fd_sc_hd__decap_8
XFILLER_134_670 VGND VGND VPWR VPWR sky130_fd_sc_hd__fill_1
XFILLER_107_895 VGND VGND VPWR VPWR sky130_fd_sc_hd__fill_1
X_10205_ _03844_ _03847_ _03953_ _03954_ VGND VGND VPWR VPWR _03956_ sky130_fd_sc_hd__a211oi_2
XFILLER_79_201 VGND VGND VPWR VPWR sky130_fd_sc_hd__fill_1
X_11185_ _04814_ _04818_ _04819_ _04821_ _04813_ VGND VGND VPWR VPWR _04927_ sky130_fd_sc_hd__a32o_1
X_10136_ _03834_ _03836_ VGND VGND VPWR VPWR _03887_ sky130_fd_sc_hd__nand2b_1
XTAP_TAPCELL_ROW_50_1131 VGND VPWR sky130_fd_sc_hd__tapvpwrvgnd_1
XTAP_TAPCELL_ROW_128_2378 VGND VPWR sky130_fd_sc_hd__tapvpwrvgnd_1
X_10067_ _03814_ _03815_ _03816_ VGND VGND VPWR VPWR _03819_ sky130_fd_sc_hd__and3_1
XTAP_TAPCELL_ROW_50_1142 VGND VPWR sky130_fd_sc_hd__tapvpwrvgnd_1
XTAP_TAPCELL_ROW_128_2389 VGND VPWR sky130_fd_sc_hd__tapvpwrvgnd_1
XFILLER_75_473 VGND VGND VPWR VPWR sky130_fd_sc_hd__decap_4
XFILLER_90_421 VGND VGND VPWR VPWR sky130_fd_sc_hd__decap_3
XFILLER_63_635 VGND VGND VPWR VPWR sky130_fd_sc_hd__fill_1
XFILLER_48_698 VGND VGND VPWR VPWR sky130_fd_sc_hd__fill_2
XFILLER_35_315 VGND VGND VPWR VPWR sky130_fd_sc_hd__fill_2
XTAP_TAPCELL_ROW_141_2589 VGND VPWR sky130_fd_sc_hd__tapvpwrvgnd_1
XFILLER_63_657 VPWR VGND VPWR VGND sky130_ef_sc_hd__decap_12
XFILLER_62_145 VGND VGND VPWR VPWR sky130_fd_sc_hd__decap_4
X_13826_ clknet_leaf_80_clk _00836_ VGND VGND VPWR VPWR u_interface.u_gelu_fp32.u_synth_top.s3_mult\[44\]
+ sky130_fd_sc_hd__dfxtp_1
X_10969_ net205 _04712_ VGND VGND VPWR VPWR _04713_ sky130_fd_sc_hd__xnor2_1
X_13757_ clknet_leaf_82_clk _00767_ VGND VGND VPWR VPWR u_interface.u_gelu_fp32.u_q16_to_fp32.s1_mag\[23\]
+ sky130_fd_sc_hd__dfxtp_1
XFILLER_31_510 VPWR VGND VPWR VGND sky130_ef_sc_hd__decap_12
XFILLER_149_729 VGND VGND VPWR VPWR sky130_fd_sc_hd__fill_2
X_12708_ u_interface.u_gelu_fp32.u_q16_to_fp32.s2_mag\[22\] u_interface.u_gelu_fp32.u_q16_to_fp32.s2_mag\[21\]
+ net336 VGND VGND VPWR VPWR _06364_ sky130_fd_sc_hd__mux2_1
X_13688_ clknet_leaf_13_clk _00698_ VGND VGND VPWR VPWR u_interface.u_gelu_fp32.u_fp32_to_q16.s3_frac\[24\]
+ sky130_fd_sc_hd__dfxtp_1
X_12639_ net213 _06335_ VGND VGND VPWR VPWR _06338_ sky130_fd_sc_hd__nor2_1
XFILLER_79_3 VPWR VGND VPWR VGND sky130_ef_sc_hd__decap_12
XFILLER_129_464 VGND VGND VPWR VPWR sky130_fd_sc_hd__decap_3
XFILLER_117_615 VGND VGND VPWR VPWR sky130_fd_sc_hd__fill_1
Xhold216 u_interface.u_gelu_fp32.u_fp32_to_q16.s3_frac\[15\] VGND VGND VPWR VPWR net1081
+ sky130_fd_sc_hd__dlygate4sd3_1
Xhold205 u_interface.fifo_data\[0\]\[7\] VGND VGND VPWR VPWR net1070 sky130_fd_sc_hd__dlygate4sd3_1
Xhold227 u_interface.fifo_data\[13\]\[11\] VGND VGND VPWR VPWR net1092 sky130_fd_sc_hd__dlygate4sd3_1
Xhold238 u_interface.fifo_data\[14\]\[0\] VGND VGND VPWR VPWR net1103 sky130_fd_sc_hd__dlygate4sd3_1
Xhold249 u_interface.fifo_data\[6\]\[21\] VGND VGND VPWR VPWR net1114 sky130_fd_sc_hd__dlygate4sd3_1
XFILLER_131_117 VGND VGND VPWR VPWR sky130_fd_sc_hd__fill_1
XFILLER_98_521 VGND VGND VPWR VPWR sky130_fd_sc_hd__fill_1
XFILLER_112_320 VGND VGND VPWR VPWR sky130_fd_sc_hd__fill_1
Xfanout707 net708 VGND VGND VPWR VPWR net707 sky130_fd_sc_hd__clkbuf_4
X_09850_ _03595_ _03601_ _03602_ VGND VGND VPWR VPWR _03604_ sky130_fd_sc_hd__nand3_1
Xfanout729 net732 VGND VGND VPWR VPWR net729 sky130_fd_sc_hd__clkbuf_4
Xfanout718 net721 VGND VGND VPWR VPWR net718 sky130_fd_sc_hd__buf_1
X_06993_ net1173 net326 net251 VGND VGND VPWR VPWR _00046_ sky130_fd_sc_hd__mux2_1
X_08801_ net590 net598 net476 net480 VGND VGND VPWR VPWR _02560_ sky130_fd_sc_hd__and4_1
X_09781_ net510 _03472_ _03473_ _03368_ VGND VGND VPWR VPWR _03535_ sky130_fd_sc_hd__o22a_1
XFILLER_100_526 VGND VGND VPWR VPWR sky130_fd_sc_hd__decap_6
XFILLER_98_598 VGND VGND VPWR VPWR sky130_fd_sc_hd__decap_4
XFILLER_98_587 VGND VGND VPWR VPWR sky130_fd_sc_hd__fill_1
X_08732_ _02487_ _02490_ VGND VGND VPWR VPWR _02491_ sky130_fd_sc_hd__nand2b_1
XFILLER_66_462 VGND VGND VPWR VPWR sky130_fd_sc_hd__decap_6
X_08663_ net152 _02427_ net793 VGND VGND VPWR VPWR _00802_ sky130_fd_sc_hd__a21oi_1
XFILLER_93_281 VPWR VGND VPWR VGND sky130_ef_sc_hd__decap_12
XFILLER_81_410 VGND VGND VPWR VPWR sky130_fd_sc_hd__decap_3
XTAP_TAPCELL_ROW_68_1425 VGND VPWR sky130_fd_sc_hd__tapvpwrvgnd_1
XFILLER_53_101 VGND VGND VPWR VPWR sky130_fd_sc_hd__decap_8
X_08594_ _02224_ _02226_ VGND VGND VPWR VPWR _02377_ sky130_fd_sc_hd__xor2_1
X_07614_ net807 net1426 _01696_ _01707_ VGND VGND VPWR VPWR _00472_ sky130_fd_sc_hd__a22o_1
XFILLER_54_668 VGND VGND VPWR VPWR sky130_fd_sc_hd__fill_1
XPHY_EDGE_ROW_138_Right_138 VGND VGND VPWR VPWR sky130_fd_sc_hd__decap_3
X_07545_ u_interface.u_gelu_fp32.u_fp32_to_q16.s2_shift\[4\] _01662_ VGND VGND VPWR
+ VPWR _01663_ sky130_fd_sc_hd__or2_1
XTAP_TAPCELL_ROW_81_1625 VGND VPWR sky130_fd_sc_hd__tapvpwrvgnd_1
XFILLER_53_189 VPWR VGND VPWR VGND sky130_ef_sc_hd__decap_12
XFILLER_53_167 VGND VGND VPWR VPWR sky130_fd_sc_hd__fill_1
XFILLER_35_893 VGND VGND VPWR VPWR sky130_fd_sc_hd__decap_3
XFILLER_41_318 VPWR VGND VPWR VGND sky130_ef_sc_hd__decap_12
X_07476_ _01608_ _01609_ net551 VGND VGND VPWR VPWR _01610_ sky130_fd_sc_hd__mux2_1
XTAP_TAPCELL_ROW_81_1636 VGND VPWR sky130_fd_sc_hd__tapvpwrvgnd_1
X_09215_ net630 net514 net518 net639 VGND VGND VPWR VPWR _02974_ sky130_fd_sc_hd__a22oi_1
XPHY_EDGE_ROW_101_Left_257 VGND VGND VPWR VPWR sky130_fd_sc_hd__decap_3
XFILLER_10_749 VGND VGND VPWR VPWR sky130_fd_sc_hd__decap_6
XFILLER_148_773 VGND VGND VPWR VPWR sky130_fd_sc_hd__fill_1
X_09146_ _02882_ _02903_ _02852_ _02873_ VGND VGND VPWR VPWR _02905_ sky130_fd_sc_hd__o211a_1
XFILLER_135_412 VGND VGND VPWR VPWR sky130_fd_sc_hd__decap_3
XFILLER_135_401 VGND VGND VPWR VPWR sky130_fd_sc_hd__fill_2
X_09077_ net621 net630 net501 net507 VGND VGND VPWR VPWR _02836_ sky130_fd_sc_hd__and4_1
XFILLER_135_423 VGND VGND VPWR VPWR sky130_fd_sc_hd__fill_1
XFILLER_107_125 VGND VGND VPWR VPWR sky130_fd_sc_hd__decap_4
XFILLER_123_629 VGND VGND VPWR VPWR sky130_fd_sc_hd__decap_3
XTAP_TAPCELL_ROW_112_2135 VGND VPWR sky130_fd_sc_hd__tapvpwrvgnd_1
XTAP_TAPCELL_ROW_112_2124 VGND VPWR sky130_fd_sc_hd__tapvpwrvgnd_1
X_08028_ u_interface.u_gelu_fp32.u_fp32_to_q16.s3_mag\[17\] _01884_ VGND VGND VPWR
+ VPWR _01885_ sky130_fd_sc_hd__and2_1
XTAP_TAPCELL_ROW_79_1598 VGND VPWR sky130_fd_sc_hd__tapvpwrvgnd_1
Xhold761 _01005_ VGND VGND VPWR VPWR net1626 sky130_fd_sc_hd__dlygate4sd3_1
Xhold750 _01006_ VGND VGND VPWR VPWR net1615 sky130_fd_sc_hd__dlygate4sd3_1
XFILLER_122_117 VPWR VGND VPWR VGND sky130_ef_sc_hd__decap_12
XFILLER_104_821 VGND VGND VPWR VPWR sky130_fd_sc_hd__decap_4
Xhold772 u_interface.u_gelu_fp32.s2_data\[18\] VGND VGND VPWR VPWR net1637 sky130_fd_sc_hd__dlygate4sd3_1
Xhold794 u_interface.u_gelu_fp32.u_q16_to_fp32.s3_norm_mag\[21\] VGND VGND VPWR VPWR
+ net1659 sky130_fd_sc_hd__dlygate4sd3_1
Xhold783 u_interface.u_gelu_fp32.s2_data\[12\] VGND VGND VPWR VPWR net1648 sky130_fd_sc_hd__dlygate4sd3_1
XFILLER_1_447 VGND VGND VPWR VPWR sky130_fd_sc_hd__fill_1
XFILLER_131_673 VGND VGND VPWR VPWR sky130_fd_sc_hd__fill_2
X_09979_ _03633_ _03729_ _03730_ VGND VGND VPWR VPWR _03732_ sky130_fd_sc_hd__nor3_1
XFILLER_76_215 VGND VGND VPWR VPWR sky130_fd_sc_hd__decap_8
XFILLER_76_204 VGND VGND VPWR VPWR sky130_fd_sc_hd__decap_3
XFILLER_39_55 VGND VGND VPWR VPWR sky130_fd_sc_hd__fill_1
XPHY_EDGE_ROW_110_Left_266 VGND VGND VPWR VPWR sky130_fd_sc_hd__decap_3
X_12990_ net1075 net370 net223 VGND VGND VPWR VPWR _01073_ sky130_fd_sc_hd__mux2_1
XFILLER_45_613 VGND VGND VPWR VPWR sky130_fd_sc_hd__decap_3
XFILLER_18_805 VGND VGND VPWR VPWR sky130_fd_sc_hd__decap_6
XFILLER_84_281 VGND VGND VPWR VPWR sky130_fd_sc_hd__fill_2
XFILLER_72_421 VGND VGND VPWR VPWR sky130_fd_sc_hd__decap_8
XFILLER_17_315 VPWR VGND VPWR VGND sky130_ef_sc_hd__decap_12
XFILLER_17_337 VPWR VGND VPWR VGND sky130_ef_sc_hd__decap_12
XFILLER_18_849 VPWR VGND VPWR VGND sky130_ef_sc_hd__decap_12
X_11941_ _05668_ _05672_ _05673_ VGND VGND VPWR VPWR _05675_ sky130_fd_sc_hd__and3_1
XFILLER_60_605 VGND VGND VPWR VPWR sky130_fd_sc_hd__decap_6
XFILLER_55_87 VGND VGND VPWR VPWR sky130_fd_sc_hd__decap_3
XFILLER_44_134 VGND VGND VPWR VPWR sky130_fd_sc_hd__decap_6
X_11872_ net658 net389 VGND VGND VPWR VPWR _05607_ sky130_fd_sc_hd__nand2_1
X_13611_ clknet_leaf_42_clk _00621_ VGND VGND VPWR VPWR u_interface.fifo_data\[3\]\[26\]
+ sky130_fd_sc_hd__dfxtp_1
XTAP_TAPCELL_ROW_123_2297 VGND VPWR sky130_fd_sc_hd__tapvpwrvgnd_1
XPHY_EDGE_ROW_105_Right_105 VGND VGND VPWR VPWR sky130_fd_sc_hd__decap_3
X_10823_ _04487_ _04489_ _04567_ VGND VGND VPWR VPWR _04568_ sky130_fd_sc_hd__or3_1
XFILLER_26_893 VPWR VGND VPWR VGND sky130_ef_sc_hd__decap_12
X_13542_ clknet_leaf_83_clk _00552_ VGND VGND VPWR VPWR u_interface.fifo_data\[5\]\[21\]
+ sky130_fd_sc_hd__dfxtp_1
XTAP_TAPCELL_ROW_99_1919 VGND VPWR sky130_fd_sc_hd__tapvpwrvgnd_1
X_10754_ _04497_ _04498_ net652 net434 VGND VGND VPWR VPWR _04500_ sky130_fd_sc_hd__or4bb_1
XFILLER_9_503 VGND VGND VPWR VPWR sky130_fd_sc_hd__fill_1
X_13473_ clknet_leaf_64_clk _00483_ VGND VGND VPWR VPWR u_interface.u_gelu_fp32.u_q16_to_fp32.s3_norm_mag\[13\]
+ sky130_fd_sc_hd__dfxtp_1
X_10685_ net196 _04312_ _04311_ VGND VGND VPWR VPWR _04432_ sky130_fd_sc_hd__o21ba_1
XFILLER_40_373 VGND VGND VPWR VPWR sky130_fd_sc_hd__fill_1
XFILLER_138_250 VGND VGND VPWR VPWR sky130_fd_sc_hd__fill_2
X_12424_ _06149_ _06150_ VGND VGND VPWR VPWR _06151_ sky130_fd_sc_hd__nand2b_1
X_12355_ net710 u_interface.u_gelu_fp32.u_synth_top.s2_dx\[31\] VGND VGND VPWR VPWR
+ _06083_ sky130_fd_sc_hd__and2b_1
XFILLER_154_765 VPWR VGND VPWR VGND sky130_ef_sc_hd__decap_12
XFILLER_142_916 VGND VGND VPWR VPWR sky130_fd_sc_hd__decap_4
X_11306_ net703 net711 net444 net439 VGND VGND VPWR VPWR _05047_ sky130_fd_sc_hd__and4_1
XFILLER_5_753 VPWR VGND VPWR VGND sky130_ef_sc_hd__decap_12
XFILLER_5_797 VPWR VGND VPWR VGND sky130_ef_sc_hd__decap_12
X_12286_ net717 net407 _05956_ _05890_ VGND VGND VPWR VPWR _06015_ sky130_fd_sc_hd__a31o_1
XFILLER_113_139 VGND VGND VPWR VPWR sky130_fd_sc_hd__decap_6
X_14025_ clknet_leaf_54_clk _00951_ VGND VGND VPWR VPWR u_interface.core_data_out\[11\]
+ sky130_fd_sc_hd__dfxtp_1
X_11237_ net633 net406 VGND VGND VPWR VPWR _04979_ sky130_fd_sc_hd__nand2_1
XFILLER_110_813 VGND VGND VPWR VPWR sky130_fd_sc_hd__decap_6
XFILLER_95_524 VGND VGND VPWR VPWR sky130_fd_sc_hd__decap_3
X_11168_ _04666_ _04788_ _04789_ _04910_ VGND VGND VPWR VPWR _04911_ sky130_fd_sc_hd__o211a_1
XFILLER_110_835 VGND VGND VPWR VPWR sky130_fd_sc_hd__decap_4
X_10119_ net482 net707 _03808_ _03807_ VGND VGND VPWR VPWR _03870_ sky130_fd_sc_hd__a31o_1
XTAP_TAPCELL_ROW_143_2629 VGND VPWR sky130_fd_sc_hd__tapvpwrvgnd_1
XTAP_TAPCELL_ROW_143_2618 VGND VPWR sky130_fd_sc_hd__tapvpwrvgnd_1
XFILLER_82_207 VGND VGND VPWR VPWR sky130_fd_sc_hd__fill_1
X_11099_ _04841_ _04840_ VGND VGND VPWR VPWR _04842_ sky130_fd_sc_hd__and2b_1
XFILLER_75_281 VGND VGND VPWR VPWR sky130_fd_sc_hd__fill_1
XFILLER_63_421 VPWR VGND VPWR VGND sky130_ef_sc_hd__decap_12
XFILLER_36_613 VPWR VGND VPWR VGND sky130_ef_sc_hd__decap_12
XFILLER_36_657 VGND VGND VPWR VPWR sky130_fd_sc_hd__decap_4
X_13809_ clknet_leaf_88_clk _00819_ VGND VGND VPWR VPWR u_interface.u_gelu_fp32.u_synth_top.s3_mult\[27\]
+ sky130_fd_sc_hd__dfxtp_1
XFILLER_23_318 VGND VGND VPWR VPWR sky130_fd_sc_hd__fill_2
X_07330_ net1322 net569 net254 VGND VGND VPWR VPWR _00360_ sky130_fd_sc_hd__mux2_1
XTAP_TAPCELL_ROW_63_1344 VGND VPWR sky130_fd_sc_hd__tapvpwrvgnd_1
X_09000_ _02629_ _02757_ _02756_ VGND VGND VPWR VPWR _02759_ sky130_fd_sc_hd__o21ai_1
X_07261_ net1409 net573 net252 VGND VGND VPWR VPWR _00293_ sky130_fd_sc_hd__mux2_1
XTAP_TAPCELL_ROW_14_560 VGND VPWR sky130_fd_sc_hd__tapvpwrvgnd_1
X_07192_ net385 net1468 net257 VGND VGND VPWR VPWR _00232_ sky130_fd_sc_hd__mux2_1
Xgelu_top_832 VGND VGND VPWR VPWR gelu_top_832/HI s_axil_bresp[1] sky130_fd_sc_hd__conb_1
Xgelu_top_843 VGND VGND VPWR VPWR gelu_top_843/HI s_axil_rdata[11] sky130_fd_sc_hd__conb_1
XFILLER_145_776 VGND VGND VPWR VPWR sky130_fd_sc_hd__decap_8
XFILLER_144_264 VPWR VGND VPWR VGND sky130_ef_sc_hd__decap_12
XFILLER_144_253 VGND VGND VPWR VPWR sky130_fd_sc_hd__fill_1
XFILLER_117_467 VPWR VGND VPWR VGND sky130_ef_sc_hd__decap_12
Xgelu_top_865 VGND VGND VPWR VPWR gelu_top_865/HI s_axil_rresp[1] sky130_fd_sc_hd__conb_1
Xgelu_top_854 VGND VGND VPWR VPWR gelu_top_854/HI s_axil_rdata[22] sky130_fd_sc_hd__conb_1
Xfanout515 u_interface.u_gelu_fp32.u_synth_top.s2_dx\[1\] VGND VGND VPWR VPWR net515
+ sky130_fd_sc_hd__buf_2
Xfanout504 u_interface.u_gelu_fp32.u_synth_top.s2_dx\[4\] VGND VGND VPWR VPWR net504
+ sky130_fd_sc_hd__buf_2
X_09902_ _03654_ VGND VGND VPWR VPWR _03655_ sky130_fd_sc_hd__inv_2
Xfanout548 net549 VGND VGND VPWR VPWR net548 sky130_fd_sc_hd__buf_2
XFILLER_113_673 VGND VGND VPWR VPWR sky130_fd_sc_hd__decap_4
XFILLER_112_161 VGND VGND VPWR VPWR sky130_fd_sc_hd__fill_1
Xfanout537 net538 VGND VGND VPWR VPWR net537 sky130_fd_sc_hd__clkbuf_2
X_09833_ _03585_ _03586_ _03584_ VGND VGND VPWR VPWR _03587_ sky130_fd_sc_hd__a21o_1
XFILLER_59_727 VGND VGND VPWR VPWR sky130_fd_sc_hd__fill_1
XFILLER_58_215 VPWR VGND VPWR VGND sky130_ef_sc_hd__decap_12
Xfanout526 u_interface.u_gelu_fp32.u_synth_top.s3_b\[18\] VGND VGND VPWR VPWR net526
+ sky130_fd_sc_hd__clkbuf_4
Xfanout559 u_interface.u_gelu_fp32.u_fp32_to_q16.s2_shift\[0\] VGND VGND VPWR VPWR
+ net559 sky130_fd_sc_hd__clkbuf_4
XFILLER_98_395 VGND VGND VPWR VPWR sky130_fd_sc_hd__fill_1
XFILLER_58_248 VGND VGND VPWR VPWR sky130_fd_sc_hd__decap_4
X_06976_ u_interface.fifo_wr_ptr\[3\] u_interface.fifo_wr_ptr\[2\] VGND VGND VPWR
+ VPWR _01502_ sky130_fd_sc_hd__nand2_1
X_09764_ _03421_ _03518_ VGND VGND VPWR VPWR _03519_ sky130_fd_sc_hd__xnor2_1
X_08715_ net582 net592 net467 net470 VGND VGND VPWR VPWR _02474_ sky130_fd_sc_hd__and4_1
X_09695_ net462 net631 _03448_ _03449_ VGND VGND VPWR VPWR _03450_ sky130_fd_sc_hd__a22o_1
XFILLER_100_389 VGND VGND VPWR VPWR sky130_fd_sc_hd__decap_3
XFILLER_67_782 VGND VGND VPWR VPWR sky130_fd_sc_hd__fill_2
XFILLER_54_421 VGND VGND VPWR VPWR sky130_fd_sc_hd__decap_6
XFILLER_81_240 VPWR VGND VPWR VGND sky130_ef_sc_hd__decap_12
X_08646_ net152 _02414_ net793 VGND VGND VPWR VPWR _00798_ sky130_fd_sc_hd__a21oi_1
XFILLER_26_123 VGND VGND VPWR VPWR sky130_fd_sc_hd__decap_4
X_08577_ _02216_ net158 _02365_ VGND VGND VPWR VPWR _02366_ sky130_fd_sc_hd__nand3b_1
XFILLER_23_841 VPWR VGND VPWR VGND sky130_ef_sc_hd__decap_12
XFILLER_25_57 VPWR VGND VPWR VGND sky130_ef_sc_hd__decap_12
XFILLER_41_137 VGND VGND VPWR VPWR sky130_fd_sc_hd__decap_6
X_07528_ _01653_ _01656_ net310 VGND VGND VPWR VPWR _01657_ sky130_fd_sc_hd__mux2_1
XFILLER_22_340 VGND VGND VPWR VPWR sky130_fd_sc_hd__decap_3
X_07459_ _01590_ _01593_ net552 VGND VGND VPWR VPWR _01594_ sky130_fd_sc_hd__mux2_1
XFILLER_50_682 VGND VGND VPWR VPWR sky130_fd_sc_hd__fill_2
X_10470_ net189 _04215_ _04216_ VGND VGND VPWR VPWR _04218_ sky130_fd_sc_hd__nand3_1
XFILLER_10_557 VPWR VGND VPWR VGND sky130_ef_sc_hd__decap_12
X_09129_ net614 net503 net507 net621 VGND VGND VPWR VPWR _02888_ sky130_fd_sc_hd__a22oi_2
XFILLER_41_78 VGND VGND VPWR VPWR sky130_fd_sc_hd__fill_2
XFILLER_108_467 VGND VGND VPWR VPWR sky130_fd_sc_hd__decap_8
XFILLER_108_445 VPWR VGND VPWR VGND sky130_ef_sc_hd__decap_12
XTAP_TAPCELL_ROW_94_1838 VGND VPWR sky130_fd_sc_hd__tapvpwrvgnd_1
X_12140_ net182 _05870_ VGND VGND VPWR VPWR _05871_ sky130_fd_sc_hd__xnor2_1
XFILLER_151_735 VGND VGND VPWR VPWR sky130_fd_sc_hd__fill_1
XFILLER_123_426 VGND VGND VPWR VPWR sky130_fd_sc_hd__decap_6
XFILLER_123_415 VGND VGND VPWR VPWR sky130_fd_sc_hd__decap_4
XFILLER_108_489 VGND VGND VPWR VPWR sky130_fd_sc_hd__decap_3
XFILLER_2_701 VPWR VGND VPWR VGND sky130_ef_sc_hd__decap_12
Xhold580 u_interface.fifo_data\[4\]\[29\] VGND VGND VPWR VPWR net1445 sky130_fd_sc_hd__dlygate4sd3_1
XFILLER_104_640 VGND VGND VPWR VPWR sky130_fd_sc_hd__decap_4
XFILLER_9_3 VPWR VGND VPWR VGND sky130_ef_sc_hd__decap_12
X_12071_ _05801_ _05802_ VGND VGND VPWR VPWR _05803_ sky130_fd_sc_hd__nor2_1
Xhold591 _01008_ VGND VGND VPWR VPWR net1456 sky130_fd_sc_hd__dlygate4sd3_1
XFILLER_89_362 VPWR VGND VPWR VGND sky130_ef_sc_hd__decap_12
X_11022_ _04637_ _04764_ VGND VGND VPWR VPWR _04766_ sky130_fd_sc_hd__xor2_1
XFILLER_131_492 VGND VGND VPWR VPWR sky130_fd_sc_hd__decap_4
XFILLER_49_237 VGND VGND VPWR VPWR sky130_fd_sc_hd__decap_4
XFILLER_106_82 VGND VGND VPWR VPWR sky130_fd_sc_hd__fill_2
XFILLER_92_505 VGND VGND VPWR VPWR sky130_fd_sc_hd__decap_6
X_12973_ _06489_ _06490_ VGND VGND VPWR VPWR _06491_ sky130_fd_sc_hd__xnor2_1
XTAP_TAPCELL_ROW_125_2337 VGND VPWR sky130_fd_sc_hd__tapvpwrvgnd_1
XFILLER_57_281 VPWR VGND VPWR VGND sky130_ef_sc_hd__decap_12
XFILLER_18_613 VPWR VGND VPWR VGND sky130_ef_sc_hd__decap_12
XFILLER_73_741 VGND VGND VPWR VPWR sky130_fd_sc_hd__decap_8
XFILLER_18_657 VPWR VGND VPWR VGND sky130_ef_sc_hd__decap_12
X_11924_ net199 _05657_ VGND VGND VPWR VPWR _05658_ sky130_fd_sc_hd__and2_1
XFILLER_82_41 VPWR VGND VPWR VGND sky130_ef_sc_hd__decap_12
XFILLER_73_785 VGND VGND VPWR VPWR sky130_fd_sc_hd__decap_4
XFILLER_60_402 VPWR VGND VPWR VGND sky130_ef_sc_hd__decap_12
XFILLER_82_74 VGND VGND VPWR VPWR sky130_fd_sc_hd__decap_8
X_11855_ net702 net710 net415 net410 VGND VGND VPWR VPWR _05590_ sky130_fd_sc_hd__and4_1
XTAP_TAPCELL_ROW_103_1978 VGND VPWR sky130_fd_sc_hd__tapvpwrvgnd_1
XFILLER_82_85 VPWR VGND VPWR VGND sky130_ef_sc_hd__decap_12
X_10806_ _04428_ _04430_ _04551_ VGND VGND VPWR VPWR _04552_ sky130_fd_sc_hd__nor3_1
XTAP_TAPCELL_ROW_45_1063 VGND VPWR sky130_fd_sc_hd__tapvpwrvgnd_1
XTAP_TAPCELL_ROW_45_1052 VGND VPWR sky130_fd_sc_hd__tapvpwrvgnd_1
X_11786_ _05520_ _05521_ VGND VGND VPWR VPWR _05522_ sky130_fd_sc_hd__nor2_1
XTAP_TAPCELL_ROW_103_1989 VGND VPWR sky130_fd_sc_hd__tapvpwrvgnd_1
X_13525_ clknet_leaf_48_clk _00535_ VGND VGND VPWR VPWR u_interface.fifo_data\[5\]\[4\]
+ sky130_fd_sc_hd__dfxtp_1
X_10737_ _04480_ _04481_ _04468_ VGND VGND VPWR VPWR _04483_ sky130_fd_sc_hd__o21a_1
XFILLER_13_373 VPWR VGND VPWR VGND sky130_ef_sc_hd__decap_12
XTAP_TAPCELL_ROW_31_828 VGND VPWR sky130_fd_sc_hd__tapvpwrvgnd_1
XTAP_TAPCELL_ROW_31_839 VGND VPWR sky130_fd_sc_hd__tapvpwrvgnd_1
X_13456_ clknet_leaf_13_clk _00466_ VGND VGND VPWR VPWR u_interface.u_gelu_fp32.u_fp32_to_q16.s3_mag\[27\]
+ sky130_fd_sc_hd__dfxtp_1
X_10668_ _04292_ _04295_ _04411_ _04412_ VGND VGND VPWR VPWR _04415_ sky130_fd_sc_hd__a211o_1
X_12407_ net199 _06132_ VGND VGND VPWR VPWR _06134_ sky130_fd_sc_hd__nor2_1
XFILLER_154_562 VGND VGND VPWR VPWR sky130_fd_sc_hd__fill_1
XTAP_TAPCELL_ROW_153_2791 VGND VPWR sky130_fd_sc_hd__tapvpwrvgnd_1
XTAP_TAPCELL_ROW_153_2780 VGND VPWR sky130_fd_sc_hd__tapvpwrvgnd_1
XFILLER_126_253 VGND VGND VPWR VPWR sky130_fd_sc_hd__decap_8
XFILLER_126_242 VGND VGND VPWR VPWR sky130_fd_sc_hd__decap_8
XFILLER_126_231 VGND VGND VPWR VPWR sky130_fd_sc_hd__decap_6
X_13387_ clknet_leaf_62_clk _00397_ VGND VGND VPWR VPWR u_interface.fifo_data\[6\]\[0\]
+ sky130_fd_sc_hd__dfxtp_1
X_10599_ _04343_ _04344_ _04345_ VGND VGND VPWR VPWR _04346_ sky130_fd_sc_hd__nand3b_1
XFILLER_142_735 VGND VGND VPWR VPWR sky130_fd_sc_hd__decap_6
Xoutput129 net129 VGND VGND VPWR VPWR m_axis_tdata[28] sky130_fd_sc_hd__buf_2
XFILLER_99_126 VGND VGND VPWR VPWR sky130_fd_sc_hd__decap_6
Xoutput118 net118 VGND VGND VPWR VPWR m_axis_tdata[18] sky130_fd_sc_hd__buf_2
XFILLER_5_561 VPWR VGND VPWR VGND sky130_ef_sc_hd__decap_12
X_12338_ _06000_ _06049_ _06048_ VGND VGND VPWR VPWR _06066_ sky130_fd_sc_hd__a21boi_1
XFILLER_142_757 VGND VGND VPWR VPWR sky130_fd_sc_hd__decap_3
XFILLER_141_223 VGND VGND VPWR VPWR sky130_fd_sc_hd__fill_1
XFILLER_99_148 VGND VGND VPWR VPWR sky130_fd_sc_hd__decap_3
X_12269_ _05997_ _05998_ net795 VGND VGND VPWR VPWR _05999_ sky130_fd_sc_hd__a21oi_1
X_14008_ clknet_leaf_51_clk _00934_ VGND VGND VPWR VPWR u_interface.u_gelu_fp32.u_q16_to_fp32.s3_exp\[4\]
+ sky130_fd_sc_hd__dfxtp_1
XFILLER_95_332 VGND VGND VPWR VPWR sky130_fd_sc_hd__decap_4
X_06830_ u_interface.fifo_data\[8\]\[25\] u_interface.fifo_data\[9\]\[25\] u_interface.fifo_data\[10\]\[25\]
+ u_interface.fifo_data\[11\]\[25\] net760 net743 VGND VGND VPWR VPWR _01380_ sky130_fd_sc_hd__mux4_1
XFILLER_83_505 VGND VGND VPWR VPWR sky130_fd_sc_hd__decap_4
X_06761_ u_interface.fifo_data\[0\]\[16\] u_interface.fifo_data\[1\]\[16\] u_interface.fifo_data\[2\]\[16\]
+ u_interface.fifo_data\[3\]\[16\] net768 net751 VGND VGND VPWR VPWR _01320_ sky130_fd_sc_hd__mux4_1
X_06692_ _01255_ _01256_ _01259_ net318 VGND VGND VPWR VPWR net138 sky130_fd_sc_hd__a22o_1
X_09480_ _03235_ _03236_ VGND VGND VPWR VPWR _03237_ sky130_fd_sc_hd__nand2_1
XTAP_TAPCELL_ROW_19_641 VGND VPWR sky130_fd_sc_hd__tapvpwrvgnd_1
X_08500_ net521 u_interface.u_gelu_fp32.u_synth_top.s3_mult\[51\] VGND VGND VPWR VPWR
+ _02291_ sky130_fd_sc_hd__xnor2_1
XFILLER_36_421 VGND VGND VPWR VPWR sky130_fd_sc_hd__fill_2
XFILLER_36_454 VPWR VGND VPWR VGND sky130_ef_sc_hd__decap_12
XFILLER_102_29 VGND VGND VPWR VPWR sky130_fd_sc_hd__fill_2
X_08431_ _02203_ _02221_ _02202_ VGND VGND VPWR VPWR _02222_ sky130_fd_sc_hd__a21bo_1
XFILLER_91_582 VGND VGND VPWR VPWR sky130_fd_sc_hd__decap_4
XFILLER_24_616 VPWR VGND VPWR VGND sky130_ef_sc_hd__decap_12
XFILLER_23_137 VGND VGND VPWR VPWR sky130_fd_sc_hd__decap_8
X_08362_ _02153_ _02154_ VGND VGND VPWR VPWR _00774_ sky130_fd_sc_hd__nor2_1
X_07313_ net1046 net365 net256 VGND VGND VPWR VPWR _00343_ sky130_fd_sc_hd__mux2_1
XFILLER_149_345 VPWR VGND VPWR VGND sky130_ef_sc_hd__decap_12
XFILLER_149_323 VGND VGND VPWR VPWR sky130_fd_sc_hd__decap_6
X_08293_ net532 net1654 _02101_ net799 VGND VGND VPWR VPWR _02103_ sky130_fd_sc_hd__a31o_1
XFILLER_20_811 VGND VGND VPWR VPWR sky130_fd_sc_hd__fill_1
XFILLER_32_693 VGND VGND VPWR VPWR sky130_fd_sc_hd__decap_6
X_07244_ net1045 net369 net249 VGND VGND VPWR VPWR _00276_ sky130_fd_sc_hd__mux2_1
XFILLER_11_15 VPWR VGND VPWR VGND sky130_ef_sc_hd__decap_12
XFILLER_117_220 VGND VGND VPWR VPWR sky130_fd_sc_hd__decap_4
X_07175_ net1179 net355 net262 VGND VGND VPWR VPWR _00215_ sky130_fd_sc_hd__mux2_1
XTAP_TAPCELL_ROW_76_1557 VGND VPWR sky130_fd_sc_hd__tapvpwrvgnd_1
XTAP_TAPCELL_ROW_76_1546 VGND VPWR sky130_fd_sc_hd__tapvpwrvgnd_1
XFILLER_117_297 VGND VGND VPWR VPWR sky130_fd_sc_hd__decap_4
Xfanout323 _01107_ VGND VGND VPWR VPWR net323 sky130_fd_sc_hd__clkbuf_4
Xfanout312 _01113_ VGND VGND VPWR VPWR net312 sky130_fd_sc_hd__clkbuf_2
Xfanout301 _01542_ VGND VGND VPWR VPWR net301 sky130_fd_sc_hd__buf_2
XFILLER_99_671 VGND VGND VPWR VPWR sky130_fd_sc_hd__fill_1
Xfanout356 u_interface.core_data_out\[14\] VGND VGND VPWR VPWR net356 sky130_fd_sc_hd__clkbuf_2
Xfanout334 net335 VGND VGND VPWR VPWR net334 sky130_fd_sc_hd__clkbuf_2
XFILLER_87_855 VPWR VGND VPWR VGND sky130_ef_sc_hd__decap_12
Xfanout345 u_interface.core_data_out\[20\] VGND VGND VPWR VPWR net345 sky130_fd_sc_hd__buf_1
XFILLER_101_665 VGND VGND VPWR VPWR sky130_fd_sc_hd__fill_2
X_09816_ net601 net607 net447 net442 VGND VGND VPWR VPWR _03570_ sky130_fd_sc_hd__and4_1
Xfanout367 u_interface.core_data_out\[9\] VGND VGND VPWR VPWR net367 sky130_fd_sc_hd__buf_1
Xfanout378 u_interface.core_data_out\[3\] VGND VGND VPWR VPWR net378 sky130_fd_sc_hd__clkbuf_2
Xfanout389 net391 VGND VGND VPWR VPWR net389 sky130_fd_sc_hd__buf_2
XTAP_TAPCELL_ROW_107_2045 VGND VPWR sky130_fd_sc_hd__tapvpwrvgnd_1
X_09747_ _03499_ _03500_ _03482_ VGND VGND VPWR VPWR _03502_ sky130_fd_sc_hd__o21ai_1
X_06959_ u_interface.u_gelu_fp32.u_synth_top.s1_x\[29\] net275 VGND VGND VPWR VPWR
+ _01488_ sky130_fd_sc_hd__xnor2_1
XFILLER_100_197 VPWR VGND VPWR VGND sky130_ef_sc_hd__decap_12
XTAP_TAPCELL_ROW_38_950 VGND VPWR sky130_fd_sc_hd__tapvpwrvgnd_1
X_09678_ _03431_ _03432_ VGND VGND VPWR VPWR _03433_ sky130_fd_sc_hd__and2b_1
XFILLER_55_785 VPWR VGND VPWR VGND sky130_ef_sc_hd__decap_12
XFILLER_27_487 VGND VGND VPWR VPWR sky130_fd_sc_hd__decap_6
XFILLER_36_78 VGND VGND VPWR VPWR sky130_fd_sc_hd__decap_6
XFILLER_42_413 VGND VGND VPWR VPWR sky130_fd_sc_hd__decap_6
XTAP_TAPCELL_ROW_120_2256 VGND VPWR sky130_fd_sc_hd__tapvpwrvgnd_1
XFILLER_82_593 VGND VGND VPWR VPWR sky130_fd_sc_hd__fill_1
XFILLER_70_755 VGND VGND VPWR VPWR sky130_fd_sc_hd__fill_1
X_08629_ _02248_ _02401_ VGND VGND VPWR VPWR _02402_ sky130_fd_sc_hd__xnor2_1
XFILLER_36_89 VGND VGND VPWR VPWR sky130_fd_sc_hd__fill_1
X_11640_ _05377_ _05376_ VGND VGND VPWR VPWR _05378_ sky130_fd_sc_hd__and2b_1
X_11571_ _05117_ _05308_ _05309_ _05212_ VGND VGND VPWR VPWR _05310_ sky130_fd_sc_hd__o22a_1
XFILLER_11_833 VGND VGND VPWR VPWR sky130_fd_sc_hd__decap_6
XFILLER_23_671 VGND VGND VPWR VPWR sky130_fd_sc_hd__fill_1
X_13310_ clknet_leaf_42_clk _00320_ VGND VGND VPWR VPWR u_interface.fifo_data\[8\]\[19\]
+ sky130_fd_sc_hd__dfxtp_1
X_10522_ _04267_ _04268_ _04269_ VGND VGND VPWR VPWR _04270_ sky130_fd_sc_hd__a21o_1
XFILLER_10_321 VGND VGND VPWR VPWR sky130_fd_sc_hd__decap_4
XFILLER_155_337 VGND VGND VPWR VPWR sky130_fd_sc_hd__fill_2
XFILLER_149_890 VGND VGND VPWR VPWR sky130_fd_sc_hd__decap_6
XFILLER_11_877 VPWR VGND VPWR VGND sky130_ef_sc_hd__decap_12
X_13241_ clknet_leaf_35_clk _00251_ VGND VGND VPWR VPWR u_interface.fifo_data\[11\]\[19\]
+ sky130_fd_sc_hd__dfxtp_1
X_10453_ _04099_ _04101_ VGND VGND VPWR VPWR _04201_ sky130_fd_sc_hd__nand2_1
X_13172_ clknet_leaf_43_clk _00182_ VGND VGND VPWR VPWR u_interface.fifo_data\[9\]\[14\]
+ sky130_fd_sc_hd__dfxtp_1
X_10384_ _04016_ _04022_ _04023_ VGND VGND VPWR VPWR _04133_ sky130_fd_sc_hd__a21bo_1
XFILLER_123_245 VGND VGND VPWR VPWR sky130_fd_sc_hd__fill_2
XFILLER_2_531 VGND VGND VPWR VPWR sky130_fd_sc_hd__fill_1
X_12123_ _05853_ _05854_ VGND VGND VPWR VPWR _05855_ sky130_fd_sc_hd__and2_1
XFILLER_111_418 VGND VGND VPWR VPWR sky130_fd_sc_hd__decap_4
X_12054_ _05785_ _05786_ VGND VGND VPWR VPWR _05787_ sky130_fd_sc_hd__nand2b_1
XFILLER_111_429 VGND VGND VPWR VPWR sky130_fd_sc_hd__decap_3
XFILLER_104_481 VGND VGND VPWR VPWR sky130_fd_sc_hd__fill_1
XFILLER_77_321 VGND VGND VPWR VPWR sky130_fd_sc_hd__decap_8
XFILLER_77_365 VPWR VGND VPWR VGND sky130_ef_sc_hd__decap_12
XFILLER_65_505 VGND VGND VPWR VPWR sky130_fd_sc_hd__decap_3
X_11005_ _04742_ _04747_ VGND VGND VPWR VPWR _04749_ sky130_fd_sc_hd__xnor2_1
XFILLER_65_549 VGND VGND VPWR VPWR sky130_fd_sc_hd__decap_8
XFILLER_18_421 VPWR VGND VPWR VGND sky130_ef_sc_hd__decap_12
XTAP_TAPCELL_ROW_36_909 VGND VPWR sky130_fd_sc_hd__tapvpwrvgnd_1
X_12956_ u_interface.fifo_count\[2\] _01100_ net1 VGND VGND VPWR VPWR _06476_ sky130_fd_sc_hd__and3_1
XFILLER_46_796 VGND VGND VPWR VPWR sky130_fd_sc_hd__fill_1
X_12887_ net785 net918 VGND VGND VPWR VPWR _01029_ sky130_fd_sc_hd__and2_1
X_11907_ _05480_ _05563_ VGND VGND VPWR VPWR _05642_ sky130_fd_sc_hd__or2_1
XFILLER_61_777 VGND VGND VPWR VPWR sky130_fd_sc_hd__fill_2
X_11838_ net201 _05571_ VGND VGND VPWR VPWR _05573_ sky130_fd_sc_hd__xnor2_1
XTAP_TAPCELL_ROW_138_2539 VGND VPWR sky130_fd_sc_hd__tapvpwrvgnd_1
XTAP_TAPCELL_ROW_60_1303 VGND VPWR sky130_fd_sc_hd__tapvpwrvgnd_1
XFILLER_14_693 VGND VGND VPWR VPWR sky130_fd_sc_hd__decap_6
XTAP_TAPCELL_ROW_155_2831 VGND VPWR sky130_fd_sc_hd__tapvpwrvgnd_1
XTAP_TAPCELL_ROW_155_2820 VGND VPWR sky130_fd_sc_hd__tapvpwrvgnd_1
Xclkbuf_leaf_40_clk clknet_3_7__leaf_clk VGND VGND VPWR VPWR clknet_leaf_40_clk sky130_fd_sc_hd__clkbuf_8
X_13508_ clknet_leaf_3_clk _00518_ VGND VGND VPWR VPWR u_interface.u_gelu_fp32.u_synth_top.s2_m\[3\]
+ sky130_fd_sc_hd__dfxtp_1
X_11769_ _05503_ _05504_ VGND VGND VPWR VPWR _05505_ sky130_fd_sc_hd__xnor2_1
XFILLER_9_185 VGND VGND VPWR VPWR sky130_fd_sc_hd__fill_1
X_13439_ clknet_leaf_11_clk _00449_ VGND VGND VPWR VPWR u_interface.u_gelu_fp32.u_fp32_to_q16.s3_mag\[10\]
+ sky130_fd_sc_hd__dfxtp_1
XFILLER_61_3 VPWR VGND VPWR VGND sky130_ef_sc_hd__decap_12
XFILLER_9_196 VGND VGND VPWR VPWR sky130_fd_sc_hd__fill_1
XFILLER_155_882 VPWR VGND VPWR VGND sky130_ef_sc_hd__decap_12
XFILLER_6_881 VPWR VGND VPWR VGND sky130_ef_sc_hd__decap_12
XFILLER_114_245 VGND VGND VPWR VPWR sky130_fd_sc_hd__fill_1
XTAP_TAPCELL_ROW_58_1265 VGND VPWR sky130_fd_sc_hd__tapvpwrvgnd_1
XFILLER_5_391 VGND VGND VPWR VPWR sky130_fd_sc_hd__fill_1
X_08980_ net637 net646 net502 net508 VGND VGND VPWR VPWR _02739_ sky130_fd_sc_hd__and4_1
X_07931_ net1784 _01808_ _01824_ VGND VGND VPWR VPWR _01825_ sky130_fd_sc_hd__nand3_4
XFILLER_130_738 VGND VGND VPWR VPWR sky130_fd_sc_hd__fill_1
X_07862_ net567 net1520 net285 VGND VGND VPWR VPWR _00623_ sky130_fd_sc_hd__mux2_1
XTAP_TAPCELL_ROW_71_1476 VGND VPWR sky130_fd_sc_hd__tapvpwrvgnd_1
XTAP_TAPCELL_ROW_71_1465 VGND VPWR sky130_fd_sc_hd__tapvpwrvgnd_1
X_09601_ _03344_ _03356_ VGND VGND VPWR VPWR _03357_ sky130_fd_sc_hd__nand2_1
X_06813_ u_interface.fifo_data\[8\]\[23\] u_interface.fifo_data\[9\]\[23\] u_interface.fifo_data\[10\]\[23\]
+ u_interface.fifo_data\[11\]\[23\] net765 net748 VGND VGND VPWR VPWR _01365_ sky130_fd_sc_hd__mux4_1
XFILLER_95_162 VGND VGND VPWR VPWR sky130_fd_sc_hd__fill_1
XFILLER_83_313 VGND VGND VPWR VPWR sky130_fd_sc_hd__decap_8
XFILLER_68_376 VGND VGND VPWR VPWR sky130_fd_sc_hd__decap_4
XFILLER_3_93 VPWR VGND VPWR VGND sky130_ef_sc_hd__decap_12
X_07793_ net1228 net577 net236 VGND VGND VPWR VPWR _00554_ sky130_fd_sc_hd__mux2_1
X_09532_ net466 net620 net631 net471 VGND VGND VPWR VPWR _03289_ sky130_fd_sc_hd__a22o_1
XFILLER_83_335 VGND VGND VPWR VPWR sky130_fd_sc_hd__fill_1
X_06744_ net734 _01302_ net728 VGND VGND VPWR VPWR _01305_ sky130_fd_sc_hd__o21a_1
X_09463_ _02762_ _02764_ _03218_ _03219_ VGND VGND VPWR VPWR _03221_ sky130_fd_sc_hd__a211o_1
X_06675_ _01243_ _01244_ net729 VGND VGND VPWR VPWR _01245_ sky130_fd_sc_hd__mux2_1
X_09394_ net454 net458 net589 net601 VGND VGND VPWR VPWR _03152_ sky130_fd_sc_hd__and4_1
X_08414_ u_interface.u_gelu_fp32.u_synth_top.s3_mult\[20\] u_interface.u_gelu_fp32.u_synth_top.s3_b\[4\]
+ VGND VGND VPWR VPWR _02205_ sky130_fd_sc_hd__nand2_1
XFILLER_51_254 VGND VGND VPWR VPWR sky130_fd_sc_hd__decap_6
XFILLER_51_287 VGND VGND VPWR VPWR sky130_fd_sc_hd__fill_1
XFILLER_51_265 VPWR VGND VPWR VGND sky130_ef_sc_hd__decap_12
X_08345_ net528 net1665 _02140_ net797 VGND VGND VPWR VPWR _02142_ sky130_fd_sc_hd__a31o_1
Xclkbuf_leaf_31_clk clknet_3_6__leaf_clk VGND VGND VPWR VPWR clknet_leaf_31_clk sky130_fd_sc_hd__clkbuf_8
XFILLER_138_827 VGND VGND VPWR VPWR sky130_fd_sc_hd__fill_1
XFILLER_137_337 VGND VGND VPWR VPWR sky130_fd_sc_hd__decap_6
XFILLER_137_315 VGND VGND VPWR VPWR sky130_fd_sc_hd__fill_2
X_08276_ net532 _02089_ net1607 VGND VGND VPWR VPWR _02090_ sky130_fd_sc_hd__a21oi_1
X_07227_ _01528_ _01529_ VGND VGND VPWR VPWR _00264_ sky130_fd_sc_hd__nor2_1
XFILLER_118_540 VGND VGND VPWR VPWR sky130_fd_sc_hd__decap_4
X_07158_ net1020 net564 net217 VGND VGND VPWR VPWR _00198_ sky130_fd_sc_hd__mux2_1
XFILLER_3_317 VPWR VGND VPWR VGND sky130_ef_sc_hd__decap_12
XFILLER_133_521 VPWR VGND VPWR VGND sky130_ef_sc_hd__decap_12
XFILLER_105_223 VGND VGND VPWR VPWR sky130_fd_sc_hd__fill_1
XFILLER_121_727 VGND VGND VPWR VPWR sky130_fd_sc_hd__fill_1
X_07089_ net1120 net369 net225 VGND VGND VPWR VPWR _00129_ sky130_fd_sc_hd__mux2_1
Xfanout164 _01897_ VGND VGND VPWR VPWR net164 sky130_fd_sc_hd__clkbuf_2
Xfanout153 net155 VGND VGND VPWR VPWR net153 sky130_fd_sc_hd__clkbuf_2
XFILLER_101_484 VGND VGND VPWR VPWR sky130_fd_sc_hd__decap_8
Xfanout197 _03751_ VGND VGND VPWR VPWR net197 sky130_fd_sc_hd__buf_2
XFILLER_59_387 VGND VGND VPWR VPWR sky130_fd_sc_hd__decap_4
XFILLER_47_527 VGND VGND VPWR VPWR sky130_fd_sc_hd__fill_2
X_12810_ net778 net100 VGND VGND VPWR VPWR _00968_ sky130_fd_sc_hd__and2_1
XTAP_TAPCELL_ROW_89_1759 VGND VPWR sky130_fd_sc_hd__tapvpwrvgnd_1
XFILLER_86_195 VGND VGND VPWR VPWR sky130_fd_sc_hd__fill_1
XFILLER_103_50 VGND VGND VPWR VPWR sky130_fd_sc_hd__decap_6
XFILLER_62_508 VPWR VGND VPWR VGND sky130_ef_sc_hd__decap_12
X_13790_ clknet_leaf_81_clk _00800_ VGND VGND VPWR VPWR u_interface.u_gelu_fp32.s2_data\[24\]
+ sky130_fd_sc_hd__dfxtp_1
XTAP_TAPCELL_ROW_2_361 VGND VPWR sky130_fd_sc_hd__tapvpwrvgnd_1
XTAP_TAPCELL_ROW_2_372 VGND VPWR sky130_fd_sc_hd__tapvpwrvgnd_1
XFILLER_27_251 VGND VGND VPWR VPWR sky130_fd_sc_hd__decap_4
X_12741_ net280 _06361_ _06389_ net281 VGND VGND VPWR VPWR _06390_ sky130_fd_sc_hd__a22o_1
X_12672_ u_interface.u_gelu_fp32.u_q16_to_fp32.s1_mag\[27\] net1720 net796 VGND VGND
+ VPWR VPWR _00908_ sky130_fd_sc_hd__mux2_1
XFILLER_31_917 VGND VGND VPWR VPWR sky130_fd_sc_hd__fill_1
XFILLER_42_232 VPWR VGND VPWR VGND sky130_ef_sc_hd__decap_12
XFILLER_63_87 VGND VGND VPWR VPWR sky130_fd_sc_hd__fill_1
X_11623_ _05359_ _05360_ VGND VGND VPWR VPWR _05361_ sky130_fd_sc_hd__nor2_1
XTAP_TAPCELL_ROW_42_1000 VGND VPWR sky130_fd_sc_hd__tapvpwrvgnd_1
XFILLER_42_287 VGND VGND VPWR VPWR sky130_fd_sc_hd__fill_1
XTAP_TAPCELL_ROW_42_1011 VGND VPWR sky130_fd_sc_hd__tapvpwrvgnd_1
XFILLER_128_304 VGND VGND VPWR VPWR sky130_fd_sc_hd__decap_4
Xclkbuf_leaf_22_clk clknet_3_3__leaf_clk VGND VGND VPWR VPWR clknet_leaf_22_clk sky130_fd_sc_hd__clkbuf_8
XTAP_TAPCELL_ROW_100_1937 VGND VPWR sky130_fd_sc_hd__tapvpwrvgnd_1
XFILLER_11_641 VPWR VGND VPWR VGND sky130_ef_sc_hd__decap_12
XFILLER_8_27 VGND VGND VPWR VPWR sky130_fd_sc_hd__fill_1
X_11554_ _05143_ _05198_ _05197_ VGND VGND VPWR VPWR _05293_ sky130_fd_sc_hd__a21oi_1
XFILLER_11_685 VPWR VGND VPWR VGND sky130_ef_sc_hd__decap_12
XTAP_TAPCELL_ROW_41_989 VGND VPWR sky130_fd_sc_hd__tapvpwrvgnd_1
X_10505_ _04238_ _04250_ _04251_ VGND VGND VPWR VPWR _04253_ sky130_fd_sc_hd__nor3_1
X_11485_ _04701_ _04930_ VGND VGND VPWR VPWR _05224_ sky130_fd_sc_hd__nand2_1
XFILLER_6_133 VGND VGND VPWR VPWR sky130_fd_sc_hd__decap_6
XFILLER_137_871 VGND VGND VPWR VPWR sky130_fd_sc_hd__fill_1
XTAP_TAPCELL_ROW_133_2469 VGND VPWR sky130_fd_sc_hd__tapvpwrvgnd_1
XTAP_TAPCELL_ROW_133_2458 VGND VPWR sky130_fd_sc_hd__tapvpwrvgnd_1
X_10436_ _04183_ _04184_ _03995_ _03997_ VGND VGND VPWR VPWR _04185_ sky130_fd_sc_hd__o211ai_1
XFILLER_6_177 VPWR VGND VPWR VGND sky130_ef_sc_hd__decap_12
X_13224_ clknet_leaf_72_clk _00234_ VGND VGND VPWR VPWR u_interface.fifo_data\[11\]\[2\]
+ sky130_fd_sc_hd__dfxtp_1
X_13155_ clknet_leaf_34_clk _00165_ VGND VGND VPWR VPWR u_interface.fifo_tlast\[2\]
+ sky130_fd_sc_hd__dfxtp_1
X_10367_ _04112_ _04113_ _04114_ VGND VGND VPWR VPWR _04116_ sky130_fd_sc_hd__nand3_1
XFILLER_151_373 VGND VGND VPWR VPWR sky130_fd_sc_hd__fill_1
X_13086_ clknet_leaf_41_clk _00096_ VGND VGND VPWR VPWR u_interface.fifo_data\[15\]\[7\]
+ sky130_fd_sc_hd__dfxtp_1
XFILLER_97_449 VGND VGND VPWR VPWR sky130_fd_sc_hd__decap_3
XFILLER_97_438 VGND VGND VPWR VPWR sky130_fd_sc_hd__decap_3
X_10298_ net618 net436 VGND VGND VPWR VPWR _04048_ sky130_fd_sc_hd__nand2_1
XFILLER_3_895 VGND VGND VPWR VPWR sky130_fd_sc_hd__fill_1
X_12106_ _05755_ _05764_ _05763_ VGND VGND VPWR VPWR _05838_ sky130_fd_sc_hd__a21oi_1
XFILLER_78_641 VGND VGND VPWR VPWR sky130_fd_sc_hd__decap_3
Xclkbuf_leaf_89_clk clknet_3_1__leaf_clk VGND VGND VPWR VPWR clknet_leaf_89_clk sky130_fd_sc_hd__clkbuf_8
X_12037_ _05677_ _05694_ _05695_ VGND VGND VPWR VPWR _05770_ sky130_fd_sc_hd__a21oi_1
XTAP_TAPCELL_ROW_53_1184 VGND VPWR sky130_fd_sc_hd__tapvpwrvgnd_1
XFILLER_38_538 VGND VGND VPWR VPWR sky130_fd_sc_hd__fill_1
XFILLER_19_741 VPWR VGND VPWR VGND sky130_ef_sc_hd__decap_12
XFILLER_38_549 VGND VGND VPWR VPWR sky130_fd_sc_hd__fill_1
X_13988_ clknet_leaf_33_clk _00914_ VGND VGND VPWR VPWR u_interface.u_gelu_fp32.u_q16_to_fp32.s2_valid
+ sky130_fd_sc_hd__dfxtp_1
XFILLER_80_316 VGND VGND VPWR VPWR sky130_fd_sc_hd__decap_8
XFILLER_19_785 VPWR VGND VPWR VGND sky130_ef_sc_hd__decap_12
X_12939_ u_interface.in_flight_count\[4\] _06441_ _06462_ net789 VGND VGND VPWR VPWR
+ _01057_ sky130_fd_sc_hd__o211a_1
XFILLER_80_349 VGND VGND VPWR VPWR sky130_fd_sc_hd__fill_1
XFILLER_22_917 VGND VGND VPWR VPWR sky130_fd_sc_hd__decap_4
XFILLER_34_755 VGND VGND VPWR VPWR sky130_fd_sc_hd__fill_1
XFILLER_34_777 VPWR VGND VPWR VGND sky130_ef_sc_hd__decap_12
XFILLER_21_405 VPWR VGND VPWR VGND sky130_ef_sc_hd__decap_12
Xclkbuf_leaf_13_clk clknet_3_2__leaf_clk VGND VGND VPWR VPWR clknet_leaf_13_clk sky130_fd_sc_hd__clkbuf_8
X_08130_ net313 _01972_ _01971_ VGND VGND VPWR VPWR _01974_ sky130_fd_sc_hd__o21ai_1
XFILLER_14_490 VGND VGND VPWR VPWR sky130_fd_sc_hd__fill_1
XFILLER_21_449 VPWR VGND VPWR VGND sky130_ef_sc_hd__decap_12
XFILLER_147_613 VGND VGND VPWR VPWR sky130_fd_sc_hd__decap_3
XFILLER_119_337 VGND VGND VPWR VPWR sky130_fd_sc_hd__decap_8
X_08061_ u_interface.u_gelu_fp32.u_fp32_to_q16.s3_mag\[2\] _01873_ VGND VGND VPWR
+ VPWR _01916_ sky130_fd_sc_hd__nor2_1
XFILLER_146_178 VGND VGND VPWR VPWR sky130_fd_sc_hd__fill_2
XFILLER_134_307 VGND VGND VPWR VPWR sky130_fd_sc_hd__fill_1
X_07012_ u_interface.fifo_wr_ptr\[3\] _01523_ VGND VGND VPWR VPWR _01524_ sky130_fd_sc_hd__nand2_1
XFILLER_115_510 VGND VGND VPWR VPWR sky130_fd_sc_hd__fill_1
XFILLER_143_852 VGND VGND VPWR VPWR sky130_fd_sc_hd__fill_2
XFILLER_143_841 VGND VGND VPWR VPWR sky130_fd_sc_hd__fill_2
XTAP_TAPCELL_ROW_73_1505 VGND VPWR sky130_fd_sc_hd__tapvpwrvgnd_1
XFILLER_142_351 VPWR VGND VPWR VGND sky130_ef_sc_hd__decap_12
XFILLER_0_309 VPWR VGND VPWR VGND sky130_ef_sc_hd__decap_12
X_08963_ _02567_ _02569_ _02568_ VGND VGND VPWR VPWR _02722_ sky130_fd_sc_hd__o21ai_1
XFILLER_103_738 VGND VGND VPWR VPWR sky130_fd_sc_hd__decap_4
XFILLER_88_427 VPWR VGND VPWR VGND sky130_ef_sc_hd__decap_12
X_07914_ u_interface.u_gelu_fp32.u_fp32_to_q16.s1_exp\[3\] u_interface.u_gelu_fp32.u_fp32_to_q16.s1_exp\[2\]
+ u_interface.u_gelu_fp32.u_fp32_to_q16.s1_exp\[1\] _01807_ VGND VGND VPWR VPWR _01808_
+ sky130_fd_sc_hd__a31o_1
XFILLER_130_557 VPWR VGND VPWR VGND sky130_ef_sc_hd__decap_12
X_08894_ _02636_ _02652_ VGND VGND VPWR VPWR _02653_ sky130_fd_sc_hd__or2_1
XFILLER_57_836 VGND VGND VPWR VPWR sky130_fd_sc_hd__decap_4
X_07845_ net362 net1477 net285 VGND VGND VPWR VPWR _00606_ sky130_fd_sc_hd__mux2_1
XFILLER_72_806 VGND VGND VPWR VPWR sky130_fd_sc_hd__decap_6
XTAP_TAPCELL_ROW_104_2004 VGND VPWR sky130_fd_sc_hd__tapvpwrvgnd_1
XFILLER_83_165 VGND VGND VPWR VPWR sky130_fd_sc_hd__decap_3
X_07776_ net1231 net373 net233 VGND VGND VPWR VPWR _00537_ sky130_fd_sc_hd__mux2_1
X_09515_ net462 net612 VGND VGND VPWR VPWR _03272_ sky130_fd_sc_hd__nand2_1
X_06727_ u_interface.fifo_data\[12\]\[12\] u_interface.fifo_data\[13\]\[12\] u_interface.fifo_data\[14\]\[12\]
+ u_interface.fifo_data\[15\]\[12\] net760 net743 VGND VGND VPWR VPWR _01290_ sky130_fd_sc_hd__mux4_1
XFILLER_71_349 VPWR VGND VPWR VGND sky130_ef_sc_hd__decap_12
XFILLER_17_69 VPWR VGND VPWR VGND sky130_ef_sc_hd__decap_12
XFILLER_140_59 VPWR VGND VPWR VGND sky130_ef_sc_hd__decap_12
X_09446_ _03202_ _03203_ _03186_ VGND VGND VPWR VPWR _03204_ sky130_fd_sc_hd__o21ai_1
XTAP_TAPCELL_ROW_84_1678 VGND VPWR sky130_fd_sc_hd__tapvpwrvgnd_1
XFILLER_25_777 VGND VGND VPWR VPWR sky130_fd_sc_hd__decap_6
X_06658_ u_interface.fifo_data\[4\]\[3\] u_interface.fifo_data\[5\]\[3\] u_interface.fifo_data\[6\]\[3\]
+ u_interface.fifo_data\[7\]\[3\] net758 net741 VGND VGND VPWR VPWR _01230_ sky130_fd_sc_hd__mux4_1
XFILLER_12_405 VGND VGND VPWR VPWR sky130_fd_sc_hd__decap_8
XFILLER_24_265 VPWR VGND VPWR VGND sky130_ef_sc_hd__decap_12
X_09377_ net484 net657 VGND VGND VPWR VPWR _03135_ sky130_fd_sc_hd__nand2_1
X_06589_ net538 u_interface.u_gelu_fp32.s1_data\[14\] _01176_ VGND VGND VPWR VPWR
+ _00022_ sky130_fd_sc_hd__and3_1
XFILLER_33_57 VGND VGND VPWR VPWR sky130_fd_sc_hd__fill_1
XFILLER_138_635 VGND VGND VPWR VPWR sky130_fd_sc_hd__fill_1
XFILLER_138_613 VGND VGND VPWR VPWR sky130_fd_sc_hd__decap_6
X_08328_ net529 _02128_ net1627 VGND VGND VPWR VPWR _02129_ sky130_fd_sc_hd__a21oi_1
X_08259_ net533 u_interface.u_gelu_fp32.s2_data\[4\] _02076_ net823 VGND VGND VPWR
+ VPWR _02078_ sky130_fd_sc_hd__a31o_1
XTAP_TAPCELL_ROW_115_2177 VGND VPWR sky130_fd_sc_hd__tapvpwrvgnd_1
XFILLER_109_3 VGND VGND VPWR VPWR sky130_fd_sc_hd__decap_3
X_11270_ _05009_ _05010_ VGND VGND VPWR VPWR _05012_ sky130_fd_sc_hd__xnor2_1
XFILLER_4_637 VGND VGND VPWR VPWR sky130_fd_sc_hd__decap_6
XFILLER_3_125 VPWR VGND VPWR VGND sky130_ef_sc_hd__decap_12
X_10221_ _03966_ _03971_ VGND VGND VPWR VPWR _03972_ sky130_fd_sc_hd__nand2_1
XFILLER_3_169 VPWR VGND VPWR VGND sky130_ef_sc_hd__decap_12
X_10152_ _03892_ _03902_ VGND VGND VPWR VPWR _03903_ sky130_fd_sc_hd__xnor2_1
XFILLER_79_449 VPWR VGND VPWR VGND sky130_ef_sc_hd__decap_12
XTAP_TAPCELL_ROW_7_442 VGND VPWR sky130_fd_sc_hd__tapvpwrvgnd_1
X_10083_ _03833_ _03834_ _03821_ VGND VGND VPWR VPWR _03835_ sky130_fd_sc_hd__o21ai_1
XFILLER_58_54 VPWR VGND VPWR VGND sky130_ef_sc_hd__decap_12
XTAP_TAPCELL_ROW_7_453 VGND VPWR sky130_fd_sc_hd__tapvpwrvgnd_1
XFILLER_0_865 VGND VGND VPWR VPWR sky130_fd_sc_hd__decap_3
Xhold9 u_interface.u_gelu_fp32.u_synth_top.s1_x\[11\] VGND VGND VPWR VPWR net874 sky130_fd_sc_hd__dlygate4sd3_1
X_13911_ clknet_leaf_3_clk net538 VGND VGND VPWR VPWR u_interface.u_gelu_fp32.u_synth_top.s1_x\[15\]
+ sky130_fd_sc_hd__dfxtp_1
XFILLER_48_869 VGND VGND VPWR VPWR sky130_fd_sc_hd__decap_4
XFILLER_47_335 VGND VGND VPWR VPWR sky130_fd_sc_hd__fill_1
X_13842_ clknet_leaf_78_clk _00852_ VGND VGND VPWR VPWR u_interface.u_gelu_fp32.u_synth_top.s3_mult\[61\]
+ sky130_fd_sc_hd__dfxtp_1
X_13773_ clknet_leaf_57_clk _00783_ VGND VGND VPWR VPWR u_interface.u_gelu_fp32.s2_data\[7\]
+ sky130_fd_sc_hd__dfxtp_1
X_12724_ net281 _06375_ _06376_ VGND VGND VPWR VPWR _06377_ sky130_fd_sc_hd__a21o_1
XFILLER_55_390 VGND VGND VPWR VPWR sky130_fd_sc_hd__fill_2
X_10985_ _04726_ _04727_ net668 net434 VGND VGND VPWR VPWR _04729_ sky130_fd_sc_hd__and4bb_1
XFILLER_16_755 VGND VGND VPWR VPWR sky130_fd_sc_hd__fill_1
XTAP_TAPCELL_ROW_26_750 VGND VPWR sky130_fd_sc_hd__tapvpwrvgnd_1
XFILLER_130_81 VGND VGND VPWR VPWR sky130_fd_sc_hd__decap_3
X_12655_ net1663 u_interface.u_gelu_fp32.u_q16_to_fp32.s2_mag\[10\] net805 VGND VGND
+ VPWR VPWR _00891_ sky130_fd_sc_hd__mux2_1
XFILLER_15_298 VPWR VGND VPWR VGND sky130_ef_sc_hd__decap_12
XFILLER_30_235 VGND VGND VPWR VPWR sky130_fd_sc_hd__decap_6
X_12586_ _06286_ _06287_ _06288_ _06289_ VGND VGND VPWR VPWR _06290_ sky130_fd_sc_hd__or4_1
XFILLER_128_112 VGND VGND VPWR VPWR sky130_fd_sc_hd__decap_6
XFILLER_90_85 VGND VGND VPWR VPWR sky130_fd_sc_hd__decap_8
XFILLER_30_268 VGND VGND VPWR VPWR sky130_fd_sc_hd__decap_6
X_11606_ _05329_ _05341_ _05342_ VGND VGND VPWR VPWR _05344_ sky130_fd_sc_hd__or3b_1
XFILLER_11_493 VGND VGND VPWR VPWR sky130_fd_sc_hd__decap_8
X_11537_ _05271_ _05275_ VGND VGND VPWR VPWR _05276_ sky130_fd_sc_hd__xnor2_1
XFILLER_144_616 VGND VGND VPWR VPWR sky130_fd_sc_hd__decap_4
XFILLER_128_178 VGND VGND VPWR VPWR sky130_fd_sc_hd__fill_1
Xhold409 u_interface.fifo_data\[14\]\[23\] VGND VGND VPWR VPWR net1274 sky130_fd_sc_hd__dlygate4sd3_1
XFILLER_99_61 VGND VGND VPWR VPWR sky130_fd_sc_hd__fill_1
X_11468_ _05023_ _05109_ _05108_ VGND VGND VPWR VPWR _05208_ sky130_fd_sc_hd__a21oi_1
X_13207_ clknet_leaf_53_clk _00217_ VGND VGND VPWR VPWR u_interface.fifo_data\[12\]\[17\]
+ sky130_fd_sc_hd__dfxtp_1
X_10419_ _04158_ _04165_ _04166_ VGND VGND VPWR VPWR _04168_ sky130_fd_sc_hd__nand3_1
XTAP_TAPCELL_ROW_55_1213 VGND VPWR sky130_fd_sc_hd__tapvpwrvgnd_1
X_11399_ net205 _05137_ VGND VGND VPWR VPWR _05139_ sky130_fd_sc_hd__xnor2_1
XFILLER_124_384 VPWR VGND VPWR VGND sky130_ef_sc_hd__decap_12
X_13138_ clknet_leaf_66_clk _00148_ VGND VGND VPWR VPWR u_interface.fifo_data\[2\]\[27\]
+ sky130_fd_sc_hd__dfxtp_1
XFILLER_112_557 VGND VGND VPWR VPWR sky130_fd_sc_hd__fill_1
XFILLER_98_769 VPWR VGND VPWR VGND sky130_ef_sc_hd__decap_12
X_13069_ clknet_leaf_36_clk _00079_ VGND VGND VPWR VPWR u_interface.fifo_data\[14\]\[22\]
+ sky130_fd_sc_hd__dfxtp_1
Xclkbuf_leaf_2_clk clknet_3_2__leaf_clk VGND VGND VPWR VPWR clknet_leaf_2_clk sky130_fd_sc_hd__clkbuf_8
XFILLER_24_3 VPWR VGND VPWR VGND sky130_ef_sc_hd__decap_12
XPHY_EDGE_ROW_119_Right_119 VGND VGND VPWR VPWR sky130_fd_sc_hd__decap_3
XFILLER_65_132 VGND VGND VPWR VPWR sky130_fd_sc_hd__decap_3
X_07630_ _01719_ _01711_ net334 VGND VGND VPWR VPWR _01720_ sky130_fd_sc_hd__mux2_1
XFILLER_66_666 VGND VGND VPWR VPWR sky130_fd_sc_hd__decap_6
XFILLER_65_143 VPWR VGND VPWR VGND sky130_ef_sc_hd__decap_12
XFILLER_54_817 VGND VGND VPWR VPWR sky130_fd_sc_hd__decap_3
XFILLER_53_305 VPWR VGND VPWR VGND sky130_ef_sc_hd__decap_12
X_07561_ _01641_ _01637_ net545 VGND VGND VPWR VPWR _01675_ sky130_fd_sc_hd__mux2_1
XFILLER_47_891 VGND VGND VPWR VPWR sky130_fd_sc_hd__fill_1
XFILLER_19_593 VPWR VGND VPWR VGND sky130_ef_sc_hd__decap_12
X_09300_ _03043_ _03057_ _03058_ VGND VGND VPWR VPWR _03059_ sky130_fd_sc_hd__nand3_1
XFILLER_62_850 VGND VGND VPWR VPWR sky130_fd_sc_hd__fill_2
XFILLER_53_349 VPWR VGND VPWR VGND sky130_ef_sc_hd__decap_12
X_06512_ net388 VGND VGND VPWR VPWR _01112_ sky130_fd_sc_hd__inv_2
X_07492_ net552 _01624_ VGND VGND VPWR VPWR _01625_ sky130_fd_sc_hd__and2_1
XFILLER_110_29 VPWR VGND VPWR VGND sky130_ef_sc_hd__decap_12
XTAP_TAPCELL_ROW_66_1397 VGND VPWR sky130_fd_sc_hd__tapvpwrvgnd_1
XTAP_TAPCELL_ROW_66_1386 VGND VPWR sky130_fd_sc_hd__tapvpwrvgnd_1
XFILLER_22_725 VPWR VGND VPWR VGND sky130_ef_sc_hd__decap_12
XFILLER_34_574 VPWR VGND VPWR VGND sky130_ef_sc_hd__decap_12
X_09231_ _02986_ _02987_ _02989_ VGND VGND VPWR VPWR _02990_ sky130_fd_sc_hd__and3_1
XFILLER_61_393 VGND VGND VPWR VPWR sky130_fd_sc_hd__decap_4
XPHY_EDGE_ROW_14_Left_170 VGND VGND VPWR VPWR sky130_fd_sc_hd__decap_3
XFILLER_21_235 VPWR VGND VPWR VGND sky130_ef_sc_hd__decap_12
XFILLER_22_769 VPWR VGND VPWR VGND sky130_ef_sc_hd__decap_12
X_09162_ _02875_ _02877_ VGND VGND VPWR VPWR _02921_ sky130_fd_sc_hd__xnor2_1
XFILLER_9_81 VPWR VGND VPWR VGND sky130_ef_sc_hd__decap_12
XFILLER_119_27 VPWR VGND VPWR VGND sky130_ef_sc_hd__decap_12
X_08113_ net313 _01958_ _01957_ VGND VGND VPWR VPWR _01960_ sky130_fd_sc_hd__o21ai_1
X_09093_ _02831_ _02849_ _02850_ _02851_ VGND VGND VPWR VPWR _02852_ sky130_fd_sc_hd__or4b_1
XFILLER_134_126 VGND VGND VPWR VPWR sky130_fd_sc_hd__decap_3
X_08044_ u_interface.u_gelu_fp32.u_fp32_to_q16.s3_frac\[13\] u_interface.u_gelu_fp32.u_fp32_to_q16.s3_frac\[12\]
+ u_interface.u_gelu_fp32.u_fp32_to_q16.s3_frac\[15\] u_interface.u_gelu_fp32.u_fp32_to_q16.s3_frac\[14\]
+ VGND VGND VPWR VPWR _01901_ sky130_fd_sc_hd__or4_1
Xhold910 u_interface.u_gelu_fp32.u_fp32_to_q16.s3_mag\[12\] VGND VGND VPWR VPWR net1775
+ sky130_fd_sc_hd__dlygate4sd3_1
Xhold921 u_interface.u_gelu_fp32.u_synth_top.s1_hits\[10\] VGND VGND VPWR VPWR net1786
+ sky130_fd_sc_hd__dlygate4sd3_1
XFILLER_116_863 VGND VGND VPWR VPWR sky130_fd_sc_hd__decap_4
XFILLER_89_714 VGND VGND VPWR VPWR sky130_fd_sc_hd__fill_2
XFILLER_88_213 VGND VGND VPWR VPWR sky130_fd_sc_hd__decap_8
XFILLER_1_629 VPWR VGND VPWR VGND sky130_ef_sc_hd__decap_12
X_09995_ _03741_ _03743_ _03745_ _03747_ VGND VGND VPWR VPWR _00814_ sky130_fd_sc_hd__o31a_1
XFILLER_130_387 VPWR VGND VPWR VGND sky130_ef_sc_hd__decap_12
XFILLER_130_365 VGND VGND VPWR VPWR sky130_fd_sc_hd__decap_4
X_08946_ _02703_ _02704_ _02629_ VGND VGND VPWR VPWR _02705_ sky130_fd_sc_hd__a21oi_1
XTAP_TAPCELL_ROW_110_2096 VGND VPWR sky130_fd_sc_hd__tapvpwrvgnd_1
XTAP_TAPCELL_ROW_4_401 VGND VPWR sky130_fd_sc_hd__tapvpwrvgnd_1
X_08877_ _02621_ _02634_ VGND VGND VPWR VPWR _02636_ sky130_fd_sc_hd__xor2_1
XFILLER_56_121 VGND VGND VPWR VPWR sky130_fd_sc_hd__fill_2
X_07828_ net1395 net571 net231 VGND VGND VPWR VPWR _00589_ sky130_fd_sc_hd__mux2_1
XTAP_TAPCELL_ROW_86_1718 VGND VPWR sky130_fd_sc_hd__tapvpwrvgnd_1
XTAP_TAPCELL_ROW_86_1707 VGND VPWR sky130_fd_sc_hd__tapvpwrvgnd_1
XFILLER_56_165 VPWR VGND VPWR VGND sky130_ef_sc_hd__decap_12
XFILLER_45_817 VGND VGND VPWR VPWR sky130_fd_sc_hd__fill_2
XFILLER_29_357 VGND VGND VPWR VPWR sky130_fd_sc_hd__decap_3
XFILLER_151_69 VGND VGND VPWR VPWR sky130_fd_sc_hd__decap_8
XFILLER_71_113 VGND VGND VPWR VPWR sky130_fd_sc_hd__fill_1
X_07759_ _01798_ _01799_ VGND VGND VPWR VPWR _00525_ sky130_fd_sc_hd__nor2_1
X_10770_ _04510_ _04515_ VGND VGND VPWR VPWR _04516_ sky130_fd_sc_hd__nand2b_1
XFILLER_53_872 VGND VGND VPWR VPWR sky130_fd_sc_hd__fill_2
XFILLER_44_56 VPWR VGND VPWR VGND sky130_ef_sc_hd__decap_12
XFILLER_40_500 VGND VGND VPWR VPWR sky130_fd_sc_hd__fill_2
X_09429_ _02641_ _02649_ _02650_ VGND VGND VPWR VPWR _03187_ sky130_fd_sc_hd__a21o_1
XFILLER_12_235 VGND VGND VPWR VPWR sky130_fd_sc_hd__fill_1
XFILLER_40_533 VPWR VGND VPWR VGND sky130_ef_sc_hd__decap_12
XTAP_TAPCELL_ROW_117_2206 VGND VPWR sky130_fd_sc_hd__tapvpwrvgnd_1
XFILLER_9_729 VPWR VGND VPWR VGND sky130_ef_sc_hd__decap_12
X_12440_ net191 _06165_ VGND VGND VPWR VPWR _06167_ sky130_fd_sc_hd__nand2_1
XFILLER_138_421 VPWR VGND VPWR VGND sky130_ef_sc_hd__decap_12
X_14110_ clknet_leaf_27_clk _01036_ VGND VGND VPWR VPWR u_interface.meta_tlast_pipe\[3\]
+ sky130_fd_sc_hd__dfxtp_1
X_12371_ _06096_ _06097_ VGND VGND VPWR VPWR _06099_ sky130_fd_sc_hd__xnor2_1
XTAP_TAPCELL_ROW_130_2417 VGND VPWR sky130_fd_sc_hd__tapvpwrvgnd_1
XFILLER_125_137 VGND VGND VPWR VPWR sky130_fd_sc_hd__fill_2
X_11322_ _05045_ _05062_ VGND VGND VPWR VPWR _05063_ sky130_fd_sc_hd__xor2_2
XFILLER_4_401 VPWR VGND VPWR VGND sky130_ef_sc_hd__decap_12
X_14041_ clknet_leaf_16_clk _00967_ VGND VGND VPWR VPWR u_interface.u_gelu_fp32.u_fp32_to_q16.s1_mant\[3\]
+ sky130_fd_sc_hd__dfxtp_1
XFILLER_125_159 VGND VGND VPWR VPWR sky130_fd_sc_hd__decap_8
XFILLER_106_351 VPWR VGND VPWR VGND sky130_ef_sc_hd__decap_12
X_11253_ _04993_ _04994_ VGND VGND VPWR VPWR _04995_ sky130_fd_sc_hd__xnor2_1
XFILLER_5_39 VPWR VGND VPWR VGND sky130_ef_sc_hd__decap_12
XFILLER_4_445 VPWR VGND VPWR VGND sky130_ef_sc_hd__decap_12
X_10204_ _03953_ _03954_ _03844_ _03847_ VGND VGND VPWR VPWR _03955_ sky130_fd_sc_hd__o211a_1
XFILLER_4_489 VPWR VGND VPWR VGND sky130_ef_sc_hd__decap_12
XFILLER_121_321 VGND VGND VPWR VPWR sky130_fd_sc_hd__decap_3
X_11184_ net206 _04824_ _04823_ VGND VGND VPWR VPWR _04926_ sky130_fd_sc_hd__o21ba_1
XFILLER_94_216 VGND VGND VPWR VPWR sky130_fd_sc_hd__fill_1
X_10135_ _03862_ _03883_ _03884_ VGND VGND VPWR VPWR _03886_ sky130_fd_sc_hd__nand3_1
XFILLER_67_408 VGND VGND VPWR VPWR sky130_fd_sc_hd__fill_1
XFILLER_0_673 VGND VGND VPWR VPWR sky130_fd_sc_hd__decap_8
XFILLER_125_92 VGND VGND VPWR VPWR sky130_fd_sc_hd__decap_4
XFILLER_94_238 VPWR VGND VPWR VGND sky130_ef_sc_hd__decap_12
X_10066_ _03814_ _03815_ _03816_ VGND VGND VPWR VPWR _03818_ sky130_fd_sc_hd__a21o_1
XTAP_TAPCELL_ROW_50_1143 VGND VPWR sky130_fd_sc_hd__tapvpwrvgnd_1
XTAP_TAPCELL_ROW_50_1132 VGND VPWR sky130_fd_sc_hd__tapvpwrvgnd_1
XFILLER_47_121 VGND VGND VPWR VPWR sky130_fd_sc_hd__fill_1
XTAP_TAPCELL_ROW_145_2660 VGND VPWR sky130_fd_sc_hd__tapvpwrvgnd_1
XTAP_TAPCELL_ROW_128_2379 VGND VPWR sky130_fd_sc_hd__tapvpwrvgnd_1
X_13825_ clknet_leaf_80_clk _00835_ VGND VGND VPWR VPWR u_interface.u_gelu_fp32.u_synth_top.s3_mult\[43\]
+ sky130_fd_sc_hd__dfxtp_1
XFILLER_141_80 VGND VGND VPWR VPWR sky130_fd_sc_hd__decap_8
XFILLER_63_669 VGND VGND VPWR VPWR sky130_fd_sc_hd__decap_3
XFILLER_90_477 VGND VGND VPWR VPWR sky130_fd_sc_hd__decap_3
X_10968_ _04709_ _04710_ VGND VGND VPWR VPWR _04712_ sky130_fd_sc_hd__xnor2_1
X_13756_ clknet_leaf_84_clk _00766_ VGND VGND VPWR VPWR u_interface.u_gelu_fp32.u_q16_to_fp32.s1_mag\[22\]
+ sky130_fd_sc_hd__dfxtp_1
X_13687_ clknet_leaf_12_clk _00697_ VGND VGND VPWR VPWR u_interface.u_gelu_fp32.u_fp32_to_q16.s3_frac\[23\]
+ sky130_fd_sc_hd__dfxtp_1
X_12707_ u_interface.u_gelu_fp32.u_q16_to_fp32.s2_clz\[3\] _01722_ net288 VGND VGND
+ VPWR VPWR _06363_ sky130_fd_sc_hd__o21ai_1
XFILLER_43_393 VPWR VGND VPWR VGND sky130_ef_sc_hd__decap_12
XFILLER_31_522 VPWR VGND VPWR VGND sky130_ef_sc_hd__decap_12
XFILLER_148_218 VGND VGND VPWR VPWR sky130_fd_sc_hd__fill_2
X_12638_ net825 net1579 _06329_ _06337_ VGND VGND VPWR VPWR _00877_ sky130_fd_sc_hd__a22o_1
X_10899_ _04615_ _04616_ _04642_ _04643_ VGND VGND VPWR VPWR _04644_ sky130_fd_sc_hd__a22o_1
XFILLER_31_566 VGND VGND VPWR VPWR sky130_fd_sc_hd__decap_6
XFILLER_129_443 VGND VGND VPWR VPWR sky130_fd_sc_hd__decap_4
X_12569_ net773 net1749 VGND VGND VPWR VPWR _00867_ sky130_fd_sc_hd__and2_1
Xhold217 u_interface.fifo_data\[0\]\[11\] VGND VGND VPWR VPWR net1082 sky130_fd_sc_hd__dlygate4sd3_1
Xhold206 u_interface.fifo_data\[10\]\[6\] VGND VGND VPWR VPWR net1071 sky130_fd_sc_hd__dlygate4sd3_1
XFILLER_144_468 VGND VGND VPWR VPWR sky130_fd_sc_hd__fill_2
Xhold228 u_interface.fifo_data\[9\]\[12\] VGND VGND VPWR VPWR net1093 sky130_fd_sc_hd__dlygate4sd3_1
Xhold239 u_interface.fifo_data\[14\]\[2\] VGND VGND VPWR VPWR net1104 sky130_fd_sc_hd__dlygate4sd3_1
X_08800_ _02516_ _02557_ _02558_ VGND VGND VPWR VPWR _02559_ sky130_fd_sc_hd__nand3_2
XFILLER_112_332 VGND VGND VPWR VPWR sky130_fd_sc_hd__fill_1
Xfanout708 u_interface.u_gelu_fp32.u_synth_top.s2_m\[15\] VGND VGND VPWR VPWR net708
+ sky130_fd_sc_hd__clkbuf_4
Xfanout719 net720 VGND VGND VPWR VPWR net719 sky130_fd_sc_hd__clkbuf_2
X_06992_ _01506_ _01512_ VGND VGND VPWR VPWR _01513_ sky130_fd_sc_hd__nor2_2
XFILLER_112_365 VGND VGND VPWR VPWR sky130_fd_sc_hd__fill_1
X_09780_ _03532_ _03533_ VGND VGND VPWR VPWR _03534_ sky130_fd_sc_hd__nor2_1
XFILLER_58_419 VGND VGND VPWR VPWR sky130_fd_sc_hd__fill_1
XPHY_EDGE_ROW_7_Right_7 VGND VGND VPWR VPWR sky130_fd_sc_hd__decap_3
X_08731_ _02487_ _02488_ _02489_ VGND VGND VPWR VPWR _02490_ sky130_fd_sc_hd__or3_1
XFILLER_66_430 VGND VGND VPWR VPWR sky130_fd_sc_hd__fill_1
X_08662_ net156 _02426_ VGND VGND VPWR VPWR _02427_ sky130_fd_sc_hd__nand2_1
X_07613_ net331 _01706_ VGND VGND VPWR VPWR _01707_ sky130_fd_sc_hd__nor2_1
XTAP_TAPCELL_ROW_68_1426 VGND VPWR sky130_fd_sc_hd__tapvpwrvgnd_1
XFILLER_53_113 VGND VGND VPWR VPWR sky130_fd_sc_hd__decap_4
XFILLER_26_305 VGND VGND VPWR VPWR sky130_fd_sc_hd__decap_3
XFILLER_27_839 VGND VGND VPWR VPWR sky130_fd_sc_hd__fill_1
XFILLER_38_176 VPWR VGND VPWR VGND sky130_ef_sc_hd__decap_12
XFILLER_93_293 VPWR VGND VPWR VGND sky130_ef_sc_hd__decap_12
X_08593_ net155 _02376_ net801 VGND VGND VPWR VPWR _00783_ sky130_fd_sc_hd__a21oi_1
X_07544_ _01595_ _01577_ net549 VGND VGND VPWR VPWR _01662_ sky130_fd_sc_hd__mux2_1
XFILLER_81_477 VPWR VGND VPWR VGND sky130_ef_sc_hd__decap_12
XTAP_TAPCELL_ROW_81_1626 VGND VPWR sky130_fd_sc_hd__tapvpwrvgnd_1
XFILLER_35_861 VPWR VGND VPWR VGND sky130_ef_sc_hd__decap_12
X_07475_ _01565_ _01543_ net555 VGND VGND VPWR VPWR _01609_ sky130_fd_sc_hd__mux2_1
XTAP_TAPCELL_ROW_81_1637 VGND VPWR sky130_fd_sc_hd__tapvpwrvgnd_1
XFILLER_14_15 VPWR VGND VPWR VGND sky130_ef_sc_hd__decap_12
XFILLER_22_544 VPWR VGND VPWR VGND sky130_ef_sc_hd__decap_12
X_09214_ _02931_ _02967_ _02972_ VGND VGND VPWR VPWR _02973_ sky130_fd_sc_hd__nand3_1
XFILLER_139_218 VGND VGND VPWR VPWR sky130_fd_sc_hd__decap_6
X_09145_ _02899_ _02900_ _02902_ VGND VGND VPWR VPWR _02904_ sky130_fd_sc_hd__nand3_1
XFILLER_108_605 VPWR VGND VPWR VGND sky130_ef_sc_hd__decap_12
X_09076_ _02785_ _02787_ _02786_ VGND VGND VPWR VPWR _02835_ sky130_fd_sc_hd__o21ai_1
XFILLER_150_405 VGND VGND VPWR VPWR sky130_fd_sc_hd__decap_3
XFILLER_135_457 VGND VGND VPWR VPWR sky130_fd_sc_hd__decap_8
XTAP_TAPCELL_ROW_112_2125 VGND VPWR sky130_fd_sc_hd__tapvpwrvgnd_1
X_08027_ u_interface.u_gelu_fp32.u_fp32_to_q16.s3_mag\[16\] u_interface.u_gelu_fp32.u_fp32_to_q16.s3_mag\[15\]
+ _01883_ VGND VGND VPWR VPWR _01884_ sky130_fd_sc_hd__and3_1
XTAP_TAPCELL_ROW_79_1599 VGND VPWR sky130_fd_sc_hd__tapvpwrvgnd_1
XFILLER_2_905 VPWR VGND VPWR VGND sky130_ef_sc_hd__decap_12
Xhold751 u_interface.u_gelu_fp32.u_fp32_to_q16.s1_mant\[21\] VGND VGND VPWR VPWR net1616
+ sky130_fd_sc_hd__dlygate4sd3_1
Xhold740 u_interface.u_gelu_fp32.u_fp32_to_q16.s3_frac\[28\] VGND VGND VPWR VPWR net1605
+ sky130_fd_sc_hd__dlygate4sd3_1
Xhold773 u_interface.u_gelu_fp32.u_fp32_to_q16.s3_mag\[4\] VGND VGND VPWR VPWR net1638
+ sky130_fd_sc_hd__dlygate4sd3_1
XFILLER_122_129 VGND VGND VPWR VPWR sky130_fd_sc_hd__decap_3
XFILLER_122_107 VGND VGND VPWR VPWR sky130_fd_sc_hd__fill_2
Xhold762 u_interface.u_gelu_fp32.s2_data\[22\] VGND VGND VPWR VPWR net1627 sky130_fd_sc_hd__dlygate4sd3_1
Xhold795 u_interface.fifo_rd_ptr\[3\] VGND VGND VPWR VPWR net1660 sky130_fd_sc_hd__dlygate4sd3_1
XFILLER_89_566 VGND VGND VPWR VPWR sky130_fd_sc_hd__decap_6
Xhold784 u_interface.u_gelu_fp32.u_q16_to_fp32.s3_norm_mag\[9\] VGND VGND VPWR VPWR
+ net1649 sky130_fd_sc_hd__dlygate4sd3_1
X_09978_ _03729_ _03730_ _03633_ VGND VGND VPWR VPWR _03731_ sky130_fd_sc_hd__o21ai_1
XFILLER_89_588 VGND VGND VPWR VPWR sky130_fd_sc_hd__decap_4
XFILLER_130_184 VGND VGND VPWR VPWR sky130_fd_sc_hd__decap_4
X_08929_ _02686_ _02687_ _02677_ VGND VGND VPWR VPWR _02688_ sky130_fd_sc_hd__a21oi_1
XFILLER_57_441 VGND VGND VPWR VPWR sky130_fd_sc_hd__fill_1
X_11940_ _05672_ _05673_ _05668_ VGND VGND VPWR VPWR _05674_ sky130_fd_sc_hd__a21oi_1
XFILLER_85_783 VGND VGND VPWR VPWR sky130_fd_sc_hd__fill_1
XFILLER_55_44 VPWR VGND VPWR VGND sky130_ef_sc_hd__decap_12
XFILLER_17_327 VGND VGND VPWR VPWR sky130_fd_sc_hd__decap_8
XFILLER_29_165 VGND VGND VPWR VPWR sky130_fd_sc_hd__decap_3
XFILLER_17_349 VPWR VGND VPWR VGND sky130_ef_sc_hd__decap_12
X_11871_ net650 net387 VGND VGND VPWR VPWR _05606_ sky130_fd_sc_hd__and2b_1
XFILLER_33_809 VPWR VGND VPWR VGND sky130_ef_sc_hd__decap_12
XTAP_TAPCELL_ROW_123_2298 VGND VPWR sky130_fd_sc_hd__tapvpwrvgnd_1
X_13610_ clknet_leaf_49_clk _00620_ VGND VGND VPWR VPWR u_interface.fifo_data\[3\]\[25\]
+ sky130_fd_sc_hd__dfxtp_1
XFILLER_72_477 VPWR VGND VPWR VGND sky130_ef_sc_hd__decap_12
X_10822_ net189 _04566_ VGND VGND VPWR VPWR _04567_ sky130_fd_sc_hd__xnor2_1
XFILLER_26_861 VGND VGND VPWR VPWR sky130_fd_sc_hd__decap_6
X_13541_ clknet_leaf_68_clk _00551_ VGND VGND VPWR VPWR u_interface.fifo_data\[5\]\[20\]
+ sky130_fd_sc_hd__dfxtp_1
X_10753_ _04497_ _04498_ net652 net434 VGND VGND VPWR VPWR _04499_ sky130_fd_sc_hd__a2bb2o_1
XFILLER_25_393 VGND VGND VPWR VPWR sky130_fd_sc_hd__fill_1
X_13472_ clknet_leaf_64_clk _00482_ VGND VGND VPWR VPWR u_interface.u_gelu_fp32.u_q16_to_fp32.s3_norm_mag\[12\]
+ sky130_fd_sc_hd__dfxtp_1
X_10684_ net196 _04429_ VGND VGND VPWR VPWR _04431_ sky130_fd_sc_hd__xnor2_1
XFILLER_9_559 VGND VGND VPWR VPWR sky130_fd_sc_hd__fill_1
XFILLER_139_785 VGND VGND VPWR VPWR sky130_fd_sc_hd__fill_2
XFILLER_126_402 VGND VGND VPWR VPWR sky130_fd_sc_hd__decap_4
X_12423_ _06098_ _06100_ VGND VGND VPWR VPWR _06150_ sky130_fd_sc_hd__nand2_1
X_12354_ net718 net390 VGND VGND VPWR VPWR _06082_ sky130_fd_sc_hd__nand2_1
XFILLER_5_721 VGND VGND VPWR VPWR sky130_fd_sc_hd__decap_6
XFILLER_154_777 VGND VGND VPWR VPWR sky130_fd_sc_hd__decap_8
X_11305_ net449 net720 VGND VGND VPWR VPWR _05046_ sky130_fd_sc_hd__nand2_4
XFILLER_5_765 VPWR VGND VPWR VGND sky130_ef_sc_hd__decap_12
XFILLER_141_438 VGND VGND VPWR VPWR sky130_fd_sc_hd__decap_4
XFILLER_141_405 VGND VGND VPWR VPWR sky130_fd_sc_hd__decap_8
X_14024_ clknet_leaf_42_clk _00950_ VGND VGND VPWR VPWR u_interface.core_data_out\[10\]
+ sky130_fd_sc_hd__dfxtp_1
XFILLER_4_253 VPWR VGND VPWR VGND sky130_ef_sc_hd__decap_12
X_12285_ net202 _06013_ VGND VGND VPWR VPWR _06014_ sky130_fd_sc_hd__xnor2_1
XFILLER_141_449 VPWR VGND VPWR VGND sky130_ef_sc_hd__decap_12
X_11236_ _04975_ _04976_ VGND VGND VPWR VPWR _04978_ sky130_fd_sc_hd__nor2_1
XFILLER_121_140 VGND VGND VPWR VPWR sky130_fd_sc_hd__fill_1
X_11167_ _04552_ _04668_ _04790_ _04669_ VGND VGND VPWR VPWR _04910_ sky130_fd_sc_hd__or4b_1
XFILLER_68_728 VPWR VGND VPWR VGND sky130_ef_sc_hd__decap_12
XFILLER_68_717 VGND VGND VPWR VPWR sky130_fd_sc_hd__decap_8
XFILLER_95_558 VGND VGND VPWR VPWR sky130_fd_sc_hd__fill_2
X_10118_ net723 _03763_ _03867_ _03637_ VGND VGND VPWR VPWR _03869_ sky130_fd_sc_hd__a31o_2
XTAP_TAPCELL_ROW_143_2619 VGND VPWR sky130_fd_sc_hd__tapvpwrvgnd_1
XFILLER_110_869 VGND VGND VPWR VPWR sky130_fd_sc_hd__decap_3
X_11098_ _04726_ _04729_ VGND VGND VPWR VPWR _04841_ sky130_fd_sc_hd__nor2_1
X_10049_ _03680_ _03682_ _03799_ VGND VGND VPWR VPWR _03801_ sky130_fd_sc_hd__and3_1
XFILLER_35_113 VPWR VGND VPWR VGND sky130_ef_sc_hd__decap_12
XFILLER_36_625 VPWR VGND VPWR VGND sky130_ef_sc_hd__decap_12
XFILLER_63_433 VPWR VGND VPWR VGND sky130_ef_sc_hd__decap_12
X_13808_ clknet_leaf_88_clk _00818_ VGND VGND VPWR VPWR u_interface.u_gelu_fp32.u_synth_top.s3_mult\[26\]
+ sky130_fd_sc_hd__dfxtp_1
X_13739_ clknet_leaf_57_clk _00749_ VGND VGND VPWR VPWR u_interface.u_gelu_fp32.u_q16_to_fp32.s1_mag\[5\]
+ sky130_fd_sc_hd__dfxtp_1
XTAP_TAPCELL_ROW_63_1345 VGND VPWR sky130_fd_sc_hd__tapvpwrvgnd_1
XFILLER_91_3 VPWR VGND VPWR VGND sky130_ef_sc_hd__decap_12
X_07260_ net1458 net575 net252 VGND VGND VPWR VPWR _00292_ sky130_fd_sc_hd__mux2_1
XTAP_TAPCELL_ROW_14_561 VGND VPWR sky130_fd_sc_hd__tapvpwrvgnd_1
XFILLER_118_914 VGND VGND VPWR VPWR sky130_fd_sc_hd__decap_3
X_07191_ net1435 net561 net261 VGND VGND VPWR VPWR _00231_ sky130_fd_sc_hd__mux2_1
Xgelu_top_844 VGND VGND VPWR VPWR gelu_top_844/HI s_axil_rdata[12] sky130_fd_sc_hd__conb_1
Xgelu_top_833 VGND VGND VPWR VPWR gelu_top_833/HI s_axil_rdata[1] sky130_fd_sc_hd__conb_1
XFILLER_8_581 VGND VGND VPWR VPWR sky130_fd_sc_hd__decap_6
XFILLER_144_243 VGND VGND VPWR VPWR sky130_fd_sc_hd__decap_8
Xgelu_top_855 VGND VGND VPWR VPWR gelu_top_855/HI s_axil_rdata[23] sky130_fd_sc_hd__conb_1
XFILLER_144_276 VPWR VGND VPWR VGND sky130_ef_sc_hd__decap_12
XFILLER_117_479 VGND VGND VPWR VPWR sky130_fd_sc_hd__fill_1
X_09901_ net510 _03533_ VGND VGND VPWR VPWR _03654_ sky130_fd_sc_hd__and2_2
Xfanout505 net509 VGND VGND VPWR VPWR net505 sky130_fd_sc_hd__clkbuf_2
Xfanout516 u_interface.u_gelu_fp32.u_synth_top.s2_dx\[1\] VGND VGND VPWR VPWR net516
+ sky130_fd_sc_hd__clkbuf_2
XFILLER_113_652 VGND VGND VPWR VPWR sky130_fd_sc_hd__fill_1
Xfanout538 u_interface.u_gelu_fp32.s1_data\[15\] VGND VGND VPWR VPWR net538 sky130_fd_sc_hd__dlymetal6s2s_1
XFILLER_99_897 VGND VGND VPWR VPWR sky130_fd_sc_hd__decap_6
X_09832_ net466 net648 net656 net471 VGND VGND VPWR VPWR _03586_ sky130_fd_sc_hd__a22o_1
Xfanout527 u_interface.u_gelu_fp32.u_synth_top.s3_b\[18\] VGND VGND VPWR VPWR net527
+ sky130_fd_sc_hd__dlymetal6s2s_1
Xfanout549 u_interface.u_gelu_fp32.u_fp32_to_q16.s2_shift\[3\] VGND VGND VPWR VPWR
+ net549 sky130_fd_sc_hd__buf_2
XFILLER_140_482 VPWR VGND VPWR VGND sky130_ef_sc_hd__decap_12
XFILLER_112_173 VGND VGND VPWR VPWR sky130_fd_sc_hd__fill_2
X_09763_ _03516_ _03517_ VGND VGND VPWR VPWR _03518_ sky130_fd_sc_hd__nand2b_1
XFILLER_58_227 VGND VGND VPWR VPWR sky130_fd_sc_hd__fill_2
X_06975_ _01100_ u_interface.fifo_wr_ptr\[0\] net827 u_interface.fifo_wr_ptr\[1\]
+ VGND VGND VPWR VPWR _01501_ sky130_fd_sc_hd__or4b_4
X_08714_ net598 net472 VGND VGND VPWR VPWR _02473_ sky130_fd_sc_hd__nand2_1
XFILLER_86_569 VGND VGND VPWR VPWR sky130_fd_sc_hd__fill_2
XFILLER_74_709 VPWR VGND VPWR VGND sky130_ef_sc_hd__decap_12
X_09694_ net454 net612 net620 net458 VGND VGND VPWR VPWR _03449_ sky130_fd_sc_hd__a22o_1
XFILLER_39_474 VGND VGND VPWR VPWR sky130_fd_sc_hd__fill_2
XFILLER_54_433 VGND VGND VPWR VPWR sky130_fd_sc_hd__decap_8
X_08645_ net156 _02413_ VGND VGND VPWR VPWR _02414_ sky130_fd_sc_hd__nand2_1
XFILLER_15_809 VPWR VGND VPWR VGND sky130_ef_sc_hd__decap_12
X_08576_ _02209_ _02210_ _02215_ VGND VGND VPWR VPWR _02365_ sky130_fd_sc_hd__a21o_1
XFILLER_81_252 VGND VGND VPWR VPWR sky130_fd_sc_hd__decap_8
XFILLER_54_477 VPWR VGND VPWR VGND sky130_ef_sc_hd__decap_12
XFILLER_41_105 VGND VGND VPWR VPWR sky130_fd_sc_hd__decap_6
X_07527_ _01655_ _01654_ net549 VGND VGND VPWR VPWR _01656_ sky130_fd_sc_hd__mux2_1
XFILLER_81_296 VGND VGND VPWR VPWR sky130_fd_sc_hd__fill_1
XFILLER_54_499 VPWR VGND VPWR VGND sky130_ef_sc_hd__decap_12
XFILLER_25_69 VPWR VGND VPWR VGND sky130_ef_sc_hd__decap_12
XFILLER_23_853 VPWR VGND VPWR VGND sky130_ef_sc_hd__decap_12
XFILLER_34_190 VGND VGND VPWR VPWR sky130_fd_sc_hd__decap_6
X_07458_ _01591_ _01592_ net555 VGND VGND VPWR VPWR _01593_ sky130_fd_sc_hd__mux2_1
XFILLER_23_897 VPWR VGND VPWR VGND sky130_ef_sc_hd__decap_12
XTAP_TAPCELL_ROW_33_870 VGND VPWR sky130_fd_sc_hd__tapvpwrvgnd_1
X_07389_ net977 net340 net239 VGND VGND VPWR VPWR _00419_ sky130_fd_sc_hd__mux2_1
XFILLER_10_569 VPWR VGND VPWR VGND sky130_ef_sc_hd__decap_12
X_09128_ net629 net512 VGND VGND VPWR VPWR _02887_ sky130_fd_sc_hd__nand2_1
XTAP_TAPCELL_ROW_94_1839 VGND VPWR sky130_fd_sc_hd__tapvpwrvgnd_1
X_09059_ _02810_ _02811_ _02593_ _02595_ VGND VGND VPWR VPWR _02818_ sky130_fd_sc_hd__o211ai_1
XFILLER_2_713 VPWR VGND VPWR VGND sky130_ef_sc_hd__decap_12
Xhold581 u_interface.fifo_data\[11\]\[19\] VGND VGND VPWR VPWR net1446 sky130_fd_sc_hd__dlygate4sd3_1
XFILLER_123_449 VPWR VGND VPWR VGND sky130_ef_sc_hd__decap_12
XFILLER_1_223 VGND VGND VPWR VPWR sky130_fd_sc_hd__fill_1
XFILLER_2_757 VPWR VGND VPWR VGND sky130_ef_sc_hd__decap_12
X_12070_ _05730_ _05733_ net178 VGND VGND VPWR VPWR _05802_ sky130_fd_sc_hd__o21a_1
Xhold570 u_interface.fifo_data\[12\]\[31\] VGND VGND VPWR VPWR net1435 sky130_fd_sc_hd__dlygate4sd3_1
Xhold592 u_interface.fifo_tuser\[15\] VGND VGND VPWR VPWR net1457 sky130_fd_sc_hd__dlygate4sd3_1
XFILLER_103_151 VPWR VGND VPWR VGND sky130_ef_sc_hd__decap_12
XFILLER_89_374 VPWR VGND VPWR VGND sky130_ef_sc_hd__decap_12
X_11021_ _04637_ _04764_ VGND VGND VPWR VPWR _04765_ sky130_fd_sc_hd__nor2_1
XFILLER_2_29 VPWR VGND VPWR VGND sky130_ef_sc_hd__decap_12
X_12972_ _06481_ _06484_ _06482_ VGND VGND VPWR VPWR _06490_ sky130_fd_sc_hd__o21a_1
XTAP_TAPCELL_ROW_125_2338 VGND VPWR sky130_fd_sc_hd__tapvpwrvgnd_1
XFILLER_100_880 VGND VGND VPWR VPWR sky130_fd_sc_hd__fill_2
XFILLER_92_528 VGND VGND VPWR VPWR sky130_fd_sc_hd__fill_1
XFILLER_18_625 VPWR VGND VPWR VGND sky130_ef_sc_hd__decap_12
XFILLER_66_98 VPWR VGND VPWR VGND sky130_ef_sc_hd__decap_12
XFILLER_57_293 VPWR VGND VPWR VGND sky130_ef_sc_hd__decap_12
XFILLER_17_113 VPWR VGND VPWR VGND sky130_ef_sc_hd__decap_12
XFILLER_18_669 VPWR VGND VPWR VGND sky130_ef_sc_hd__decap_12
X_11923_ net201 _05655_ VGND VGND VPWR VPWR _05657_ sky130_fd_sc_hd__xnor2_1
XFILLER_122_82 VGND VGND VPWR VPWR sky130_fd_sc_hd__fill_2
XFILLER_60_414 VGND VGND VPWR VPWR sky130_fd_sc_hd__decap_6
X_11854_ net710 net415 net410 net702 VGND VGND VPWR VPWR _05589_ sky130_fd_sc_hd__a22oi_1
XFILLER_33_617 VPWR VGND VPWR VGND sky130_ef_sc_hd__decap_12
X_10805_ net197 _04550_ VGND VGND VPWR VPWR _04551_ sky130_fd_sc_hd__xnor2_1
XTAP_TAPCELL_ROW_103_1979 VGND VPWR sky130_fd_sc_hd__tapvpwrvgnd_1
XFILLER_82_97 VPWR VGND VPWR VGND sky130_ef_sc_hd__decap_12
XTAP_TAPCELL_ROW_45_1053 VGND VPWR sky130_fd_sc_hd__tapvpwrvgnd_1
X_11785_ _05511_ _05518_ _05519_ VGND VGND VPWR VPWR _05521_ sky130_fd_sc_hd__and3_1
X_10736_ _04481_ VGND VGND VPWR VPWR _04482_ sky130_fd_sc_hd__inv_2
X_13524_ clknet_leaf_73_clk _00534_ VGND VGND VPWR VPWR u_interface.fifo_data\[5\]\[3\]
+ sky130_fd_sc_hd__dfxtp_1
XTAP_TAPCELL_ROW_31_829 VGND VPWR sky130_fd_sc_hd__tapvpwrvgnd_1
X_13455_ clknet_leaf_13_clk _00465_ VGND VGND VPWR VPWR u_interface.u_gelu_fp32.u_fp32_to_q16.s3_mag\[26\]
+ sky130_fd_sc_hd__dfxtp_1
X_10667_ _04411_ _04412_ _04292_ _04295_ VGND VGND VPWR VPWR _04414_ sky130_fd_sc_hd__o211ai_1
XFILLER_9_356 VPWR VGND VPWR VGND sky130_ef_sc_hd__decap_12
X_12406_ net198 _06132_ VGND VGND VPWR VPWR _06133_ sky130_fd_sc_hd__and2_1
XFILLER_154_530 VGND VGND VPWR VPWR sky130_fd_sc_hd__fill_2
XTAP_TAPCELL_ROW_153_2781 VGND VPWR sky130_fd_sc_hd__tapvpwrvgnd_1
X_10598_ net464 net708 net715 net468 VGND VGND VPWR VPWR _04345_ sky130_fd_sc_hd__a22o_1
X_13386_ clknet_leaf_76_clk _00396_ VGND VGND VPWR VPWR u_interface.fifo_data\[7\]\[31\]
+ sky130_fd_sc_hd__dfxtp_1
Xoutput119 net119 VGND VGND VPWR VPWR m_axis_tdata[19] sky130_fd_sc_hd__buf_2
XFILLER_99_116 VGND VGND VPWR VPWR sky130_fd_sc_hd__decap_4
XFILLER_5_573 VPWR VGND VPWR VGND sky130_ef_sc_hd__decap_12
X_12337_ _06060_ _06063_ _06065_ VGND VGND VPWR VPWR _00838_ sky130_fd_sc_hd__a21oi_1
X_12268_ _05931_ _05936_ _05930_ VGND VGND VPWR VPWR _05998_ sky130_fd_sc_hd__o21ai_1
XFILLER_141_279 VGND VGND VPWR VPWR sky130_fd_sc_hd__fill_1
XFILLER_122_460 VGND VGND VPWR VPWR sky130_fd_sc_hd__decap_6
X_14007_ clknet_leaf_55_clk net1580 VGND VGND VPWR VPWR u_interface.u_gelu_fp32.u_q16_to_fp32.s3_exp\[3\]
+ sky130_fd_sc_hd__dfxtp_1
X_11219_ _04951_ _04960_ VGND VGND VPWR VPWR _04961_ sky130_fd_sc_hd__xor2_1
XFILLER_110_633 VGND VGND VPWR VPWR sky130_fd_sc_hd__fill_2
X_12199_ _05928_ _05929_ VGND VGND VPWR VPWR _05930_ sky130_fd_sc_hd__or2_1
XFILLER_96_867 VGND VGND VPWR VPWR sky130_fd_sc_hd__fill_1
XFILLER_37_901 VGND VGND VPWR VPWR sky130_fd_sc_hd__fill_1
X_06760_ net323 _01316_ net727 VGND VGND VPWR VPWR _01319_ sky130_fd_sc_hd__o21a_1
XFILLER_95_388 VGND VGND VPWR VPWR sky130_fd_sc_hd__decap_4
XFILLER_36_400 VPWR VGND VPWR VGND sky130_ef_sc_hd__decap_12
X_06691_ _01257_ _01258_ net733 VGND VGND VPWR VPWR _01259_ sky130_fd_sc_hd__mux2_1
X_08430_ _02206_ _02219_ _02205_ VGND VGND VPWR VPWR _02221_ sky130_fd_sc_hd__a21bo_1
XFILLER_91_561 VGND VGND VPWR VPWR sky130_fd_sc_hd__decap_6
XFILLER_51_403 VGND VGND VPWR VPWR sky130_fd_sc_hd__decap_4
XTAP_TAPCELL_ROW_19_642 VGND VPWR sky130_fd_sc_hd__tapvpwrvgnd_1
XFILLER_24_628 VPWR VGND VPWR VGND sky130_ef_sc_hd__decap_12
XFILLER_36_466 VGND VGND VPWR VPWR sky130_fd_sc_hd__decap_8
XFILLER_36_477 VPWR VGND VPWR VGND sky130_ef_sc_hd__decap_12
XFILLER_51_414 VGND VGND VPWR VPWR sky130_fd_sc_hd__decap_8
XFILLER_23_105 VGND VGND VPWR VPWR sky130_fd_sc_hd__decap_6
X_08361_ net528 u_interface.u_gelu_fp32.s2_data\[30\] _02152_ net797 VGND VGND VPWR
+ VPWR _02154_ sky130_fd_sc_hd__a31o_1
X_08292_ net532 _02101_ net1654 VGND VGND VPWR VPWR _02102_ sky130_fd_sc_hd__a21oi_1
X_07312_ net1172 net366 net253 VGND VGND VPWR VPWR _00342_ sky130_fd_sc_hd__mux2_1
XFILLER_149_357 VGND VGND VPWR VPWR sky130_fd_sc_hd__decap_8
XFILLER_137_519 VGND VGND VPWR VPWR sky130_fd_sc_hd__fill_1
X_07243_ net1070 net370 net251 VGND VGND VPWR VPWR _00275_ sky130_fd_sc_hd__mux2_1
XFILLER_20_867 VGND VGND VPWR VPWR sky130_fd_sc_hd__fill_1
X_07174_ net1293 net356 net263 VGND VGND VPWR VPWR _00214_ sky130_fd_sc_hd__mux2_1
XFILLER_117_232 VGND VGND VPWR VPWR sky130_fd_sc_hd__fill_1
XFILLER_11_27 VPWR VGND VPWR VGND sky130_ef_sc_hd__decap_12
XTAP_TAPCELL_ROW_76_1558 VGND VPWR sky130_fd_sc_hd__tapvpwrvgnd_1
XTAP_TAPCELL_ROW_76_1547 VGND VPWR sky130_fd_sc_hd__tapvpwrvgnd_1
XFILLER_105_449 VGND VGND VPWR VPWR sky130_fd_sc_hd__fill_1
XFILLER_105_438 VGND VGND VPWR VPWR sky130_fd_sc_hd__fill_1
Xfanout302 net303 VGND VGND VPWR VPWR net302 sky130_fd_sc_hd__buf_2
Xfanout313 net314 VGND VGND VPWR VPWR net313 sky130_fd_sc_hd__clkbuf_2
XFILLER_99_661 VGND VGND VPWR VPWR sky130_fd_sc_hd__fill_1
Xfanout324 u_interface.meta_tlast_pipe\[11\] VGND VGND VPWR VPWR net324 sky130_fd_sc_hd__clkbuf_2
Xfanout346 u_interface.core_data_out\[19\] VGND VGND VPWR VPWR net346 sky130_fd_sc_hd__clkbuf_2
Xfanout357 u_interface.core_data_out\[14\] VGND VGND VPWR VPWR net357 sky130_fd_sc_hd__buf_1
XFILLER_100_110 VGND VGND VPWR VPWR sky130_fd_sc_hd__decap_3
X_09815_ net612 net450 VGND VGND VPWR VPWR _03569_ sky130_fd_sc_hd__nand2_1
Xfanout335 u_interface.u_gelu_fp32.u_q16_to_fp32.s2_clz\[1\] VGND VGND VPWR VPWR net335
+ sky130_fd_sc_hd__buf_2
XFILLER_87_878 VGND VGND VPWR VPWR sky130_fd_sc_hd__fill_1
XFILLER_87_867 VGND VGND VPWR VPWR sky130_fd_sc_hd__fill_2
Xfanout379 u_interface.core_data_out\[3\] VGND VGND VPWR VPWR net379 sky130_fd_sc_hd__buf_1
Xfanout368 u_interface.core_data_out\[8\] VGND VGND VPWR VPWR net368 sky130_fd_sc_hd__clkbuf_2
X_09746_ _03500_ VGND VGND VPWR VPWR _03501_ sky130_fd_sc_hd__inv_2
X_06958_ _01486_ _01487_ VGND VGND VPWR VPWR _00028_ sky130_fd_sc_hd__nor2_1
XTAP_TAPCELL_ROW_107_2046 VGND VPWR sky130_fd_sc_hd__tapvpwrvgnd_1
X_09677_ net475 net662 net672 net479 VGND VGND VPWR VPWR _03432_ sky130_fd_sc_hd__a22o_1
XTAP_TAPCELL_ROW_38_940 VGND VPWR sky130_fd_sc_hd__tapvpwrvgnd_1
X_06889_ _01110_ _01431_ VGND VGND VPWR VPWR _01432_ sky130_fd_sc_hd__nand2_1
X_08628_ _02173_ _02241_ _02251_ VGND VGND VPWR VPWR _02401_ sky130_fd_sc_hd__o21a_1
XPHY_EDGE_ROW_6_Left_162 VGND VGND VPWR VPWR sky130_fd_sc_hd__decap_3
XFILLER_15_617 VPWR VGND VPWR VGND sky130_ef_sc_hd__decap_12
XTAP_TAPCELL_ROW_38_951 VGND VPWR sky130_fd_sc_hd__tapvpwrvgnd_1
XFILLER_82_583 VGND VGND VPWR VPWR sky130_fd_sc_hd__decap_4
XFILLER_55_797 VGND VGND VPWR VPWR sky130_fd_sc_hd__decap_4
XFILLER_54_285 VGND VGND VPWR VPWR sky130_fd_sc_hd__decap_3
XTAP_TAPCELL_ROW_120_2257 VGND VPWR sky130_fd_sc_hd__tapvpwrvgnd_1
X_08559_ _02348_ _02349_ VGND VGND VPWR VPWR _02350_ sky130_fd_sc_hd__nor2_1
X_11570_ _05114_ _05115_ _05122_ _05211_ VGND VGND VPWR VPWR _05309_ sky130_fd_sc_hd__o22a_1
X_10521_ _04159_ _04161_ _04160_ VGND VGND VPWR VPWR _04269_ sky130_fd_sc_hd__a21bo_1
XFILLER_50_491 VPWR VGND VPWR VGND sky130_ef_sc_hd__decap_12
XFILLER_109_733 VGND VGND VPWR VPWR sky130_fd_sc_hd__fill_1
X_13240_ clknet_leaf_50_clk _00250_ VGND VGND VPWR VPWR u_interface.fifo_data\[11\]\[18\]
+ sky130_fd_sc_hd__dfxtp_1
XFILLER_11_889 VGND VGND VPWR VPWR sky130_fd_sc_hd__decap_6
XFILLER_108_221 VGND VGND VPWR VPWR sky130_fd_sc_hd__fill_2
X_10452_ _04185_ _04186_ _04188_ _04189_ net195 VGND VGND VPWR VPWR _04200_ sky130_fd_sc_hd__a32o_1
XFILLER_6_348 VGND VGND VPWR VPWR sky130_fd_sc_hd__fill_1
XFILLER_6_359 VGND VGND VPWR VPWR sky130_fd_sc_hd__fill_2
X_13171_ clknet_leaf_34_clk _00181_ VGND VGND VPWR VPWR u_interface.fifo_data\[9\]\[13\]
+ sky130_fd_sc_hd__dfxtp_1
X_10383_ _04123_ _04129_ _04130_ VGND VGND VPWR VPWR _04132_ sky130_fd_sc_hd__nand3_1
X_12122_ _05728_ _05780_ _05779_ VGND VGND VPWR VPWR _05854_ sky130_fd_sc_hd__o21ai_1
X_12053_ _05650_ _05713_ _05712_ VGND VGND VPWR VPWR _05786_ sky130_fd_sc_hd__a21o_1
XFILLER_104_471 VGND VGND VPWR VPWR sky130_fd_sc_hd__decap_4
X_11004_ _04742_ _04747_ VGND VGND VPWR VPWR _04748_ sky130_fd_sc_hd__nand2b_1
XFILLER_2_587 VGND VGND VPWR VPWR sky130_fd_sc_hd__fill_1
XFILLER_77_75 VGND VGND VPWR VPWR sky130_fd_sc_hd__fill_1
XFILLER_77_377 VPWR VGND VPWR VGND sky130_ef_sc_hd__decap_12
XFILLER_65_528 VGND VGND VPWR VPWR sky130_fd_sc_hd__fill_1
X_12955_ u_interface.fifo_count\[1\] _06468_ _06475_ net790 VGND VGND VPWR VPWR _01060_
+ sky130_fd_sc_hd__o211a_1
XFILLER_92_336 VGND VGND VPWR VPWR sky130_fd_sc_hd__fill_1
XFILLER_46_742 VGND VGND VPWR VPWR sky130_fd_sc_hd__decap_3
XFILLER_18_433 VPWR VGND VPWR VGND sky130_ef_sc_hd__decap_12
XFILLER_93_63 VGND VGND VPWR VPWR sky130_fd_sc_hd__fill_1
X_11906_ _05638_ _05639_ VGND VGND VPWR VPWR _05641_ sky130_fd_sc_hd__xnor2_1
X_12886_ net785 net942 VGND VGND VPWR VPWR _01028_ sky130_fd_sc_hd__and2_1
XFILLER_33_414 VPWR VGND VPWR VGND sky130_ef_sc_hd__decap_12
XFILLER_60_244 VGND VGND VPWR VPWR sky130_fd_sc_hd__fill_1
X_11837_ _05408_ _05571_ VGND VGND VPWR VPWR _05572_ sky130_fd_sc_hd__nor2_1
XTAP_TAPCELL_ROW_155_2810 VGND VPWR sky130_fd_sc_hd__tapvpwrvgnd_1
X_11768_ net435 _05417_ _05418_ _05333_ VGND VGND VPWR VPWR _05504_ sky130_fd_sc_hd__o22a_1
XTAP_TAPCELL_ROW_155_2832 VGND VPWR sky130_fd_sc_hd__tapvpwrvgnd_1
XTAP_TAPCELL_ROW_155_2821 VGND VPWR sky130_fd_sc_hd__tapvpwrvgnd_1
XFILLER_119_519 VGND VGND VPWR VPWR sky130_fd_sc_hd__fill_1
X_13507_ clknet_leaf_3_clk _00517_ VGND VGND VPWR VPWR u_interface.u_gelu_fp32.u_synth_top.s2_m\[4\]
+ sky130_fd_sc_hd__dfxtp_1
X_10719_ _04343_ _04464_ VGND VGND VPWR VPWR _04465_ sky130_fd_sc_hd__xor2_1
XFILLER_13_193 VPWR VGND VPWR VGND sky130_ef_sc_hd__decap_12
X_11699_ _05434_ _05435_ _05428_ VGND VGND VPWR VPWR _05436_ sky130_fd_sc_hd__a21oi_1
XFILLER_127_541 VPWR VGND VPWR VGND sky130_ef_sc_hd__decap_12
X_13438_ clknet_leaf_10_clk _00448_ VGND VGND VPWR VPWR u_interface.u_gelu_fp32.u_fp32_to_q16.s3_mag\[9\]
+ sky130_fd_sc_hd__dfxtp_1
XFILLER_155_894 VGND VGND VPWR VPWR sky130_fd_sc_hd__fill_2
X_13369_ clknet_leaf_43_clk _00379_ VGND VGND VPWR VPWR u_interface.fifo_data\[7\]\[14\]
+ sky130_fd_sc_hd__dfxtp_1
XFILLER_54_3 VPWR VGND VPWR VGND sky130_ef_sc_hd__decap_12
XFILLER_142_533 VGND VGND VPWR VPWR sky130_fd_sc_hd__decap_4
XTAP_TAPCELL_ROW_58_1266 VGND VPWR sky130_fd_sc_hd__tapvpwrvgnd_1
XFILLER_6_893 VPWR VGND VPWR VGND sky130_ef_sc_hd__decap_12
X_07930_ u_interface.u_gelu_fp32.u_fp32_to_q16.s1_mant\[2\] _01816_ _01820_ _01823_
+ VGND VGND VPWR VPWR _01824_ sky130_fd_sc_hd__or4_2
XFILLER_102_419 VGND VGND VPWR VPWR sky130_fd_sc_hd__fill_1
XFILLER_102_408 VGND VGND VPWR VPWR sky130_fd_sc_hd__decap_3
XFILLER_69_801 VGND VGND VPWR VPWR sky130_fd_sc_hd__decap_8
XFILLER_95_130 VPWR VGND VPWR VGND sky130_ef_sc_hd__decap_12
X_07861_ net569 net1471 net283 VGND VGND VPWR VPWR _00622_ sky130_fd_sc_hd__mux2_1
XTAP_TAPCELL_ROW_71_1477 VGND VPWR sky130_fd_sc_hd__tapvpwrvgnd_1
XTAP_TAPCELL_ROW_71_1466 VGND VPWR sky130_fd_sc_hd__tapvpwrvgnd_1
XFILLER_29_709 VPWR VGND VPWR VGND sky130_ef_sc_hd__decap_12
X_06812_ _01360_ _01361_ _01364_ net319 VGND VGND VPWR VPWR net123 sky130_fd_sc_hd__a22o_1
X_07792_ net990 net340 net235 VGND VGND VPWR VPWR _00553_ sky130_fd_sc_hd__mux2_1
X_09600_ _03278_ _03354_ VGND VGND VPWR VPWR _03356_ sky130_fd_sc_hd__xnor2_1
XFILLER_84_848 VGND VGND VPWR VPWR sky130_fd_sc_hd__decap_4
X_06743_ net322 _01303_ VGND VGND VPWR VPWR _01304_ sky130_fd_sc_hd__or2_1
X_09531_ net466 net471 net620 net631 VGND VGND VPWR VPWR _03288_ sky130_fd_sc_hd__nand4_1
XFILLER_95_196 VGND VGND VPWR VPWR sky130_fd_sc_hd__decap_3
X_09462_ _03218_ _03219_ _02762_ _02764_ VGND VGND VPWR VPWR _03220_ sky130_fd_sc_hd__o211a_1
X_06674_ u_interface.fifo_data\[4\]\[5\] u_interface.fifo_data\[5\]\[5\] u_interface.fifo_data\[6\]\[5\]
+ u_interface.fifo_data\[7\]\[5\] net757 net740 VGND VGND VPWR VPWR _01244_ sky130_fd_sc_hd__mux4_1
XFILLER_64_594 VGND VGND VPWR VPWR sky130_fd_sc_hd__fill_2
XFILLER_51_211 VPWR VGND VPWR VGND sky130_ef_sc_hd__decap_12
X_09393_ net462 net607 VGND VGND VPWR VPWR _03151_ sky130_fd_sc_hd__nand2_1
X_08413_ _02202_ _02203_ VGND VGND VPWR VPWR _02204_ sky130_fd_sc_hd__nand2_1
XFILLER_24_469 VGND VGND VPWR VPWR sky130_fd_sc_hd__fill_2
XFILLER_51_277 VGND VGND VPWR VPWR sky130_fd_sc_hd__decap_3
X_08344_ net528 _02140_ net1665 VGND VGND VPWR VPWR _02141_ sky130_fd_sc_hd__a21oi_1
XFILLER_22_15 VPWR VGND VPWR VGND sky130_ef_sc_hd__decap_12
XFILLER_137_327 VGND VGND VPWR VPWR sky130_fd_sc_hd__decap_8
X_08275_ u_interface.u_gelu_fp32.s2_data\[8\] _02086_ VGND VGND VPWR VPWR _02089_
+ sky130_fd_sc_hd__or2_1
X_07226_ _01102_ _01527_ net828 VGND VGND VPWR VPWR _01529_ sky130_fd_sc_hd__a21o_1
X_07157_ net1182 net565 net219 VGND VGND VPWR VPWR _00197_ sky130_fd_sc_hd__mux2_1
XFILLER_133_533 VPWR VGND VPWR VGND sky130_ef_sc_hd__decap_12
XFILLER_3_329 VGND VGND VPWR VPWR sky130_fd_sc_hd__decap_6
X_07088_ net1053 net370 net227 VGND VGND VPWR VPWR _00128_ sky130_fd_sc_hd__mux2_1
XFILLER_133_599 VPWR VGND VPWR VGND sky130_ef_sc_hd__decap_12
XFILLER_120_205 VGND VGND VPWR VPWR sky130_fd_sc_hd__fill_1
XFILLER_105_279 VGND VGND VPWR VPWR sky130_fd_sc_hd__fill_1
Xfanout154 net155 VGND VGND VPWR VPWR net154 sky130_fd_sc_hd__buf_2
Xfanout165 _06274_ VGND VGND VPWR VPWR net165 sky130_fd_sc_hd__buf_2
XFILLER_101_474 VGND VGND VPWR VPWR sky130_fd_sc_hd__fill_1
XFILLER_101_452 VGND VGND VPWR VPWR sky130_fd_sc_hd__decap_6
XFILLER_19_208 VGND VGND VPWR VPWR sky130_fd_sc_hd__fill_2
Xfanout198 net199 VGND VGND VPWR VPWR net198 sky130_fd_sc_hd__clkbuf_2
X_09729_ _03384_ _03387_ VGND VGND VPWR VPWR _03484_ sky130_fd_sc_hd__nand2_1
XFILLER_74_369 VGND VGND VPWR VPWR sky130_fd_sc_hd__fill_1
XTAP_TAPCELL_ROW_2_362 VGND VPWR sky130_fd_sc_hd__tapvpwrvgnd_1
XTAP_TAPCELL_ROW_2_373 VGND VPWR sky130_fd_sc_hd__tapvpwrvgnd_1
X_12740_ _06388_ _06374_ net328 VGND VGND VPWR VPWR _06389_ sky130_fd_sc_hd__mux2_1
XFILLER_27_263 VGND VGND VPWR VPWR sky130_fd_sc_hd__decap_4
XFILLER_42_200 VGND VGND VPWR VPWR sky130_fd_sc_hd__decap_6
XFILLER_63_55 VGND VGND VPWR VPWR sky130_fd_sc_hd__fill_1
X_12671_ u_interface.u_gelu_fp32.u_q16_to_fp32.s1_mag\[26\] net1722 net796 VGND VGND
+ VPWR VPWR _00907_ sky130_fd_sc_hd__mux2_1
XFILLER_15_447 VGND VGND VPWR VPWR sky130_fd_sc_hd__fill_1
XFILLER_42_244 VGND VGND VPWR VPWR sky130_fd_sc_hd__decap_8
X_11622_ net658 net402 net399 net650 VGND VGND VPWR VPWR _05360_ sky130_fd_sc_hd__a22oi_1
XTAP_TAPCELL_ROW_42_1001 VGND VPWR sky130_fd_sc_hd__tapvpwrvgnd_1
XTAP_TAPCELL_ROW_100_1938 VGND VPWR sky130_fd_sc_hd__tapvpwrvgnd_1
XTAP_TAPCELL_ROW_42_1012 VGND VPWR sky130_fd_sc_hd__tapvpwrvgnd_1
XFILLER_155_113 VGND VGND VPWR VPWR sky130_fd_sc_hd__fill_2
XFILLER_11_653 VPWR VGND VPWR VGND sky130_ef_sc_hd__decap_12
XFILLER_10_141 VPWR VGND VPWR VGND sky130_ef_sc_hd__decap_12
X_11553_ _05235_ _05291_ VGND VGND VPWR VPWR _05292_ sky130_fd_sc_hd__xnor2_1
XFILLER_155_146 VGND VGND VPWR VPWR sky130_fd_sc_hd__decap_4
X_10504_ _04250_ _04251_ _04238_ VGND VGND VPWR VPWR _04252_ sky130_fd_sc_hd__o21a_1
X_11484_ _05031_ _05132_ _05133_ VGND VGND VPWR VPWR _05223_ sky130_fd_sc_hd__a21o_1
XFILLER_11_697 VPWR VGND VPWR VGND sky130_ef_sc_hd__decap_12
XFILLER_10_185 VGND VGND VPWR VPWR sky130_fd_sc_hd__decap_3
XTAP_TAPCELL_ROW_21_670 VGND VPWR sky130_fd_sc_hd__tapvpwrvgnd_1
XTAP_TAPCELL_ROW_150_2740 VGND VPWR sky130_fd_sc_hd__tapvpwrvgnd_1
XTAP_TAPCELL_ROW_133_2459 VGND VPWR sky130_fd_sc_hd__tapvpwrvgnd_1
X_13223_ clknet_leaf_54_clk _00233_ VGND VGND VPWR VPWR u_interface.fifo_data\[11\]\[1\]
+ sky130_fd_sc_hd__dfxtp_1
X_10435_ _04066_ _04068_ _04181_ net171 VGND VGND VPWR VPWR _04184_ sky130_fd_sc_hd__a211oi_1
X_13154_ clknet_leaf_34_clk _00164_ VGND VGND VPWR VPWR u_interface.fifo_tlast\[3\]
+ sky130_fd_sc_hd__dfxtp_1
XFILLER_128_81 VGND VGND VPWR VPWR sky130_fd_sc_hd__decap_3
XFILLER_124_533 VGND VGND VPWR VPWR sky130_fd_sc_hd__decap_3
XFILLER_6_189 VGND VGND VPWR VPWR sky130_fd_sc_hd__decap_6
XFILLER_151_330 VGND VGND VPWR VPWR sky130_fd_sc_hd__decap_6
XFILLER_98_918 VGND VGND VPWR VPWR sky130_fd_sc_hd__decap_3
X_10366_ _04113_ _04114_ _04112_ VGND VGND VPWR VPWR _04115_ sky130_fd_sc_hd__a21o_1
XFILLER_3_841 VPWR VGND VPWR VGND sky130_ef_sc_hd__decap_12
X_12105_ _05827_ _05836_ VGND VGND VPWR VPWR _05837_ sky130_fd_sc_hd__xor2_1
X_10297_ _04043_ _04046_ VGND VGND VPWR VPWR _04047_ sky130_fd_sc_hd__xnor2_1
X_13085_ clknet_leaf_75_clk _00095_ VGND VGND VPWR VPWR u_interface.fifo_data\[15\]\[6\]
+ sky130_fd_sc_hd__dfxtp_1
X_12036_ _05750_ _05768_ VGND VGND VPWR VPWR _05769_ sky130_fd_sc_hd__xor2_1
XFILLER_120_783 VGND VGND VPWR VPWR sky130_fd_sc_hd__fill_2
XPHY_EDGE_ROW_69_Left_225 VGND VGND VPWR VPWR sky130_fd_sc_hd__decap_3
XTAP_TAPCELL_ROW_53_1185 VGND VPWR sky130_fd_sc_hd__tapvpwrvgnd_1
XFILLER_80_306 VGND VGND VPWR VPWR sky130_fd_sc_hd__fill_2
X_13987_ clknet_leaf_82_clk net914 VGND VGND VPWR VPWR u_interface.u_gelu_fp32.u_q16_to_fp32.s2_sign
+ sky130_fd_sc_hd__dfxtp_1
XFILLER_19_753 VPWR VGND VPWR VGND sky130_ef_sc_hd__decap_12
XFILLER_34_701 VPWR VGND VPWR VGND sky130_ef_sc_hd__decap_12
X_12938_ _06441_ _06461_ VGND VGND VPWR VPWR _06462_ sky130_fd_sc_hd__nand2_1
XFILLER_19_797 VPWR VGND VPWR VGND sky130_ef_sc_hd__decap_12
XFILLER_73_391 VGND VGND VPWR VPWR sky130_fd_sc_hd__fill_1
XTAP_TAPCELL_ROW_29_792 VGND VPWR sky130_fd_sc_hd__tapvpwrvgnd_1
X_12869_ net1609 u_interface.u_gelu_fp32.u_fp32_to_q16.s2_norm_mag\[24\] net818 VGND
+ VGND VPWR VPWR _01013_ sky130_fd_sc_hd__mux2_1
XFILLER_21_417 VGND VGND VPWR VPWR sky130_fd_sc_hd__decap_8
XFILLER_33_277 VGND VGND VPWR VPWR sky130_fd_sc_hd__decap_3
XFILLER_34_789 VPWR VGND VPWR VGND sky130_ef_sc_hd__decap_12
XFILLER_146_113 VGND VGND VPWR VPWR sky130_fd_sc_hd__decap_8
XPHY_EDGE_ROW_78_Left_234 VGND VGND VPWR VPWR sky130_fd_sc_hd__decap_3
XFILLER_147_647 VGND VGND VPWR VPWR sky130_fd_sc_hd__fill_2
X_08060_ net292 _01915_ VGND VGND VPWR VPWR _00711_ sky130_fd_sc_hd__nor2_1
X_07011_ _01101_ _01508_ VGND VGND VPWR VPWR _01523_ sky130_fd_sc_hd__nor2_1
XFILLER_127_393 VGND VGND VPWR VPWR sky130_fd_sc_hd__decap_6
XFILLER_108_29 VGND VGND VPWR VPWR sky130_fd_sc_hd__decap_8
XTAP_TAPCELL_ROW_73_1506 VGND VPWR sky130_fd_sc_hd__tapvpwrvgnd_1
XFILLER_115_577 VPWR VGND VPWR VGND sky130_ef_sc_hd__decap_12
XFILLER_142_363 VGND VGND VPWR VPWR sky130_fd_sc_hd__fill_1
X_08962_ net598 net485 _02719_ _02717_ VGND VGND VPWR VPWR _02721_ sky130_fd_sc_hd__a31o_1
XFILLER_88_439 VGND VGND VPWR VPWR sky130_fd_sc_hd__decap_6
X_07913_ u_interface.u_gelu_fp32.u_fp32_to_q16.s1_exp\[5\] u_interface.u_gelu_fp32.u_fp32_to_q16.s1_exp\[6\]
+ u_interface.u_gelu_fp32.u_fp32_to_q16.s1_exp\[4\] VGND VGND VPWR VPWR _01807_ sky130_fd_sc_hd__or3_1
XFILLER_130_569 VGND VGND VPWR VPWR sky130_fd_sc_hd__decap_4
X_08893_ _02641_ _02651_ VGND VGND VPWR VPWR _02652_ sky130_fd_sc_hd__xnor2_1
XPHY_EDGE_ROW_87_Left_243 VGND VGND VPWR VPWR sky130_fd_sc_hd__decap_3
X_07844_ net364 net1487 net284 VGND VGND VPWR VPWR _00605_ sky130_fd_sc_hd__mux2_1
XFILLER_68_141 VGND VGND VPWR VPWR sky130_fd_sc_hd__decap_4
XFILLER_56_303 VGND VGND VPWR VPWR sky130_fd_sc_hd__decap_4
XFILLER_83_122 VPWR VGND VPWR VGND sky130_ef_sc_hd__decap_12
XTAP_TAPCELL_ROW_104_2005 VGND VPWR sky130_fd_sc_hd__tapvpwrvgnd_1
X_07775_ net1229 net374 net234 VGND VGND VPWR VPWR _00536_ sky130_fd_sc_hd__mux2_1
XFILLER_17_15 VPWR VGND VPWR VGND sky130_ef_sc_hd__decap_12
XFILLER_37_561 VPWR VGND VPWR VGND sky130_ef_sc_hd__decap_12
X_09514_ _03269_ _03270_ VGND VGND VPWR VPWR _03271_ sky130_fd_sc_hd__nor2_1
X_06726_ net732 _01288_ VGND VGND VPWR VPWR _01289_ sky130_fd_sc_hd__or2_1
XFILLER_71_328 VGND VGND VPWR VPWR sky130_fd_sc_hd__decap_8
X_09445_ _02690_ _02692_ _03200_ _03201_ VGND VGND VPWR VPWR _03203_ sky130_fd_sc_hd__a211oi_1
XFILLER_52_531 VGND VGND VPWR VPWR sky130_fd_sc_hd__fill_1
X_06657_ u_interface.fifo_data\[0\]\[3\] u_interface.fifo_data\[1\]\[3\] u_interface.fifo_data\[2\]\[3\]
+ u_interface.fifo_data\[3\]\[3\] net757 net740 VGND VGND VPWR VPWR _01229_ sky130_fd_sc_hd__mux4_1
XTAP_TAPCELL_ROW_84_1679 VGND VPWR sky130_fd_sc_hd__tapvpwrvgnd_1
XFILLER_12_417 VGND VGND VPWR VPWR sky130_fd_sc_hd__decap_3
XFILLER_24_277 VGND VGND VPWR VPWR sky130_fd_sc_hd__decap_6
X_09376_ net585 net450 VGND VGND VPWR VPWR _03134_ sky130_fd_sc_hd__nand2_1
X_06588_ u_interface.u_gelu_fp32.s1_data\[16\] u_interface.u_gelu_fp32.s1_data\[17\]
+ _01173_ VGND VGND VPWR VPWR _01176_ sky130_fd_sc_hd__and3_1
XPHY_EDGE_ROW_96_Left_252 VGND VGND VPWR VPWR sky130_fd_sc_hd__decap_3
X_08327_ u_interface.u_gelu_fp32.s2_data\[21\] _02125_ VGND VGND VPWR VPWR _02128_
+ sky130_fd_sc_hd__or2_1
XFILLER_20_450 VPWR VGND VPWR VGND sky130_ef_sc_hd__decap_12
X_08258_ net533 _02076_ net1736 VGND VGND VPWR VPWR _02077_ sky130_fd_sc_hd__a21oi_1
XFILLER_20_494 VGND VGND VPWR VPWR sky130_fd_sc_hd__fill_1
XFILLER_153_617 VGND VGND VPWR VPWR sky130_fd_sc_hd__decap_8
X_07209_ net351 net1556 net259 VGND VGND VPWR VPWR _00249_ sky130_fd_sc_hd__mux2_1
XTAP_TAPCELL_ROW_115_2178 VGND VPWR sky130_fd_sc_hd__tapvpwrvgnd_1
X_08189_ net289 _02023_ VGND VGND VPWR VPWR _00732_ sky130_fd_sc_hd__nor2_1
X_10220_ _03969_ _03970_ VGND VGND VPWR VPWR _03971_ sky130_fd_sc_hd__nand2_1
XFILLER_106_566 VGND VGND VPWR VPWR sky130_fd_sc_hd__fill_1
XFILLER_106_544 VGND VGND VPWR VPWR sky130_fd_sc_hd__fill_1
XFILLER_3_137 VPWR VGND VPWR VGND sky130_ef_sc_hd__decap_12
XFILLER_134_897 VGND VGND VPWR VPWR sky130_fd_sc_hd__decap_3
XFILLER_121_536 VPWR VGND VPWR VGND sky130_ef_sc_hd__decap_12
X_10151_ _03899_ _03901_ VGND VGND VPWR VPWR _03902_ sky130_fd_sc_hd__nor2_1
XFILLER_0_811 VGND VGND VPWR VPWR sky130_fd_sc_hd__fill_1
XFILLER_94_409 VGND VGND VPWR VPWR sky130_fd_sc_hd__decap_8
X_10082_ _03830_ _03831_ _03832_ VGND VGND VPWR VPWR _03834_ sky130_fd_sc_hd__and3_1
XTAP_TAPCELL_ROW_7_454 VGND VPWR sky130_fd_sc_hd__tapvpwrvgnd_1
XTAP_TAPCELL_ROW_7_443 VGND VPWR sky130_fd_sc_hd__tapvpwrvgnd_1
X_13910_ clknet_leaf_3_clk net936 VGND VGND VPWR VPWR u_interface.u_gelu_fp32.u_synth_top.s1_x\[14\]
+ sky130_fd_sc_hd__dfxtp_1
XFILLER_58_66 VPWR VGND VPWR VGND sky130_ef_sc_hd__decap_12
XFILLER_0_877 VGND VGND VPWR VPWR sky130_fd_sc_hd__fill_1
XFILLER_0_888 VGND VGND VPWR VPWR sky130_fd_sc_hd__decap_4
XFILLER_62_306 VGND VGND VPWR VPWR sky130_fd_sc_hd__fill_2
XFILLER_16_701 VPWR VGND VPWR VGND sky130_ef_sc_hd__decap_12
X_13841_ clknet_leaf_78_clk _00851_ VGND VGND VPWR VPWR u_interface.u_gelu_fp32.u_synth_top.s3_mult\[60\]
+ sky130_fd_sc_hd__dfxtp_1
X_13772_ clknet_leaf_57_clk _00782_ VGND VGND VPWR VPWR u_interface.u_gelu_fp32.s2_data\[6\]
+ sky130_fd_sc_hd__dfxtp_1
X_10984_ net668 net434 _04726_ _04727_ VGND VGND VPWR VPWR _04728_ sky130_fd_sc_hd__o2bb2a_1
XFILLER_15_200 VGND VGND VPWR VPWR sky130_fd_sc_hd__fill_2
X_12723_ net803 u_interface.u_gelu_fp32.u_q16_to_fp32.s3_norm_mag\[25\] net280 _06347_
+ VGND VGND VPWR VPWR _06376_ sky130_fd_sc_hd__a22o_1
XFILLER_71_895 VGND VGND VPWR VPWR sky130_fd_sc_hd__fill_1
XTAP_TAPCELL_ROW_26_751 VGND VPWR sky130_fd_sc_hd__tapvpwrvgnd_1
XFILLER_90_64 VGND VGND VPWR VPWR sky130_fd_sc_hd__fill_2
X_12654_ net1684 u_interface.u_gelu_fp32.u_q16_to_fp32.s2_mag\[9\] net805 VGND VGND
+ VPWR VPWR _00890_ sky130_fd_sc_hd__mux2_1
XFILLER_43_597 VPWR VGND VPWR VGND sky130_ef_sc_hd__decap_12
X_12585_ net10 net13 net12 net16 VGND VGND VPWR VPWR _06289_ sky130_fd_sc_hd__or4_1
X_11605_ _05341_ _05342_ VGND VGND VPWR VPWR _05343_ sky130_fd_sc_hd__and2b_1
XFILLER_7_410 VGND VGND VPWR VPWR sky130_fd_sc_hd__decap_4
X_11536_ _05272_ _05273_ VGND VGND VPWR VPWR _05275_ sky130_fd_sc_hd__xnor2_1
X_13206_ clknet_leaf_36_clk _00216_ VGND VGND VPWR VPWR u_interface.fifo_data\[12\]\[16\]
+ sky130_fd_sc_hd__dfxtp_1
XFILLER_109_393 VGND VGND VPWR VPWR sky130_fd_sc_hd__fill_1
XFILLER_109_371 VPWR VGND VPWR VGND sky130_ef_sc_hd__decap_12
X_11467_ _05123_ _05206_ VGND VGND VPWR VPWR _05207_ sky130_fd_sc_hd__xnor2_1
X_10418_ _04165_ _04166_ _04158_ VGND VGND VPWR VPWR _04167_ sky130_fd_sc_hd__a21o_1
XTAP_TAPCELL_ROW_55_1214 VGND VPWR sky130_fd_sc_hd__tapvpwrvgnd_1
X_11398_ net205 _05137_ VGND VGND VPWR VPWR _05138_ sky130_fd_sc_hd__and2b_1
X_13137_ clknet_leaf_42_clk _00147_ VGND VGND VPWR VPWR u_interface.fifo_data\[2\]\[26\]
+ sky130_fd_sc_hd__dfxtp_1
XFILLER_125_897 VGND VGND VPWR VPWR sky130_fd_sc_hd__decap_4
XFILLER_124_363 VGND VGND VPWR VPWR sky130_fd_sc_hd__fill_1
XFILLER_97_225 VGND VGND VPWR VPWR sky130_fd_sc_hd__decap_3
X_10349_ _04096_ _04097_ _04086_ VGND VGND VPWR VPWR _04098_ sky130_fd_sc_hd__a21o_1
XFILLER_3_671 VGND VGND VPWR VPWR sky130_fd_sc_hd__fill_1
XFILLER_140_867 VGND VGND VPWR VPWR sky130_fd_sc_hd__fill_1
XFILLER_124_396 VGND VGND VPWR VPWR sky130_fd_sc_hd__fill_2
X_13068_ clknet_leaf_77_clk _00078_ VGND VGND VPWR VPWR u_interface.fifo_data\[14\]\[21\]
+ sky130_fd_sc_hd__dfxtp_1
X_12019_ net701 net401 net397 net692 VGND VGND VPWR VPWR _05752_ sky130_fd_sc_hd__a22oi_1
XFILLER_120_580 VGND VGND VPWR VPWR sky130_fd_sc_hd__decap_8
XFILLER_65_111 VGND VGND VPWR VPWR sky130_fd_sc_hd__fill_1
XFILLER_17_3 VPWR VGND VPWR VGND sky130_ef_sc_hd__decap_12
XFILLER_93_464 VGND VGND VPWR VPWR sky130_fd_sc_hd__decap_8
XFILLER_65_155 VPWR VGND VPWR VGND sky130_ef_sc_hd__decap_12
XFILLER_38_347 VGND VGND VPWR VPWR sky130_fd_sc_hd__fill_2
X_07560_ net544 _01638_ VGND VGND VPWR VPWR _01674_ sky130_fd_sc_hd__nor2_1
XFILLER_81_626 VGND VGND VPWR VPWR sky130_fd_sc_hd__decap_3
XFILLER_65_199 VPWR VGND VPWR VGND sky130_ef_sc_hd__decap_12
XFILLER_65_177 VGND VGND VPWR VPWR sky130_fd_sc_hd__fill_2
XFILLER_53_317 VGND VGND VPWR VPWR sky130_fd_sc_hd__decap_6
X_06511_ net395 VGND VGND VPWR VPWR _01111_ sky130_fd_sc_hd__inv_2
XFILLER_34_531 VGND VGND VPWR VPWR sky130_fd_sc_hd__fill_1
XFILLER_34_553 VGND VGND VPWR VPWR sky130_fd_sc_hd__decap_4
X_09230_ _02768_ _02988_ VGND VGND VPWR VPWR _02989_ sky130_fd_sc_hd__nor2_1
X_07491_ _01596_ _01588_ net554 VGND VGND VPWR VPWR _01624_ sky130_fd_sc_hd__mux2_1
XTAP_TAPCELL_ROW_66_1387 VGND VPWR sky130_fd_sc_hd__tapvpwrvgnd_1
XFILLER_61_361 VGND VGND VPWR VPWR sky130_fd_sc_hd__decap_4
XFILLER_34_586 VGND VGND VPWR VPWR sky130_fd_sc_hd__fill_2
XTAP_TAPCELL_ROW_66_1398 VGND VPWR sky130_fd_sc_hd__tapvpwrvgnd_1
XFILLER_21_225 VGND VGND VPWR VPWR sky130_fd_sc_hd__fill_1
XFILLER_22_737 VPWR VGND VPWR VGND sky130_ef_sc_hd__decap_12
X_09161_ net583 net591 net492 net496 VGND VGND VPWR VPWR _02920_ sky130_fd_sc_hd__and4_1
XFILLER_119_102 VGND VGND VPWR VPWR sky130_fd_sc_hd__fill_2
XFILLER_21_247 VGND VGND VPWR VPWR sky130_fd_sc_hd__decap_8
X_09092_ _02828_ _02829_ _02830_ _02780_ VGND VGND VPWR VPWR _02851_ sky130_fd_sc_hd__a2bb2o_1
XFILLER_119_113 VGND VGND VPWR VPWR sky130_fd_sc_hd__decap_4
X_08112_ net313 _01957_ _01958_ VGND VGND VPWR VPWR _01959_ sky130_fd_sc_hd__or3_1
XFILLER_9_93 VPWR VGND VPWR VGND sky130_ef_sc_hd__decap_12
XFILLER_30_781 VPWR VGND VPWR VGND sky130_ef_sc_hd__decap_12
X_08043_ u_interface.u_gelu_fp32.u_fp32_to_q16.s3_frac\[9\] u_interface.u_gelu_fp32.u_fp32_to_q16.s3_frac\[8\]
+ u_interface.u_gelu_fp32.u_fp32_to_q16.s3_frac\[11\] u_interface.u_gelu_fp32.u_fp32_to_q16.s3_frac\[10\]
+ VGND VGND VPWR VPWR _01900_ sky130_fd_sc_hd__or4_1
Xhold911 u_interface.fifo_wr_ptr\[0\] VGND VGND VPWR VPWR net1776 sky130_fd_sc_hd__dlygate4sd3_1
XFILLER_134_138 VGND VGND VPWR VPWR sky130_fd_sc_hd__fill_2
Xhold900 u_interface.u_gelu_fp32.u_q16_to_fp32.s3_norm_mag\[14\] VGND VGND VPWR VPWR
+ net1765 sky130_fd_sc_hd__dlygate4sd3_1
Xhold922 u_interface.u_gelu_fp32.u_q16_to_fp32.s3_norm_mag\[7\] VGND VGND VPWR VPWR
+ net1787 sky130_fd_sc_hd__dlygate4sd3_1
XFILLER_134_149 VPWR VGND VPWR VGND sky130_ef_sc_hd__decap_12
XFILLER_115_352 VGND VGND VPWR VPWR sky130_fd_sc_hd__fill_2
XFILLER_131_823 VGND VGND VPWR VPWR sky130_fd_sc_hd__fill_1
XFILLER_103_503 VGND VGND VPWR VPWR sky130_fd_sc_hd__fill_1
X_09994_ net830 _03746_ VGND VGND VPWR VPWR _03747_ sky130_fd_sc_hd__nor2_1
XFILLER_0_118 VPWR VGND VPWR VGND sky130_ef_sc_hd__decap_12
XFILLER_130_322 VPWR VGND VPWR VGND sky130_ef_sc_hd__decap_12
X_08945_ _02701_ _02702_ _02658_ VGND VGND VPWR VPWR _02704_ sky130_fd_sc_hd__o21bai_1
XTAP_TAPCELL_ROW_110_2097 VGND VPWR sky130_fd_sc_hd__tapvpwrvgnd_1
XFILLER_69_461 VPWR VGND VPWR VGND sky130_ef_sc_hd__decap_12
XTAP_TAPCELL_ROW_4_402 VGND VPWR sky130_fd_sc_hd__tapvpwrvgnd_1
XFILLER_130_399 VGND VGND VPWR VPWR sky130_fd_sc_hd__fill_1
X_08876_ _02621_ _02634_ VGND VGND VPWR VPWR _02635_ sky130_fd_sc_hd__and2b_1
XFILLER_57_634 VGND VGND VPWR VPWR sky130_fd_sc_hd__fill_1
X_07827_ net1376 net573 net232 VGND VGND VPWR VPWR _00588_ sky130_fd_sc_hd__mux2_1
XTAP_TAPCELL_ROW_86_1719 VGND VPWR sky130_fd_sc_hd__tapvpwrvgnd_1
XTAP_TAPCELL_ROW_86_1708 VGND VPWR sky130_fd_sc_hd__tapvpwrvgnd_1
X_07758_ u_interface.u_gelu_fp32.u_q16_to_fp32.s3_exp\[3\] _01796_ net294 VGND VGND
+ VPWR VPWR _01799_ sky130_fd_sc_hd__o21ai_1
XFILLER_84_497 VPWR VGND VPWR VGND sky130_ef_sc_hd__decap_12
XFILLER_84_475 VGND VGND VPWR VPWR sky130_fd_sc_hd__fill_1
XFILLER_56_177 VPWR VGND VPWR VGND sky130_ef_sc_hd__decap_12
X_06709_ u_interface.fifo_data\[12\]\[10\] u_interface.fifo_data\[13\]\[10\] u_interface.fifo_data\[14\]\[10\]
+ u_interface.fifo_data\[15\]\[10\] net769 net752 VGND VGND VPWR VPWR _01274_ sky130_fd_sc_hd__mux4_1
XFILLER_72_659 VGND VGND VPWR VPWR sky130_fd_sc_hd__decap_3
XFILLER_37_380 VGND VGND VPWR VPWR sky130_fd_sc_hd__fill_1
X_07689_ u_interface.u_gelu_fp32.u_synth_top.s1_hits\[13\] u_interface.u_gelu_fp32.u_synth_top.s1_hits\[2\]
+ _01760_ VGND VGND VPWR VPWR _01761_ sky130_fd_sc_hd__or3_1
XFILLER_80_670 VGND VGND VPWR VPWR sky130_fd_sc_hd__fill_1
XFILLER_71_169 VPWR VGND VPWR VGND sky130_ef_sc_hd__decap_12
XFILLER_44_68 VPWR VGND VPWR VGND sky130_ef_sc_hd__decap_12
X_09428_ _02661_ _03185_ VGND VGND VPWR VPWR _03186_ sky130_fd_sc_hd__xnor2_1
XTAP_TAPCELL_ROW_23_710 VGND VPWR sky130_fd_sc_hd__tapvpwrvgnd_1
XFILLER_40_545 VGND VGND VPWR VPWR sky130_fd_sc_hd__decap_3
X_09359_ _03068_ _03115_ VGND VGND VPWR VPWR _03118_ sky130_fd_sc_hd__xnor2_1
XFILLER_12_269 VGND VGND VPWR VPWR sky130_fd_sc_hd__decap_4
XFILLER_138_433 VGND VGND VPWR VPWR sky130_fd_sc_hd__decap_3
XTAP_TAPCELL_ROW_117_2207 VGND VPWR sky130_fd_sc_hd__tapvpwrvgnd_1
X_12370_ _06097_ _06096_ VGND VGND VPWR VPWR _06098_ sky130_fd_sc_hd__nand2b_1
XFILLER_40_589 VPWR VGND VPWR VGND sky130_ef_sc_hd__decap_12
XFILLER_121_3 VGND VGND VPWR VPWR sky130_fd_sc_hd__fill_2
XFILLER_60_56 VGND VGND VPWR VPWR sky130_fd_sc_hd__decap_4
X_11321_ _05060_ _05061_ VGND VGND VPWR VPWR _05062_ sky130_fd_sc_hd__or2_1
XTAP_TAPCELL_ROW_130_2418 VGND VPWR sky130_fd_sc_hd__tapvpwrvgnd_1
XFILLER_4_413 VGND VGND VPWR VPWR sky130_fd_sc_hd__decap_6
X_14040_ clknet_leaf_15_clk _00966_ VGND VGND VPWR VPWR u_interface.u_gelu_fp32.u_fp32_to_q16.s1_mant\[2\]
+ sky130_fd_sc_hd__dfxtp_1
X_11252_ _04868_ _04877_ _04876_ VGND VGND VPWR VPWR _04994_ sky130_fd_sc_hd__a21boi_1
XFILLER_4_457 VPWR VGND VPWR VGND sky130_ef_sc_hd__decap_12
XFILLER_106_363 VGND VGND VPWR VPWR sky130_fd_sc_hd__fill_1
X_10203_ _03885_ _03886_ _03950_ _03951_ VGND VGND VPWR VPWR _03954_ sky130_fd_sc_hd__and4_1
X_11183_ _04923_ _04924_ VGND VGND VPWR VPWR _04925_ sky130_fd_sc_hd__or2_1
XFILLER_122_867 VGND VGND VPWR VPWR sky130_fd_sc_hd__fill_1
XFILLER_122_845 VGND VGND VPWR VPWR sky130_fd_sc_hd__decap_4
X_10134_ _03883_ _03884_ _03862_ VGND VGND VPWR VPWR _03885_ sky130_fd_sc_hd__a21o_1
XFILLER_122_878 VGND VGND VPWR VPWR sky130_fd_sc_hd__decap_6
XFILLER_95_729 VGND VGND VPWR VPWR sky130_fd_sc_hd__decap_6
XFILLER_0_641 VGND VGND VPWR VPWR sky130_fd_sc_hd__decap_3
XFILLER_88_781 VGND VGND VPWR VPWR sky130_fd_sc_hd__decap_3
X_10065_ _03814_ _03815_ _03816_ VGND VGND VPWR VPWR _03817_ sky130_fd_sc_hd__a21oi_1
XFILLER_85_42 VGND VGND VPWR VPWR sky130_fd_sc_hd__fill_1
XTAP_TAPCELL_ROW_50_1133 VGND VPWR sky130_fd_sc_hd__tapvpwrvgnd_1
XFILLER_48_623 VGND VGND VPWR VPWR sky130_fd_sc_hd__fill_2
XFILLER_0_685 VGND VGND VPWR VPWR sky130_fd_sc_hd__decap_4
XTAP_TAPCELL_ROW_145_2661 VGND VPWR sky130_fd_sc_hd__tapvpwrvgnd_1
XTAP_TAPCELL_ROW_145_2650 VGND VPWR sky130_fd_sc_hd__tapvpwrvgnd_1
XFILLER_85_75 VGND VGND VPWR VPWR sky130_fd_sc_hd__decap_3
XFILLER_48_678 VPWR VGND VPWR VGND sky130_ef_sc_hd__decap_12
XFILLER_47_177 VGND VGND VPWR VPWR sky130_fd_sc_hd__decap_3
XFILLER_47_166 VGND VGND VPWR VPWR sky130_fd_sc_hd__fill_2
X_13824_ clknet_leaf_80_clk _00834_ VGND VGND VPWR VPWR u_interface.u_gelu_fp32.u_synth_top.s3_mult\[42\]
+ sky130_fd_sc_hd__dfxtp_1
XFILLER_141_70 VGND VGND VPWR VPWR sky130_fd_sc_hd__decap_6
XFILLER_16_531 VGND VGND VPWR VPWR sky130_fd_sc_hd__fill_1
XFILLER_16_542 VGND VGND VPWR VPWR sky130_fd_sc_hd__decap_6
XFILLER_28_380 VGND VGND VPWR VPWR sky130_fd_sc_hd__fill_1
X_10967_ _04709_ _04710_ VGND VGND VPWR VPWR _04711_ sky130_fd_sc_hd__or2_1
X_13755_ clknet_leaf_84_clk _00765_ VGND VGND VPWR VPWR u_interface.u_gelu_fp32.u_q16_to_fp32.s1_mag\[21\]
+ sky130_fd_sc_hd__dfxtp_1
X_13686_ clknet_leaf_12_clk _00696_ VGND VGND VPWR VPWR u_interface.u_gelu_fp32.u_fp32_to_q16.s3_frac\[22\]
+ sky130_fd_sc_hd__dfxtp_1
X_12706_ net781 net1659 _06359_ _06362_ VGND VGND VPWR VPWR _00920_ sky130_fd_sc_hd__o211a_1
XFILLER_71_681 VGND VGND VPWR VPWR sky130_fd_sc_hd__decap_3
X_10898_ _04528_ _04640_ _04641_ VGND VGND VPWR VPWR _04643_ sky130_fd_sc_hd__nand3_1
XFILLER_31_534 VPWR VGND VPWR VGND sky130_ef_sc_hd__decap_12
X_12637_ _06335_ _06336_ VGND VGND VPWR VPWR _06337_ sky130_fd_sc_hd__or2_1
XFILLER_12_781 VPWR VGND VPWR VGND sky130_ef_sc_hd__decap_12
XFILLER_129_477 VGND VGND VPWR VPWR sky130_fd_sc_hd__decap_6
XFILLER_117_617 VGND VGND VPWR VPWR sky130_fd_sc_hd__decap_8
X_12568_ net784 net1772 VGND VGND VPWR VPWR _00866_ sky130_fd_sc_hd__and2_1
XPHY_EDGE_ROW_152_Right_152 VGND VGND VPWR VPWR sky130_fd_sc_hd__decap_3
Xhold207 u_interface.u_gelu_fp32.u_fp32_to_q16.s1_mant\[6\] VGND VGND VPWR VPWR net1072
+ sky130_fd_sc_hd__dlygate4sd3_1
X_12499_ _06081_ _06186_ VGND VGND VPWR VPWR _06224_ sky130_fd_sc_hd__or2_1
X_11519_ net676 net419 net411 net667 VGND VGND VPWR VPWR _05258_ sky130_fd_sc_hd__a22o_1
Xhold218 u_interface.fifo_tuser\[6\] VGND VGND VPWR VPWR net1083 sky130_fd_sc_hd__dlygate4sd3_1
Xhold229 u_interface.fifo_data\[15\]\[3\] VGND VGND VPWR VPWR net1094 sky130_fd_sc_hd__dlygate4sd3_1
XFILLER_113_801 VGND VGND VPWR VPWR sky130_fd_sc_hd__decap_4
X_14169_ clknet_leaf_44_clk _01095_ VGND VGND VPWR VPWR u_interface.fifo_data\[1\]\[29\]
+ sky130_fd_sc_hd__dfxtp_1
Xfanout709 net710 VGND VGND VPWR VPWR net709 sky130_fd_sc_hd__buf_2
X_06991_ u_interface.fifo_wr_ptr\[3\] u_interface.fifo_wr_ptr\[2\] VGND VGND VPWR
+ VPWR _01512_ sky130_fd_sc_hd__or2_2
XFILLER_98_567 VPWR VGND VPWR VGND sky130_ef_sc_hd__decap_12
X_08730_ net629 net488 net493 net638 VGND VGND VPWR VPWR _02489_ sky130_fd_sc_hd__a22oi_1
X_08661_ _02273_ _02425_ VGND VGND VPWR VPWR _02426_ sky130_fd_sc_hd__xnor2_1
X_07612_ net334 _01704_ _01705_ VGND VGND VPWR VPWR _01706_ sky130_fd_sc_hd__o21ai_1
XTAP_TAPCELL_ROW_68_1427 VGND VPWR sky130_fd_sc_hd__tapvpwrvgnd_1
XTAP_TAPCELL_ROW_68_1416 VGND VPWR sky130_fd_sc_hd__tapvpwrvgnd_1
XFILLER_38_188 VGND VGND VPWR VPWR sky130_fd_sc_hd__decap_8
X_08592_ net159 _02375_ VGND VGND VPWR VPWR _02376_ sky130_fd_sc_hd__nand2_1
X_07543_ net545 _01585_ VGND VGND VPWR VPWR _01661_ sky130_fd_sc_hd__or2_1
XFILLER_81_489 VGND VGND VPWR VPWR sky130_fd_sc_hd__decap_8
Xclkbuf_3_5__f_clk clknet_0_clk VGND VGND VPWR VPWR clknet_3_5__leaf_clk sky130_fd_sc_hd__clkbuf_16
XFILLER_53_169 VGND VGND VPWR VPWR sky130_fd_sc_hd__decap_6
XFILLER_35_873 VPWR VGND VPWR VGND sky130_ef_sc_hd__decap_12
X_07474_ _01562_ _01564_ net557 VGND VGND VPWR VPWR _01608_ sky130_fd_sc_hd__mux2_1
XTAP_TAPCELL_ROW_81_1638 VGND VPWR sky130_fd_sc_hd__tapvpwrvgnd_1
XTAP_TAPCELL_ROW_81_1627 VGND VPWR sky130_fd_sc_hd__tapvpwrvgnd_1
XFILLER_14_27 VGND VGND VPWR VPWR sky130_fd_sc_hd__fill_1
X_09213_ _02969_ _02970_ _02968_ VGND VGND VPWR VPWR _02972_ sky130_fd_sc_hd__o21bai_1
XFILLER_50_865 VGND VGND VPWR VPWR sky130_fd_sc_hd__decap_3
XFILLER_22_556 VPWR VGND VPWR VGND sky130_ef_sc_hd__decap_12
X_09144_ _02899_ _02900_ _02902_ VGND VGND VPWR VPWR _02903_ sky130_fd_sc_hd__and3_1
XFILLER_22_589 VPWR VGND VPWR VGND sky130_ef_sc_hd__decap_12
XFILLER_108_617 VGND VGND VPWR VPWR sky130_fd_sc_hd__decap_8
X_09075_ _02791_ _02794_ _02793_ VGND VGND VPWR VPWR _02834_ sky130_fd_sc_hd__a21o_1
XFILLER_30_15 VPWR VGND VPWR VGND sky130_ef_sc_hd__decap_12
XFILLER_146_26 VGND VGND VPWR VPWR sky130_fd_sc_hd__fill_2
Xhold730 _01004_ VGND VGND VPWR VPWR net1595 sky130_fd_sc_hd__dlygate4sd3_1
XTAP_TAPCELL_ROW_112_2126 VGND VPWR sky130_fd_sc_hd__tapvpwrvgnd_1
X_08026_ u_interface.u_gelu_fp32.u_fp32_to_q16.s3_mag\[14\] _01882_ VGND VGND VPWR
+ VPWR _01883_ sky130_fd_sc_hd__and2_1
XTAP_TAPCELL_ROW_96_1870 VGND VPWR sky130_fd_sc_hd__tapvpwrvgnd_1
Xhold752 _01018_ VGND VGND VPWR VPWR net1617 sky130_fd_sc_hd__dlygate4sd3_1
Xhold741 u_interface.u_gelu_fp32.s2_data\[10\] VGND VGND VPWR VPWR net1606 sky130_fd_sc_hd__dlygate4sd3_1
Xhold763 u_interface.u_gelu_fp32.s2_data\[19\] VGND VGND VPWR VPWR net1628 sky130_fd_sc_hd__dlygate4sd3_1
XFILLER_1_405 VPWR VGND VPWR VGND sky130_ef_sc_hd__decap_12
XFILLER_2_917 VGND VGND VPWR VPWR sky130_fd_sc_hd__fill_1
Xhold774 u_interface.fifo_rd_ptr\[3\] VGND VGND VPWR VPWR net1639 sky130_fd_sc_hd__dlygate4sd3_1
XFILLER_104_867 VGND VGND VPWR VPWR sky130_fd_sc_hd__fill_1
Xhold796 u_interface.u_gelu_fp32.u_q16_to_fp32.s3_norm_mag\[23\] VGND VGND VPWR VPWR
+ net1661 sky130_fd_sc_hd__dlygate4sd3_1
Xhold785 u_interface.u_gelu_fp32.u_q16_to_fp32.s1_mag\[5\] VGND VGND VPWR VPWR net1650
+ sky130_fd_sc_hd__dlygate4sd3_1
XFILLER_1_449 VPWR VGND VPWR VGND sky130_ef_sc_hd__decap_12
X_09977_ _03617_ _03619_ _03727_ _03728_ VGND VGND VPWR VPWR _03730_ sky130_fd_sc_hd__o211a_1
XFILLER_77_729 VGND VGND VPWR VPWR sky130_fd_sc_hd__fill_2
XFILLER_39_57 VGND VGND VPWR VPWR sky130_fd_sc_hd__decap_8
X_08928_ _02678_ _02684_ _02685_ VGND VGND VPWR VPWR _02687_ sky130_fd_sc_hd__nand3_2
X_08859_ _02607_ _02617_ VGND VGND VPWR VPWR _02618_ sky130_fd_sc_hd__xor2_1
XFILLER_84_250 VGND VGND VPWR VPWR sky130_fd_sc_hd__fill_2
X_11870_ net666 net393 VGND VGND VPWR VPWR _05605_ sky130_fd_sc_hd__nand2_1
XTAP_TAPCELL_ROW_123_2299 VGND VPWR sky130_fd_sc_hd__tapvpwrvgnd_1
XFILLER_72_489 VPWR VGND VPWR VGND sky130_ef_sc_hd__decap_12
X_10821_ _04559_ _04564_ VGND VGND VPWR VPWR _04566_ sky130_fd_sc_hd__xnor2_1
XTAP_TAPCELL_ROW_140_2580 VGND VPWR sky130_fd_sc_hd__tapvpwrvgnd_1
X_13540_ clknet_leaf_43_clk _00550_ VGND VGND VPWR VPWR u_interface.fifo_data\[5\]\[19\]
+ sky130_fd_sc_hd__dfxtp_1
X_10752_ net644 net431 net427 net635 VGND VGND VPWR VPWR _04498_ sky130_fd_sc_hd__a22oi_1
X_13471_ clknet_leaf_64_clk _00481_ VGND VGND VPWR VPWR u_interface.u_gelu_fp32.u_q16_to_fp32.s3_norm_mag\[11\]
+ sky130_fd_sc_hd__dfxtp_1
XFILLER_9_505 VPWR VGND VPWR VGND sky130_ef_sc_hd__decap_12
XFILLER_41_854 VGND VGND VPWR VPWR sky130_fd_sc_hd__fill_1
X_10683_ _03752_ _04429_ VGND VGND VPWR VPWR _04430_ sky130_fd_sc_hd__and2_1
XFILLER_71_77 VGND VGND VPWR VPWR sky130_fd_sc_hd__fill_2
X_12422_ _06081_ _06147_ VGND VGND VPWR VPWR _06149_ sky130_fd_sc_hd__xor2_1
XFILLER_40_397 VGND VGND VPWR VPWR sky130_fd_sc_hd__decap_8
XFILLER_154_745 VGND VGND VPWR VPWR sky130_fd_sc_hd__decap_8
X_12353_ net202 _06080_ VGND VGND VPWR VPWR _06081_ sky130_fd_sc_hd__xnor2_4
XPHY_EDGE_ROW_33_Left_189 VGND VGND VPWR VPWR sky130_fd_sc_hd__decap_3
XFILLER_99_309 VGND VGND VPWR VPWR sky130_fd_sc_hd__decap_6
X_11304_ _04951_ _04958_ _04959_ VGND VGND VPWR VPWR _05045_ sky130_fd_sc_hd__a21boi_2
XFILLER_4_221 VPWR VGND VPWR VGND sky130_ef_sc_hd__decap_12
X_12284_ net203 _06011_ VGND VGND VPWR VPWR _06013_ sky130_fd_sc_hd__xor2_1
X_14023_ clknet_leaf_71_clk _00949_ VGND VGND VPWR VPWR u_interface.core_data_out\[9\]
+ sky130_fd_sc_hd__dfxtp_1
X_11235_ _04966_ _04974_ VGND VGND VPWR VPWR _04977_ sky130_fd_sc_hd__nand2_1
XFILLER_5_777 VGND VGND VPWR VPWR sky130_fd_sc_hd__decap_6
XFILLER_4_265 VPWR VGND VPWR VGND sky130_ef_sc_hd__decap_12
XFILLER_136_70 VGND VGND VPWR VPWR sky130_fd_sc_hd__fill_2
X_11166_ _03969_ _03970_ _04436_ _04907_ VGND VGND VPWR VPWR _04909_ sky130_fd_sc_hd__a211o_1
XFILLER_96_85 VGND VGND VPWR VPWR sky130_fd_sc_hd__fill_1
X_10117_ net499 net723 _03763_ _03867_ VGND VGND VPWR VPWR _03868_ sky130_fd_sc_hd__nand4_1
X_11097_ _04836_ _04839_ VGND VGND VPWR VPWR _04840_ sky130_fd_sc_hd__xnor2_1
X_10048_ _03680_ _03682_ _03799_ VGND VGND VPWR VPWR _03800_ sky130_fd_sc_hd__a21oi_1
XPHY_EDGE_ROW_42_Left_198 VGND VGND VPWR VPWR sky130_fd_sc_hd__decap_3
Xhold90 u_interface.meta_tlast_pipe\[7\] VGND VGND VPWR VPWR net955 sky130_fd_sc_hd__dlygate4sd3_1
XFILLER_91_721 VGND VGND VPWR VPWR sky130_fd_sc_hd__decap_6
XFILLER_36_637 VGND VGND VPWR VPWR sky130_fd_sc_hd__decap_6
XFILLER_90_220 VGND VGND VPWR VPWR sky130_fd_sc_hd__fill_1
XFILLER_35_125 VGND VGND VPWR VPWR sky130_fd_sc_hd__decap_8
XFILLER_90_253 VGND VGND VPWR VPWR sky130_fd_sc_hd__fill_2
X_13807_ clknet_leaf_58_clk _00817_ VGND VGND VPWR VPWR u_interface.u_gelu_fp32.u_synth_top.s3_mult\[25\]
+ sky130_fd_sc_hd__dfxtp_1
XFILLER_35_169 VGND VGND VPWR VPWR sky130_fd_sc_hd__fill_2
X_13738_ clknet_leaf_56_clk _00748_ VGND VGND VPWR VPWR u_interface.u_gelu_fp32.u_q16_to_fp32.s1_mag\[4\]
+ sky130_fd_sc_hd__dfxtp_1
XFILLER_50_139 VGND VGND VPWR VPWR sky130_fd_sc_hd__fill_1
XFILLER_17_895 VGND VGND VPWR VPWR sky130_fd_sc_hd__fill_1
X_11999_ net199 _05731_ VGND VGND VPWR VPWR _05732_ sky130_fd_sc_hd__and2_1
XTAP_TAPCELL_ROW_63_1346 VGND VPWR sky130_fd_sc_hd__tapvpwrvgnd_1
XFILLER_31_353 VGND VGND VPWR VPWR sky130_fd_sc_hd__fill_1
X_13669_ clknet_leaf_13_clk _00679_ VGND VGND VPWR VPWR u_interface.u_gelu_fp32.u_fp32_to_q16.s2_overflow
+ sky130_fd_sc_hd__dfxtp_1
XFILLER_84_3 VPWR VGND VPWR VGND sky130_ef_sc_hd__decap_12
XTAP_TAPCELL_ROW_14_562 VGND VPWR sky130_fd_sc_hd__tapvpwrvgnd_1
XFILLER_129_252 VGND VGND VPWR VPWR sky130_fd_sc_hd__fill_1
X_07190_ net1300 net564 net262 VGND VGND VPWR VPWR _00230_ sky130_fd_sc_hd__mux2_1
XFILLER_117_403 VGND VGND VPWR VPWR sky130_fd_sc_hd__fill_1
Xgelu_top_834 VGND VGND VPWR VPWR gelu_top_834/HI s_axil_rdata[2] sky130_fd_sc_hd__conb_1
Xgelu_top_845 VGND VGND VPWR VPWR gelu_top_845/HI s_axil_rdata[13] sky130_fd_sc_hd__conb_1
XFILLER_144_222 VGND VGND VPWR VPWR sky130_fd_sc_hd__decap_4
XFILLER_133_918 VGND VGND VPWR VPWR sky130_fd_sc_hd__decap_3
XFILLER_117_447 VGND VGND VPWR VPWR sky130_fd_sc_hd__fill_1
Xgelu_top_856 VGND VGND VPWR VPWR gelu_top_856/HI s_axil_rdata[24] sky130_fd_sc_hd__conb_1
XFILLER_144_288 VGND VGND VPWR VPWR sky130_fd_sc_hd__fill_1
XFILLER_104_108 VGND VGND VPWR VPWR sky130_fd_sc_hd__fill_1
X_09900_ _03554_ _03556_ _03649_ _03650_ VGND VGND VPWR VPWR _03653_ sky130_fd_sc_hd__a211o_1
XFILLER_6_83 VGND VGND VPWR VPWR sky130_fd_sc_hd__fill_1
Xfanout506 net507 VGND VGND VPWR VPWR net506 sky130_fd_sc_hd__buf_2
Xfanout517 net518 VGND VGND VPWR VPWR net517 sky130_fd_sc_hd__clkbuf_2
Xfanout539 net540 VGND VGND VPWR VPWR net539 sky130_fd_sc_hd__buf_2
XFILLER_112_141 VPWR VGND VPWR VGND sky130_ef_sc_hd__decap_12
X_09831_ net466 net471 net648 net656 VGND VGND VPWR VPWR _03585_ sky130_fd_sc_hd__nand4_1
Xfanout528 net529 VGND VGND VPWR VPWR net528 sky130_fd_sc_hd__buf_2
XFILLER_140_494 VPWR VGND VPWR VGND sky130_ef_sc_hd__decap_12
X_09762_ _03408_ _03410_ _03514_ _03515_ VGND VGND VPWR VPWR _03517_ sky130_fd_sc_hd__o211ai_2
XFILLER_86_548 VGND VGND VPWR VPWR sky130_fd_sc_hd__fill_2
X_06974_ _01499_ _01500_ VGND VGND VPWR VPWR _00031_ sky130_fd_sc_hd__xnor2_1
X_08713_ net582 net590 net470 net472 VGND VGND VPWR VPWR _02472_ sky130_fd_sc_hd__and4_1
XFILLER_67_751 VGND VGND VPWR VPWR sky130_fd_sc_hd__fill_2
X_09693_ net455 net458 net612 net620 VGND VGND VPWR VPWR _03448_ sky130_fd_sc_hd__nand4_2
XFILLER_66_250 VGND VGND VPWR VPWR sky130_fd_sc_hd__fill_2
XFILLER_27_615 VGND VGND VPWR VPWR sky130_fd_sc_hd__fill_1
XFILLER_39_464 VGND VGND VPWR VPWR sky130_fd_sc_hd__fill_1
XFILLER_81_220 VGND VGND VPWR VPWR sky130_fd_sc_hd__decap_4
XFILLER_66_294 VPWR VGND VPWR VGND sky130_ef_sc_hd__decap_12
X_08644_ _02261_ _02412_ VGND VGND VPWR VPWR _02413_ sky130_fd_sc_hd__xor2_1
X_08575_ net154 _02364_ net824 VGND VGND VPWR VPWR _00777_ sky130_fd_sc_hd__a21oi_1
XFILLER_54_489 VGND VGND VPWR VPWR sky130_fd_sc_hd__decap_6
XFILLER_14_309 VGND VGND VPWR VPWR sky130_fd_sc_hd__decap_4
XFILLER_25_15 VPWR VGND VPWR VGND sky130_ef_sc_hd__decap_12
XFILLER_155_9 VPWR VGND VPWR VGND sky130_ef_sc_hd__decap_12
X_07526_ _01624_ _01621_ net552 VGND VGND VPWR VPWR _01655_ sky130_fd_sc_hd__mux2_1
XFILLER_23_821 VPWR VGND VPWR VGND sky130_ef_sc_hd__decap_12
XFILLER_22_320 VPWR VGND VPWR VGND sky130_ef_sc_hd__decap_12
XFILLER_23_865 VPWR VGND VPWR VGND sky130_ef_sc_hd__decap_12
X_07457_ u_interface.u_gelu_fp32.u_fp32_to_q16.s2_norm_mag\[15\] u_interface.u_gelu_fp32.u_fp32_to_q16.s2_norm_mag\[16\]
+ net558 VGND VGND VPWR VPWR _01592_ sky130_fd_sc_hd__mux2_1
XTAP_TAPCELL_ROW_33_860 VGND VPWR sky130_fd_sc_hd__tapvpwrvgnd_1
XTAP_TAPCELL_ROW_33_871 VGND VPWR sky130_fd_sc_hd__tapvpwrvgnd_1
XFILLER_136_701 VGND VGND VPWR VPWR sky130_fd_sc_hd__decap_6
XTAP_TAPCELL_ROW_98_1910 VGND VPWR sky130_fd_sc_hd__tapvpwrvgnd_1
X_07388_ net1114 net342 net237 VGND VGND VPWR VPWR _00418_ sky130_fd_sc_hd__mux2_1
X_09127_ net614 net621 net503 net507 VGND VGND VPWR VPWR _02886_ sky130_fd_sc_hd__and4_1
XFILLER_135_233 VPWR VGND VPWR VGND sky130_ef_sc_hd__decap_12
X_09058_ _02814_ _02815_ VGND VGND VPWR VPWR _02817_ sky130_fd_sc_hd__nand2_1
X_08009_ net311 _01681_ _01870_ VGND VGND VPWR VPWR _01871_ sky130_fd_sc_hd__o21a_1
Xhold571 u_interface.fifo_data\[8\]\[19\] VGND VGND VPWR VPWR net1436 sky130_fd_sc_hd__dlygate4sd3_1
Xhold560 u_interface.fifo_data\[14\]\[25\] VGND VGND VPWR VPWR net1425 sky130_fd_sc_hd__dlygate4sd3_1
XFILLER_2_725 VPWR VGND VPWR VGND sky130_ef_sc_hd__decap_12
Xhold582 u_interface.u_gelu_fp32.u_fp32_to_q16.s3_frac\[2\] VGND VGND VPWR VPWR net1447
+ sky130_fd_sc_hd__dlygate4sd3_1
Xhold593 u_interface.fifo_data\[0\]\[24\] VGND VGND VPWR VPWR net1458 sky130_fd_sc_hd__dlygate4sd3_1
X_11020_ _04756_ _04763_ VGND VGND VPWR VPWR _04764_ sky130_fd_sc_hd__xnor2_1
XFILLER_2_769 VPWR VGND VPWR VGND sky130_ef_sc_hd__decap_12
XFILLER_131_483 VGND VGND VPWR VPWR sky130_fd_sc_hd__fill_1
XFILLER_106_62 VPWR VGND VPWR VGND sky130_ef_sc_hd__decap_12
XFILLER_103_163 VGND VGND VPWR VPWR sky130_fd_sc_hd__decap_4
XFILLER_89_386 VGND VGND VPWR VPWR sky130_fd_sc_hd__decap_6
XFILLER_77_515 VGND VGND VPWR VPWR sky130_fd_sc_hd__fill_1
XFILLER_1_279 VGND VGND VPWR VPWR sky130_fd_sc_hd__fill_1
X_12971_ _06487_ _06488_ VGND VGND VPWR VPWR _06489_ sky130_fd_sc_hd__nand2_1
XTAP_TAPCELL_ROW_125_2339 VGND VPWR sky130_fd_sc_hd__tapvpwrvgnd_1
XTAP_TAPCELL_ROW_125_2328 VGND VPWR sky130_fd_sc_hd__tapvpwrvgnd_1
XFILLER_45_401 VGND VGND VPWR VPWR sky130_fd_sc_hd__decap_3
XFILLER_72_220 VPWR VGND VPWR VGND sky130_ef_sc_hd__decap_12
XFILLER_45_434 VPWR VGND VPWR VGND sky130_ef_sc_hd__decap_12
XFILLER_17_125 VPWR VGND VPWR VGND sky130_ef_sc_hd__decap_12
XFILLER_18_637 VGND VGND VPWR VPWR sky130_fd_sc_hd__decap_6
X_11922_ net201 _05655_ VGND VGND VPWR VPWR _05656_ sky130_fd_sc_hd__nor2_1
XFILLER_122_61 VGND VGND VPWR VPWR sky130_fd_sc_hd__fill_2
X_11853_ net685 net406 _05526_ _05524_ VGND VGND VPWR VPWR _05588_ sky130_fd_sc_hd__a31o_1
XFILLER_73_798 VGND VGND VPWR VPWR sky130_fd_sc_hd__decap_4
X_10804_ _04443_ _04549_ VGND VGND VPWR VPWR _04550_ sky130_fd_sc_hd__xnor2_2
XFILLER_26_681 VPWR VGND VPWR VGND sky130_ef_sc_hd__decap_12
XFILLER_33_629 VPWR VGND VPWR VGND sky130_ef_sc_hd__decap_12
XFILLER_60_459 VGND VGND VPWR VPWR sky130_fd_sc_hd__fill_1
XTAP_TAPCELL_ROW_45_1054 VGND VPWR sky130_fd_sc_hd__tapvpwrvgnd_1
X_11784_ _05518_ _05519_ _05511_ VGND VGND VPWR VPWR _05520_ sky130_fd_sc_hd__a21oi_1
X_10735_ _04477_ _04478_ _04479_ VGND VGND VPWR VPWR _04481_ sky130_fd_sc_hd__and3_1
X_13523_ clknet_leaf_73_clk _00533_ VGND VGND VPWR VPWR u_interface.fifo_data\[5\]\[2\]
+ sky130_fd_sc_hd__dfxtp_1
XFILLER_15_81 VPWR VGND VPWR VGND sky130_ef_sc_hd__decap_12
XFILLER_41_673 VGND VGND VPWR VPWR sky130_fd_sc_hd__decap_4
X_13454_ clknet_leaf_9_clk _00464_ VGND VGND VPWR VPWR u_interface.u_gelu_fp32.u_fp32_to_q16.s3_mag\[25\]
+ sky130_fd_sc_hd__dfxtp_1
X_10666_ _04391_ _04392_ _04409_ _04410_ VGND VGND VPWR VPWR _04413_ sky130_fd_sc_hd__nand4_1
XTAP_TAPCELL_ROW_11_510 VGND VPWR sky130_fd_sc_hd__tapvpwrvgnd_1
XFILLER_9_368 VGND VGND VPWR VPWR sky130_fd_sc_hd__decap_6
XFILLER_9_335 VGND VGND VPWR VPWR sky130_fd_sc_hd__fill_1
XFILLER_154_520 VGND VGND VPWR VPWR sky130_fd_sc_hd__fill_1
X_13385_ clknet_leaf_68_clk _00395_ VGND VGND VPWR VPWR u_interface.fifo_data\[7\]\[30\]
+ sky130_fd_sc_hd__dfxtp_1
XFILLER_9_379 VPWR VGND VPWR VGND sky130_ef_sc_hd__decap_12
X_12405_ net200 _06130_ VGND VGND VPWR VPWR _06132_ sky130_fd_sc_hd__xnor2_1
XTAP_TAPCELL_ROW_153_2782 VGND VPWR sky130_fd_sc_hd__tapvpwrvgnd_1
X_10597_ net464 net468 net708 net715 VGND VGND VPWR VPWR _04344_ sky130_fd_sc_hd__nand4_1
XFILLER_5_541 VPWR VGND VPWR VGND sky130_ef_sc_hd__decap_12
XFILLER_141_203 VGND VGND VPWR VPWR sky130_fd_sc_hd__decap_4
XFILLER_115_918 VGND VGND VPWR VPWR sky130_fd_sc_hd__decap_3
XFILLER_114_417 VGND VGND VPWR VPWR sky130_fd_sc_hd__decap_3
Xoutput109 net109 VGND VGND VPWR VPWR m_axis_tdata[0] sky130_fd_sc_hd__buf_2
X_12336_ net795 _06064_ VGND VGND VPWR VPWR _06065_ sky130_fd_sc_hd__or2_1
XFILLER_141_225 VGND VGND VPWR VPWR sky130_fd_sc_hd__decap_4
XFILLER_5_585 VPWR VGND VPWR VGND sky130_ef_sc_hd__decap_12
X_12267_ _05995_ _05996_ VGND VGND VPWR VPWR _05997_ sky130_fd_sc_hd__nor2_1
X_14006_ clknet_leaf_54_clk _00932_ VGND VGND VPWR VPWR u_interface.u_gelu_fp32.u_q16_to_fp32.s3_exp\[2\]
+ sky130_fd_sc_hd__dfxtp_1
X_11218_ _04958_ _04959_ VGND VGND VPWR VPWR _04960_ sky130_fd_sc_hd__nand2_1
X_12198_ net193 _05860_ _05859_ VGND VGND VPWR VPWR _05929_ sky130_fd_sc_hd__a21oi_1
XFILLER_110_601 VPWR VGND VPWR VGND sky130_ef_sc_hd__decap_12
XFILLER_96_824 VGND VGND VPWR VPWR sky130_fd_sc_hd__fill_1
X_11149_ _04889_ _04890_ VGND VGND VPWR VPWR _04892_ sky130_fd_sc_hd__xnor2_1
XPHY_EDGE_ROW_50_Left_206 VGND VGND VPWR VPWR sky130_fd_sc_hd__decap_3
XFILLER_110_667 VGND VGND VPWR VPWR sky130_fd_sc_hd__fill_2
XFILLER_110_645 VGND VGND VPWR VPWR sky130_fd_sc_hd__decap_6
XFILLER_95_378 VGND VGND VPWR VPWR sky130_fd_sc_hd__decap_6
XFILLER_83_529 VPWR VGND VPWR VGND sky130_ef_sc_hd__decap_12
X_06690_ u_interface.fifo_data\[4\]\[7\] u_interface.fifo_data\[5\]\[7\] u_interface.fifo_data\[6\]\[7\]
+ u_interface.fifo_data\[7\]\[7\] net770 net753 VGND VGND VPWR VPWR _01258_ sky130_fd_sc_hd__mux4_1
XFILLER_64_754 VGND VGND VPWR VPWR sky130_fd_sc_hd__fill_2
XTAP_TAPCELL_ROW_19_632 VGND VPWR sky130_fd_sc_hd__tapvpwrvgnd_1
XFILLER_36_412 VGND VGND VPWR VPWR sky130_fd_sc_hd__fill_1
XTAP_TAPCELL_ROW_19_643 VGND VPWR sky130_fd_sc_hd__tapvpwrvgnd_1
X_08360_ net529 _02152_ net1604 VGND VGND VPWR VPWR _02153_ sky130_fd_sc_hd__a21oi_1
XFILLER_36_489 VPWR VGND VPWR VGND sky130_ef_sc_hd__decap_12
X_07311_ net1396 net368 net253 VGND VGND VPWR VPWR _00341_ sky130_fd_sc_hd__mux2_1
XFILLER_16_191 VGND VGND VPWR VPWR sky130_fd_sc_hd__decap_4
X_08291_ u_interface.u_gelu_fp32.s2_data\[12\] _02098_ VGND VGND VPWR VPWR _02101_
+ sky130_fd_sc_hd__or2_1
XFILLER_20_813 VPWR VGND VPWR VGND sky130_ef_sc_hd__decap_12
X_07242_ net1366 net372 net249 VGND VGND VPWR VPWR _00274_ sky130_fd_sc_hd__mux2_1
XFILLER_31_172 VGND VGND VPWR VPWR sky130_fd_sc_hd__decap_6
X_07173_ net1272 net359 net263 VGND VGND VPWR VPWR _00213_ sky130_fd_sc_hd__mux2_1
XFILLER_11_39 VPWR VGND VPWR VGND sky130_ef_sc_hd__decap_12
XTAP_TAPCELL_ROW_76_1559 VGND VPWR sky130_fd_sc_hd__tapvpwrvgnd_1
XTAP_TAPCELL_ROW_76_1548 VGND VPWR sky130_fd_sc_hd__tapvpwrvgnd_1
Xfanout303 _01536_ VGND VGND VPWR VPWR net303 sky130_fd_sc_hd__buf_2
XFILLER_120_409 VGND VGND VPWR VPWR sky130_fd_sc_hd__decap_8
Xfanout314 net315 VGND VGND VPWR VPWR net314 sky130_fd_sc_hd__buf_2
Xfanout325 u_interface.meta_tlast_pipe\[11\] VGND VGND VPWR VPWR net325 sky130_fd_sc_hd__buf_1
XFILLER_141_781 VGND VGND VPWR VPWR sky130_fd_sc_hd__decap_3
Xfanout347 u_interface.core_data_out\[19\] VGND VGND VPWR VPWR net347 sky130_fd_sc_hd__buf_1
XFILLER_101_601 VGND VGND VPWR VPWR sky130_fd_sc_hd__fill_1
XFILLER_87_846 VGND VGND VPWR VPWR sky130_fd_sc_hd__fill_1
X_09814_ _03566_ _03567_ VGND VGND VPWR VPWR _03568_ sky130_fd_sc_hd__nor2_1
Xfanout336 net337 VGND VGND VPWR VPWR net336 sky130_fd_sc_hd__clkbuf_4
XFILLER_143_49 VGND VGND VPWR VPWR sky130_fd_sc_hd__decap_6
XFILLER_143_38 VGND VGND VPWR VPWR sky130_fd_sc_hd__decap_3
Xfanout358 u_interface.core_data_out\[13\] VGND VGND VPWR VPWR net358 sky130_fd_sc_hd__clkbuf_2
Xfanout369 u_interface.core_data_out\[8\] VGND VGND VPWR VPWR net369 sky130_fd_sc_hd__buf_1
X_09745_ _03393_ _03395_ _03496_ _03498_ VGND VGND VPWR VPWR _03500_ sky130_fd_sc_hd__o211a_1
XFILLER_101_689 VGND VGND VPWR VPWR sky130_fd_sc_hd__fill_2
XFILLER_86_378 VGND VGND VPWR VPWR sky130_fd_sc_hd__decap_4
X_06957_ _01483_ _01485_ VGND VGND VPWR VPWR _01487_ sky130_fd_sc_hd__and2_1
XFILLER_67_570 VGND VGND VPWR VPWR sky130_fd_sc_hd__fill_2
XFILLER_46_209 VGND VGND VPWR VPWR sky130_fd_sc_hd__decap_6
XTAP_TAPCELL_ROW_107_2047 VGND VPWR sky130_fd_sc_hd__tapvpwrvgnd_1
X_09676_ net475 net479 net662 net672 VGND VGND VPWR VPWR _03431_ sky130_fd_sc_hd__and4_1
X_06888_ u_interface.u_gelu_fp32.u_synth_top.s1_hits\[9\] _01428_ _01429_ _01430_
+ VGND VGND VPWR VPWR _01431_ sky130_fd_sc_hd__or4_1
XTAP_TAPCELL_ROW_38_941 VGND VPWR sky130_fd_sc_hd__tapvpwrvgnd_1
X_08627_ net153 _02400_ net799 VGND VGND VPWR VPWR _00793_ sky130_fd_sc_hd__a21oi_1
XFILLER_54_253 VPWR VGND VPWR VGND sky130_ef_sc_hd__decap_12
XFILLER_54_242 VGND VGND VPWR VPWR sky130_fd_sc_hd__decap_8
XFILLER_15_629 VPWR VGND VPWR VGND sky130_ef_sc_hd__decap_12
XTAP_TAPCELL_ROW_120_2258 VGND VPWR sky130_fd_sc_hd__tapvpwrvgnd_1
XFILLER_70_757 VGND VGND VPWR VPWR sky130_fd_sc_hd__decap_6
XFILLER_14_139 VGND VGND VPWR VPWR sky130_fd_sc_hd__fill_1
X_08558_ _02328_ _02329_ _02332_ _02339_ VGND VGND VPWR VPWR _02349_ sky130_fd_sc_hd__or4_1
X_07509_ _01637_ _01639_ net545 VGND VGND VPWR VPWR _01640_ sky130_fd_sc_hd__mux2_1
XFILLER_10_301 VGND VGND VPWR VPWR sky130_fd_sc_hd__decap_3
XFILLER_22_161 VGND VGND VPWR VPWR sky130_fd_sc_hd__fill_2
XFILLER_23_673 VPWR VGND VPWR VGND sky130_ef_sc_hd__decap_12
X_08489_ _02279_ VGND VGND VPWR VPWR _02280_ sky130_fd_sc_hd__inv_2
X_10520_ _04264_ _04265_ _04266_ VGND VGND VPWR VPWR _04268_ sky130_fd_sc_hd__nand3_1
X_10451_ net809 _04198_ _04199_ VGND VGND VPWR VPWR _00818_ sky130_fd_sc_hd__nor3_1
XFILLER_7_839 VGND VGND VPWR VPWR sky130_fd_sc_hd__fill_1
XFILLER_148_380 VGND VGND VPWR VPWR sky130_fd_sc_hd__fill_2
XFILLER_136_531 VGND VGND VPWR VPWR sky130_fd_sc_hd__fill_1
XFILLER_151_501 VGND VGND VPWR VPWR sky130_fd_sc_hd__decap_3
XFILLER_136_586 VGND VGND VPWR VPWR sky130_fd_sc_hd__fill_2
XTAP_TAPCELL_ROW_135_2490 VGND VPWR sky130_fd_sc_hd__tapvpwrvgnd_1
XFILLER_123_203 VGND VGND VPWR VPWR sky130_fd_sc_hd__fill_1
X_13170_ clknet_leaf_65_clk _00180_ VGND VGND VPWR VPWR u_interface.fifo_data\[9\]\[12\]
+ sky130_fd_sc_hd__dfxtp_1
X_10382_ _04129_ _04130_ _04123_ VGND VGND VPWR VPWR _04131_ sky130_fd_sc_hd__a21o_1
XFILLER_123_225 VPWR VGND VPWR VGND sky130_ef_sc_hd__decap_12
XPHY_EDGE_ROW_107_Left_263 VGND VGND VPWR VPWR sky130_fd_sc_hd__decap_3
XFILLER_2_533 VPWR VGND VPWR VGND sky130_ef_sc_hd__decap_12
X_12121_ _05804_ _05852_ VGND VGND VPWR VPWR _05853_ sky130_fd_sc_hd__xor2_1
XFILLER_151_567 VGND VGND VPWR VPWR sky130_fd_sc_hd__fill_1
Xhold390 u_interface.u_gelu_fp32.u_fp32_to_q16.s3_frac\[16\] VGND VGND VPWR VPWR net1255
+ sky130_fd_sc_hd__dlygate4sd3_1
X_12052_ _05724_ _05784_ VGND VGND VPWR VPWR _05785_ sky130_fd_sc_hd__xnor2_1
X_11003_ _04743_ _04746_ VGND VGND VPWR VPWR _04747_ sky130_fd_sc_hd__xnor2_1
XFILLER_77_389 VGND VGND VPWR VPWR sky130_fd_sc_hd__decap_3
XFILLER_18_401 VPWR VGND VPWR VGND sky130_ef_sc_hd__decap_12
XFILLER_37_209 VPWR VGND VPWR VGND sky130_ef_sc_hd__decap_12
X_12954_ _06473_ _06474_ _06468_ VGND VGND VPWR VPWR _06475_ sky130_fd_sc_hd__a21bo_1
XFILLER_93_31 VGND VGND VPWR VPWR sky130_fd_sc_hd__decap_4
XPHY_EDGE_ROW_116_Left_272 VGND VGND VPWR VPWR sky130_fd_sc_hd__decap_3
XFILLER_46_754 VGND VGND VPWR VPWR sky130_fd_sc_hd__fill_2
X_11905_ _05638_ _05639_ VGND VGND VPWR VPWR _05640_ sky130_fd_sc_hd__nor2_1
XFILLER_18_445 VGND VGND VPWR VPWR sky130_fd_sc_hd__decap_3
XFILLER_34_905 VPWR VGND VPWR VGND sky130_ef_sc_hd__decap_12
X_12885_ net785 net941 VGND VGND VPWR VPWR _01027_ sky130_fd_sc_hd__and2_1
XFILLER_61_713 VGND VGND VPWR VPWR sky130_fd_sc_hd__fill_1
XFILLER_33_426 VGND VGND VPWR VPWR sky130_fd_sc_hd__decap_3
X_11836_ _05501_ _05506_ _05509_ VGND VGND VPWR VPWR _05571_ sky130_fd_sc_hd__o21ba_1
XFILLER_20_109 VPWR VGND VPWR VGND sky130_ef_sc_hd__decap_12
X_11767_ _05416_ _05502_ VGND VGND VPWR VPWR _05503_ sky130_fd_sc_hd__nor2_1
XTAP_TAPCELL_ROW_155_2833 VGND VPWR sky130_fd_sc_hd__tapvpwrvgnd_1
XTAP_TAPCELL_ROW_155_2822 VGND VPWR sky130_fd_sc_hd__tapvpwrvgnd_1
XTAP_TAPCELL_ROW_155_2811 VGND VPWR sky130_fd_sc_hd__tapvpwrvgnd_1
X_13506_ clknet_leaf_5_clk _00516_ VGND VGND VPWR VPWR u_interface.u_gelu_fp32.u_synth_top.s2_m\[5\]
+ sky130_fd_sc_hd__dfxtp_1
X_10718_ _04462_ _04463_ VGND VGND VPWR VPWR _04464_ sky130_fd_sc_hd__nand2_1
XFILLER_13_161 VGND VGND VPWR VPWR sky130_fd_sc_hd__decap_6
XFILLER_146_328 VPWR VGND VPWR VGND sky130_ef_sc_hd__decap_12
XFILLER_146_306 VGND VGND VPWR VPWR sky130_fd_sc_hd__fill_2
X_11698_ _05429_ _05432_ _05433_ VGND VGND VPWR VPWR _05435_ sky130_fd_sc_hd__nand3_1
X_13437_ clknet_leaf_11_clk _00447_ VGND VGND VPWR VPWR u_interface.u_gelu_fp32.u_fp32_to_q16.s3_mag\[8\]
+ sky130_fd_sc_hd__dfxtp_1
X_10649_ _04394_ _04395_ VGND VGND VPWR VPWR _04396_ sky130_fd_sc_hd__and2b_1
X_13368_ clknet_leaf_26_clk _00378_ VGND VGND VPWR VPWR u_interface.fifo_data\[7\]\[13\]
+ sky130_fd_sc_hd__dfxtp_1
XPHY_EDGE_ROW_125_Left_281 VGND VGND VPWR VPWR sky130_fd_sc_hd__decap_3
XFILLER_6_861 VGND VGND VPWR VPWR sky130_fd_sc_hd__decap_6
XTAP_TAPCELL_ROW_58_1267 VGND VPWR sky130_fd_sc_hd__tapvpwrvgnd_1
XTAP_TAPCELL_ROW_58_1256 VGND VPWR sky130_fd_sc_hd__tapvpwrvgnd_1
X_12319_ _06046_ _06047_ VGND VGND VPWR VPWR _06048_ sky130_fd_sc_hd__nand2_1
XFILLER_47_3 VPWR VGND VPWR VGND sky130_ef_sc_hd__decap_12
X_13299_ clknet_leaf_72_clk _00309_ VGND VGND VPWR VPWR u_interface.fifo_data\[8\]\[8\]
+ sky130_fd_sc_hd__dfxtp_1
XFILLER_5_393 VGND VGND VPWR VPWR sky130_fd_sc_hd__decap_8
XFILLER_142_589 VPWR VGND VPWR VGND sky130_ef_sc_hd__decap_12
X_07860_ net571 net1557 net284 VGND VGND VPWR VPWR _00621_ sky130_fd_sc_hd__mux2_1
XFILLER_96_643 VGND VGND VPWR VPWR sky130_fd_sc_hd__fill_1
XTAP_TAPCELL_ROW_71_1478 VGND VPWR sky130_fd_sc_hd__tapvpwrvgnd_1
XTAP_TAPCELL_ROW_71_1467 VGND VPWR sky130_fd_sc_hd__tapvpwrvgnd_1
XFILLER_3_51 VGND VGND VPWR VPWR sky130_fd_sc_hd__decap_4
X_06811_ _01362_ _01363_ net735 VGND VGND VPWR VPWR _01364_ sky130_fd_sc_hd__mux2_1
XFILLER_95_142 VPWR VGND VPWR VGND sky130_ef_sc_hd__decap_12
X_07791_ net1105 net343 net233 VGND VGND VPWR VPWR _00552_ sky130_fd_sc_hd__mux2_1
XFILLER_28_209 VGND VGND VPWR VPWR sky130_fd_sc_hd__decap_4
XPHY_EDGE_ROW_134_Left_290 VGND VGND VPWR VPWR sky130_fd_sc_hd__decap_3
X_06742_ u_interface.fifo_data\[12\]\[14\] u_interface.fifo_data\[13\]\[14\] u_interface.fifo_data\[14\]\[14\]
+ u_interface.fifo_data\[15\]\[14\] net766 net749 VGND VGND VPWR VPWR _01303_ sky130_fd_sc_hd__mux4_1
X_09530_ net472 net640 VGND VGND VPWR VPWR _03287_ sky130_fd_sc_hd__and2_1
XFILLER_83_348 VGND VGND VPWR VPWR sky130_fd_sc_hd__decap_8
XFILLER_83_337 VGND VGND VPWR VPWR sky130_fd_sc_hd__decap_3
X_09461_ _02673_ _02675_ _03216_ _03217_ VGND VGND VPWR VPWR _03219_ sky130_fd_sc_hd__a211oi_2
XFILLER_91_381 VGND VGND VPWR VPWR sky130_fd_sc_hd__decap_8
X_06673_ u_interface.fifo_data\[0\]\[5\] u_interface.fifo_data\[1\]\[5\] u_interface.fifo_data\[2\]\[5\]
+ u_interface.fifo_data\[3\]\[5\] net758 net741 VGND VGND VPWR VPWR _01243_ sky130_fd_sc_hd__mux4_1
XTAP_TAPCELL_ROW_35_900 VGND VPWR sky130_fd_sc_hd__tapvpwrvgnd_1
X_09392_ _03139_ _03149_ VGND VGND VPWR VPWR _03150_ sky130_fd_sc_hd__xnor2_1
X_08412_ u_interface.u_gelu_fp32.u_synth_top.s3_mult\[21\] u_interface.u_gelu_fp32.u_synth_top.s3_b\[5\]
+ VGND VGND VPWR VPWR _02203_ sky130_fd_sc_hd__or2_1
XFILLER_51_223 VGND VGND VPWR VPWR sky130_fd_sc_hd__fill_1
XFILLER_149_111 VGND VGND VPWR VPWR sky130_fd_sc_hd__fill_1
X_08343_ u_interface.u_gelu_fp32.s2_data\[25\] _02137_ VGND VGND VPWR VPWR _02140_
+ sky130_fd_sc_hd__or2_1
X_08274_ _02087_ _02088_ VGND VGND VPWR VPWR _00752_ sky130_fd_sc_hd__nor2_1
XFILLER_20_643 VGND VGND VPWR VPWR sky130_fd_sc_hd__fill_1
X_07225_ _01102_ _01527_ VGND VGND VPWR VPWR _01528_ sky130_fd_sc_hd__nor2_1
XFILLER_22_27 VGND VGND VPWR VPWR sky130_fd_sc_hd__fill_1
XFILLER_118_531 VGND VGND VPWR VPWR sky130_fd_sc_hd__fill_1
X_07156_ net1016 net568 net220 VGND VGND VPWR VPWR _00196_ sky130_fd_sc_hd__mux2_1
XFILLER_152_309 VPWR VGND VPWR VGND sky130_ef_sc_hd__decap_12
XFILLER_133_512 VGND VGND VPWR VPWR sky130_fd_sc_hd__decap_6
X_07087_ net1308 net373 net225 VGND VGND VPWR VPWR _00127_ sky130_fd_sc_hd__mux2_1
XFILLER_154_26 VGND VGND VPWR VPWR sky130_fd_sc_hd__fill_2
XFILLER_133_545 VGND VGND VPWR VPWR sky130_fd_sc_hd__decap_4
XFILLER_101_431 VGND VGND VPWR VPWR sky130_fd_sc_hd__fill_2
XFILLER_101_420 VGND VGND VPWR VPWR sky130_fd_sc_hd__fill_2
Xfanout155 _02360_ VGND VGND VPWR VPWR net155 sky130_fd_sc_hd__buf_2
Xfanout166 net167 VGND VGND VPWR VPWR net166 sky130_fd_sc_hd__buf_2
XFILLER_75_827 VPWR VGND VPWR VGND sky130_ef_sc_hd__decap_12
Xfanout177 _04921_ VGND VGND VPWR VPWR net177 sky130_fd_sc_hd__buf_2
Xfanout199 _05493_ VGND VGND VPWR VPWR net199 sky130_fd_sc_hd__buf_2
X_07989_ u_interface.u_gelu_fp32.u_fp32_to_q16.s2_shift\[4\] _01662_ _01839_ _01856_
+ VGND VGND VPWR VPWR _01857_ sky130_fd_sc_hd__o2bb2a_1
X_09728_ _03333_ _03341_ _03342_ VGND VGND VPWR VPWR _03483_ sky130_fd_sc_hd__a21o_1
XFILLER_86_197 VGND VGND VPWR VPWR sky130_fd_sc_hd__decap_4
XFILLER_86_175 VGND VGND VPWR VPWR sky130_fd_sc_hd__decap_3
XFILLER_47_57 VGND VGND VPWR VPWR sky130_fd_sc_hd__decap_8
XPHY_EDGE_ROW_29_Right_29 VGND VGND VPWR VPWR sky130_fd_sc_hd__decap_3
XFILLER_103_41 VGND VGND VPWR VPWR sky130_fd_sc_hd__decap_6
XTAP_TAPCELL_ROW_2_363 VGND VPWR sky130_fd_sc_hd__tapvpwrvgnd_1
XTAP_TAPCELL_ROW_2_374 VGND VPWR sky130_fd_sc_hd__tapvpwrvgnd_1
XFILLER_16_905 VPWR VGND VPWR VGND sky130_ef_sc_hd__decap_12
X_09659_ _03413_ _03414_ _03315_ _03317_ VGND VGND VPWR VPWR _03415_ sky130_fd_sc_hd__o211a_1
XFILLER_82_381 VPWR VGND VPWR VGND sky130_ef_sc_hd__decap_12
XFILLER_82_370 VGND VGND VPWR VPWR sky130_fd_sc_hd__fill_2
X_12670_ u_interface.u_gelu_fp32.u_q16_to_fp32.s1_mag\[25\] net1690 net796 VGND VGND
+ VPWR VPWR _00906_ sky130_fd_sc_hd__mux2_1
XFILLER_70_587 VGND VGND VPWR VPWR sky130_fd_sc_hd__fill_1
XFILLER_70_576 VGND VGND VPWR VPWR sky130_fd_sc_hd__decap_6
X_11621_ net650 net658 net403 net399 VGND VGND VPWR VPWR _05359_ sky130_fd_sc_hd__and4_1
XFILLER_30_429 VPWR VGND VPWR VGND sky130_ef_sc_hd__decap_12
XTAP_TAPCELL_ROW_42_1002 VGND VPWR sky130_fd_sc_hd__tapvpwrvgnd_1
XTAP_TAPCELL_ROW_100_1939 VGND VPWR sky130_fd_sc_hd__tapvpwrvgnd_1
XTAP_TAPCELL_ROW_100_1928 VGND VPWR sky130_fd_sc_hd__tapvpwrvgnd_1
XFILLER_8_29 VPWR VGND VPWR VGND sky130_ef_sc_hd__decap_12
XTAP_TAPCELL_ROW_42_1013 VGND VPWR sky130_fd_sc_hd__tapvpwrvgnd_1
XTAP_TAPCELL_ROW_137_2530 VGND VPWR sky130_fd_sc_hd__tapvpwrvgnd_1
XFILLER_11_665 VGND VGND VPWR VPWR sky130_fd_sc_hd__decap_6
XPHY_EDGE_ROW_38_Right_38 VGND VGND VPWR VPWR sky130_fd_sc_hd__decap_3
X_11552_ _05287_ _05288_ VGND VGND VPWR VPWR _05291_ sky130_fd_sc_hd__xnor2_1
XFILLER_128_339 VGND VGND VPWR VPWR sky130_fd_sc_hd__fill_1
X_10503_ _04247_ _04248_ _04249_ VGND VGND VPWR VPWR _04251_ sky130_fd_sc_hd__and3_1
XFILLER_10_153 VPWR VGND VPWR VGND sky130_ef_sc_hd__decap_12
XTAP_TAPCELL_ROW_21_671 VGND VPWR sky130_fd_sc_hd__tapvpwrvgnd_1
X_11483_ _05144_ _05158_ _05159_ VGND VGND VPWR VPWR _05222_ sky130_fd_sc_hd__o21ba_1
XFILLER_152_810 VGND VGND VPWR VPWR sky130_fd_sc_hd__fill_2
XTAP_TAPCELL_ROW_150_2730 VGND VPWR sky130_fd_sc_hd__tapvpwrvgnd_1
X_10434_ _04181_ net171 _04066_ _04068_ VGND VGND VPWR VPWR _04183_ sky130_fd_sc_hd__o211a_1
X_13222_ clknet_leaf_62_clk _00232_ VGND VGND VPWR VPWR u_interface.fifo_data\[11\]\[0\]
+ sky130_fd_sc_hd__dfxtp_1
XTAP_TAPCELL_ROW_150_2741 VGND VPWR sky130_fd_sc_hd__tapvpwrvgnd_1
X_13153_ clknet_leaf_35_clk _00163_ VGND VGND VPWR VPWR u_interface.fifo_tlast\[4\]
+ sky130_fd_sc_hd__dfxtp_1
X_10365_ net465 net688 net699 net469 VGND VGND VPWR VPWR _04114_ sky130_fd_sc_hd__a22o_1
XFILLER_112_718 VPWR VGND VPWR VGND sky130_ef_sc_hd__decap_12
X_12104_ _05833_ _05834_ VGND VGND VPWR VPWR _05836_ sky130_fd_sc_hd__xor2_1
XFILLER_3_853 VPWR VGND VPWR VGND sky130_ef_sc_hd__decap_12
XFILLER_124_589 VGND VGND VPWR VPWR sky130_fd_sc_hd__decap_8
X_10296_ _04044_ _04045_ VGND VGND VPWR VPWR _04046_ sky130_fd_sc_hd__and2b_1
XFILLER_69_109 VGND VGND VPWR VPWR sky130_fd_sc_hd__decap_3
X_13084_ clknet_leaf_63_clk _00094_ VGND VGND VPWR VPWR u_interface.fifo_data\[15\]\[5\]
+ sky130_fd_sc_hd__dfxtp_1
XFILLER_3_897 VPWR VGND VPWR VGND sky130_ef_sc_hd__decap_12
XFILLER_2_363 VGND VGND VPWR VPWR sky130_fd_sc_hd__fill_1
XFILLER_104_280 VGND VGND VPWR VPWR sky130_fd_sc_hd__decap_8
X_12035_ _05765_ _05766_ VGND VGND VPWR VPWR _05768_ sky130_fd_sc_hd__xnor2_1
XTAP_TAPCELL_ROW_53_1186 VGND VPWR sky130_fd_sc_hd__tapvpwrvgnd_1
XPHY_EDGE_ROW_47_Right_47 VGND VGND VPWR VPWR sky130_fd_sc_hd__decap_3
XFILLER_65_337 VPWR VGND VPWR VGND sky130_ef_sc_hd__decap_12
XFILLER_19_721 VGND VGND VPWR VPWR sky130_fd_sc_hd__decap_6
X_13986_ clknet_leaf_56_clk _00912_ VGND VGND VPWR VPWR u_interface.u_gelu_fp32.u_q16_to_fp32.s2_is_zero
+ sky130_fd_sc_hd__dfxtp_1
XFILLER_19_765 VPWR VGND VPWR VGND sky130_ef_sc_hd__decap_12
X_12937_ _06459_ _06460_ VGND VGND VPWR VPWR _06461_ sky130_fd_sc_hd__xnor2_1
XFILLER_46_584 VGND VGND VPWR VPWR sky130_fd_sc_hd__decap_4
XFILLER_18_253 VPWR VGND VPWR VGND sky130_ef_sc_hd__decap_12
XFILLER_34_713 VPWR VGND VPWR VGND sky130_ef_sc_hd__decap_12
X_12868_ net1623 u_interface.u_gelu_fp32.u_fp32_to_q16.s2_norm_mag\[23\] net818 VGND
+ VGND VPWR VPWR _01012_ sky130_fd_sc_hd__mux2_1
XTAP_TAPCELL_ROW_29_793 VGND VPWR sky130_fd_sc_hd__tapvpwrvgnd_1
XFILLER_33_245 VPWR VGND VPWR VGND sky130_ef_sc_hd__decap_12
XFILLER_34_757 VPWR VGND VPWR VGND sky130_ef_sc_hd__decap_12
X_11819_ _05552_ _05553_ VGND VGND VPWR VPWR _05555_ sky130_fd_sc_hd__xor2_1
X_12799_ u_interface.u_gelu_fp32.u_q16_to_fp32.s3_norm_mag\[28\] _01788_ net296 VGND
+ VGND VPWR VPWR _06416_ sky130_fd_sc_hd__o21ai_1
XPHY_EDGE_ROW_56_Right_56 VGND VGND VPWR VPWR sky130_fd_sc_hd__decap_3
XTAP_TAPCELL_ROW_40_980 VGND VPWR sky130_fd_sc_hd__tapvpwrvgnd_1
X_07010_ net1327 net326 net223 VGND VGND VPWR VPWR _00054_ sky130_fd_sc_hd__mux2_1
XFILLER_134_309 VGND VGND VPWR VPWR sky130_fd_sc_hd__decap_8
XFILLER_128_873 VGND VGND VPWR VPWR sky130_fd_sc_hd__fill_1
XTAP_TAPCELL_ROW_73_1507 VGND VPWR sky130_fd_sc_hd__tapvpwrvgnd_1
X_08961_ _02717_ _02719_ VGND VGND VPWR VPWR _02720_ sky130_fd_sc_hd__and2b_1
XFILLER_115_589 VPWR VGND VPWR VGND sky130_ef_sc_hd__decap_12
XPHY_EDGE_ROW_65_Right_65 VGND VGND VPWR VPWR sky130_fd_sc_hd__decap_3
XFILLER_142_397 VGND VGND VPWR VPWR sky130_fd_sc_hd__fill_1
X_07912_ net775 net97 VGND VGND VPWR VPWR _00671_ sky130_fd_sc_hd__and2_1
X_08892_ _02648_ _02650_ VGND VGND VPWR VPWR _02651_ sky130_fd_sc_hd__nor2_1
XFILLER_96_473 VGND VGND VPWR VPWR sky130_fd_sc_hd__decap_3
XFILLER_68_164 VGND VGND VPWR VPWR sky130_fd_sc_hd__decap_4
XFILLER_57_827 VGND VGND VPWR VPWR sky130_fd_sc_hd__fill_1
X_07843_ net366 net1522 net282 VGND VGND VPWR VPWR _00604_ sky130_fd_sc_hd__mux2_1
XFILLER_110_261 VGND VGND VPWR VPWR sky130_fd_sc_hd__fill_2
XFILLER_96_495 VGND VGND VPWR VPWR sky130_fd_sc_hd__decap_6
XFILLER_83_101 VGND VGND VPWR VPWR sky130_fd_sc_hd__fill_1
XFILLER_68_197 VGND VGND VPWR VPWR sky130_fd_sc_hd__fill_2
XTAP_TAPCELL_ROW_104_2006 VGND VPWR sky130_fd_sc_hd__tapvpwrvgnd_1
X_07774_ net1247 net377 net234 VGND VGND VPWR VPWR _00535_ sky130_fd_sc_hd__mux2_1
XTAP_TAPCELL_ROW_88_1750 VGND VPWR sky130_fd_sc_hd__tapvpwrvgnd_1
XFILLER_83_145 VPWR VGND VPWR VGND sky130_ef_sc_hd__decap_12
XFILLER_83_134 VGND VGND VPWR VPWR sky130_fd_sc_hd__decap_6
XFILLER_17_27 VPWR VGND VPWR VGND sky130_ef_sc_hd__decap_12
X_09513_ net585 net589 net451 net446 VGND VGND VPWR VPWR _03270_ sky130_fd_sc_hd__and4_1
X_06725_ u_interface.fifo_data\[8\]\[12\] u_interface.fifo_data\[9\]\[12\] u_interface.fifo_data\[10\]\[12\]
+ u_interface.fifo_data\[11\]\[12\] net760 net743 VGND VGND VPWR VPWR _01288_ sky130_fd_sc_hd__mux4_1
XFILLER_37_573 VPWR VGND VPWR VGND sky130_ef_sc_hd__decap_12
X_09444_ _03200_ _03201_ _02690_ _02692_ VGND VGND VPWR VPWR _03202_ sky130_fd_sc_hd__o211a_1
X_06656_ net320 _01227_ net725 VGND VGND VPWR VPWR _01228_ sky130_fd_sc_hd__o21a_1
XPHY_EDGE_ROW_74_Right_74 VGND VGND VPWR VPWR sky130_fd_sc_hd__decap_3
XFILLER_33_15 VPWR VGND VPWR VGND sky130_ef_sc_hd__decap_12
XFILLER_40_727 VGND VGND VPWR VPWR sky130_fd_sc_hd__decap_3
X_09375_ net783 _03132_ _03133_ VGND VGND VPWR VPWR _00808_ sky130_fd_sc_hd__and3_1
X_06587_ net954 _01173_ VGND VGND VPWR VPWR _01175_ sky130_fd_sc_hd__nand2_1
XFILLER_52_598 VGND VGND VPWR VPWR sky130_fd_sc_hd__fill_2
X_08326_ _02126_ _02127_ VGND VGND VPWR VPWR _00765_ sky130_fd_sc_hd__nor2_1
XFILLER_20_440 VGND VGND VPWR VPWR sky130_fd_sc_hd__decap_3
X_08257_ u_interface.u_gelu_fp32.s2_data\[1\] u_interface.u_gelu_fp32.s2_data\[0\]
+ u_interface.u_gelu_fp32.s2_data\[3\] u_interface.u_gelu_fp32.s2_data\[2\] VGND VGND
+ VPWR VPWR _02076_ sky130_fd_sc_hd__or4_2
XFILLER_20_462 VGND VGND VPWR VPWR sky130_fd_sc_hd__decap_6
X_07208_ net352 net1566 net260 VGND VGND VPWR VPWR _00248_ sky130_fd_sc_hd__mux2_1
XFILLER_137_169 VPWR VGND VPWR VGND sky130_ef_sc_hd__decap_12
X_08188_ net166 _02021_ _02022_ net162 VGND VGND VPWR VPWR _02023_ sky130_fd_sc_hd__a31oi_1
XFILLER_119_895 VGND VGND VPWR VPWR sky130_fd_sc_hd__fill_1
XTAP_TAPCELL_ROW_115_2179 VGND VPWR sky130_fd_sc_hd__tapvpwrvgnd_1
XTAP_TAPCELL_ROW_115_2168 VGND VPWR sky130_fd_sc_hd__tapvpwrvgnd_1
X_07139_ net1076 net363 net219 VGND VGND VPWR VPWR _00179_ sky130_fd_sc_hd__mux2_1
XFILLER_3_105 VGND VGND VPWR VPWR sky130_fd_sc_hd__decap_6
XPHY_EDGE_ROW_83_Right_83 VGND VGND VPWR VPWR sky130_fd_sc_hd__decap_3
XFILLER_3_149 VPWR VGND VPWR VGND sky130_ef_sc_hd__decap_12
XFILLER_133_364 VGND VGND VPWR VPWR sky130_fd_sc_hd__decap_3
X_10150_ _03896_ _03897_ _03898_ VGND VGND VPWR VPWR _03901_ sky130_fd_sc_hd__and3_1
XFILLER_121_548 VGND VGND VPWR VPWR sky130_fd_sc_hd__decap_8
X_10081_ _03830_ _03831_ _03832_ VGND VGND VPWR VPWR _03833_ sky130_fd_sc_hd__a21oi_1
XFILLER_59_120 VPWR VGND VPWR VGND sky130_ef_sc_hd__decap_12
XTAP_TAPCELL_ROW_7_455 VGND VPWR sky130_fd_sc_hd__tapvpwrvgnd_1
XTAP_TAPCELL_ROW_7_444 VGND VPWR sky130_fd_sc_hd__tapvpwrvgnd_1
XFILLER_58_78 VGND VGND VPWR VPWR sky130_fd_sc_hd__decap_6
XFILLER_101_272 VGND VGND VPWR VPWR sky130_fd_sc_hd__fill_1
X_13840_ clknet_leaf_78_clk _00850_ VGND VGND VPWR VPWR u_interface.u_gelu_fp32.u_synth_top.s3_mult\[59\]
+ sky130_fd_sc_hd__dfxtp_1
X_13771_ clknet_leaf_57_clk _00781_ VGND VGND VPWR VPWR u_interface.u_gelu_fp32.s2_data\[5\]
+ sky130_fd_sc_hd__dfxtp_1
XFILLER_62_329 VGND VGND VPWR VPWR sky130_fd_sc_hd__decap_3
XFILLER_56_882 VGND VGND VPWR VPWR sky130_fd_sc_hd__fill_1
X_10983_ net660 net431 net426 net652 VGND VGND VPWR VPWR _04727_ sky130_fd_sc_hd__a22oi_1
XFILLER_16_713 VPWR VGND VPWR VGND sky130_ef_sc_hd__decap_12
XPHY_EDGE_ROW_92_Right_92 VGND VGND VPWR VPWR sky130_fd_sc_hd__decap_3
X_12722_ _06374_ _06360_ net328 VGND VGND VPWR VPWR _06375_ sky130_fd_sc_hd__mux2_1
XFILLER_55_381 VGND VGND VPWR VPWR sky130_fd_sc_hd__fill_2
XFILLER_15_223 VGND VGND VPWR VPWR sky130_fd_sc_hd__fill_1
XFILLER_16_757 VPWR VGND VPWR VGND sky130_ef_sc_hd__decap_12
XPHY_EDGE_ROW_133_Right_133 VGND VGND VPWR VPWR sky130_fd_sc_hd__decap_3
XTAP_TAPCELL_ROW_26_752 VGND VPWR sky130_fd_sc_hd__tapvpwrvgnd_1
XFILLER_31_727 VGND VGND VPWR VPWR sky130_fd_sc_hd__fill_1
X_12653_ net1197 u_interface.u_gelu_fp32.u_q16_to_fp32.s2_mag\[8\] net805 VGND VGND
+ VPWR VPWR _00889_ sky130_fd_sc_hd__mux2_1
XFILLER_70_373 VPWR VGND VPWR VGND sky130_ef_sc_hd__decap_12
X_12584_ net6 net9 net8 net11 VGND VGND VPWR VPWR _06288_ sky130_fd_sc_hd__or4_1
X_11604_ _05330_ _05339_ _05340_ VGND VGND VPWR VPWR _05342_ sky130_fd_sc_hd__nand3_1
XFILLER_23_81 VPWR VGND VPWR VGND sky130_ef_sc_hd__decap_12
X_11535_ net625 net389 _05272_ VGND VGND VPWR VPWR _05274_ sky130_fd_sc_hd__and3_1
XFILLER_144_629 VPWR VGND VPWR VGND sky130_ef_sc_hd__decap_12
XFILLER_116_309 VPWR VGND VPWR VGND sky130_ef_sc_hd__decap_12
XFILLER_143_106 VGND VGND VPWR VPWR sky130_fd_sc_hd__decap_6
XFILLER_137_681 VGND VGND VPWR VPWR sky130_fd_sc_hd__decap_8
XFILLER_109_383 VGND VGND VPWR VPWR sky130_fd_sc_hd__fill_2
XFILLER_109_361 VGND VGND VPWR VPWR sky130_fd_sc_hd__decap_6
XFILLER_99_52 VGND VGND VPWR VPWR sky130_fd_sc_hd__decap_4
X_13205_ clknet_leaf_66_clk _00215_ VGND VGND VPWR VPWR u_interface.fifo_data\[12\]\[15\]
+ sky130_fd_sc_hd__dfxtp_1
X_11466_ _05203_ _05204_ VGND VGND VPWR VPWR _05206_ sky130_fd_sc_hd__xor2_1
XFILLER_152_651 VGND VGND VPWR VPWR sky130_fd_sc_hd__fill_1
XFILLER_124_331 VPWR VGND VPWR VGND sky130_ef_sc_hd__decap_12
XFILLER_124_320 VGND VGND VPWR VPWR sky130_fd_sc_hd__fill_2
X_10417_ _04162_ _04163_ _04164_ VGND VGND VPWR VPWR _04166_ sky130_fd_sc_hd__nand3_1
XTAP_TAPCELL_ROW_55_1215 VGND VPWR sky130_fd_sc_hd__tapvpwrvgnd_1
X_11397_ _05130_ _05135_ VGND VGND VPWR VPWR _05137_ sky130_fd_sc_hd__xnor2_1
X_13136_ clknet_leaf_49_clk _00146_ VGND VGND VPWR VPWR u_interface.fifo_data\[2\]\[25\]
+ sky130_fd_sc_hd__dfxtp_1
X_10348_ _04087_ _04094_ _04095_ VGND VGND VPWR VPWR _04097_ sky130_fd_sc_hd__nand3_1
X_10279_ _04027_ _04028_ _04015_ VGND VGND VPWR VPWR _04029_ sky130_fd_sc_hd__o21a_1
X_13067_ clknet_leaf_69_clk _00077_ VGND VGND VPWR VPWR u_interface.fifo_data\[14\]\[20\]
+ sky130_fd_sc_hd__dfxtp_1
X_12018_ net692 net701 net401 net397 VGND VGND VPWR VPWR _05751_ sky130_fd_sc_hd__and4_1
XFILLER_38_304 VGND VGND VPWR VPWR sky130_fd_sc_hd__decap_4
XFILLER_78_473 VGND VGND VPWR VPWR sky130_fd_sc_hd__decap_3
XFILLER_66_635 VGND VGND VPWR VPWR sky130_fd_sc_hd__decap_8
XFILLER_38_315 VPWR VGND VPWR VGND sky130_ef_sc_hd__decap_12
XFILLER_81_638 VGND VGND VPWR VPWR sky130_fd_sc_hd__fill_1
X_13969_ clknet_leaf_87_clk net961 VGND VGND VPWR VPWR u_interface.u_gelu_fp32.u_q16_to_fp32.s2_mag\[14\]
+ sky130_fd_sc_hd__dfxtp_1
XFILLER_65_167 VGND VGND VPWR VPWR sky130_fd_sc_hd__fill_1
XFILLER_0_41 VPWR VGND VPWR VGND sky130_ef_sc_hd__decap_12
X_07490_ _01621_ _01622_ net552 VGND VGND VPWR VPWR _01623_ sky130_fd_sc_hd__mux2_1
X_06510_ u_interface.u_gelu_fp32.u_synth_top.s1_x\[15\] VGND VGND VPWR VPWR _01110_
+ sky130_fd_sc_hd__inv_2
XFILLER_0_85 VPWR VGND VPWR VGND sky130_ef_sc_hd__decap_12
XTAP_TAPCELL_ROW_66_1388 VGND VPWR sky130_fd_sc_hd__tapvpwrvgnd_1
XPHY_EDGE_ROW_100_Right_100 VGND VGND VPWR VPWR sky130_fd_sc_hd__decap_3
XTAP_TAPCELL_ROW_66_1399 VGND VPWR sky130_fd_sc_hd__tapvpwrvgnd_1
XFILLER_62_896 VGND VGND VPWR VPWR sky130_fd_sc_hd__decap_6
XFILLER_61_373 VGND VGND VPWR VPWR sky130_fd_sc_hd__decap_6
XFILLER_22_749 VGND VGND VPWR VPWR sky130_fd_sc_hd__decap_6
XFILLER_147_401 VGND VGND VPWR VPWR sky130_fd_sc_hd__decap_8
X_09160_ net583 net496 VGND VGND VPWR VPWR _02919_ sky130_fd_sc_hd__nand2_1
X_09091_ _02847_ _02848_ _02833_ VGND VGND VPWR VPWR _02850_ sky130_fd_sc_hd__a21oi_1
X_08111_ _01942_ _01943_ _01948_ _01952_ VGND VGND VPWR VPWR _01958_ sky130_fd_sc_hd__and4_1
XFILLER_30_793 VPWR VGND VPWR VGND sky130_ef_sc_hd__decap_12
X_08042_ u_interface.u_gelu_fp32.u_fp32_to_q16.s3_frac\[1\] u_interface.u_gelu_fp32.u_fp32_to_q16.s3_frac\[0\]
+ u_interface.u_gelu_fp32.u_fp32_to_q16.s3_frac\[3\] u_interface.u_gelu_fp32.u_fp32_to_q16.s3_frac\[2\]
+ VGND VGND VPWR VPWR _01899_ sky130_fd_sc_hd__or4_1
XFILLER_119_169 VGND VGND VPWR VPWR sky130_fd_sc_hd__decap_4
Xhold901 u_interface.u_gelu_fp32.u_fp32_to_q16.s3_mag\[3\] VGND VGND VPWR VPWR net1766
+ sky130_fd_sc_hd__dlygate4sd3_1
Xhold912 u_interface.u_gelu_fp32.u_fp32_to_q16.s3_frac\[22\] VGND VGND VPWR VPWR net1777
+ sky130_fd_sc_hd__dlygate4sd3_1
XFILLER_116_821 VGND VGND VPWR VPWR sky130_fd_sc_hd__decap_4
XFILLER_116_843 VGND VGND VPWR VPWR sky130_fd_sc_hd__decap_4
Xhold923 u_interface.u_gelu_fp32.u_q16_to_fp32.s3_exp\[2\] VGND VGND VPWR VPWR net1788
+ sky130_fd_sc_hd__dlygate4sd3_1
XFILLER_89_705 VGND VGND VPWR VPWR sky130_fd_sc_hd__fill_1
XFILLER_143_684 VGND VGND VPWR VPWR sky130_fd_sc_hd__fill_2
X_09993_ _03743_ _03745_ _03741_ VGND VGND VPWR VPWR _03746_ sky130_fd_sc_hd__o21a_1
XFILLER_1_609 VGND VGND VPWR VPWR sky130_fd_sc_hd__decap_6
XFILLER_142_194 VGND VGND VPWR VPWR sky130_fd_sc_hd__fill_2
XFILLER_130_334 VGND VGND VPWR VPWR sky130_fd_sc_hd__decap_8
X_08944_ _02701_ _02702_ _02658_ VGND VGND VPWR VPWR _02703_ sky130_fd_sc_hd__or3b_2
XFILLER_115_386 VGND VGND VPWR VPWR sky130_fd_sc_hd__decap_6
XTAP_TAPCELL_ROW_110_2098 VGND VPWR sky130_fd_sc_hd__tapvpwrvgnd_1
XTAP_TAPCELL_ROW_4_403 VGND VPWR sky130_fd_sc_hd__tapvpwrvgnd_1
X_08875_ _02630_ _02633_ VGND VGND VPWR VPWR _02634_ sky130_fd_sc_hd__xnor2_1
XFILLER_97_793 VGND VGND VPWR VPWR sky130_fd_sc_hd__fill_2
XFILLER_84_421 VPWR VGND VPWR VGND sky130_ef_sc_hd__decap_12
XFILLER_69_473 VGND VGND VPWR VPWR sky130_fd_sc_hd__decap_8
XFILLER_56_101 VPWR VGND VPWR VGND sky130_ef_sc_hd__decap_12
XFILLER_28_15 VPWR VGND VPWR VGND sky130_ef_sc_hd__decap_12
XFILLER_29_337 VPWR VGND VPWR VGND sky130_ef_sc_hd__decap_12
X_07826_ net1108 net575 net232 VGND VGND VPWR VPWR _00587_ sky130_fd_sc_hd__mux2_1
XTAP_TAPCELL_ROW_86_1709 VGND VPWR sky130_fd_sc_hd__tapvpwrvgnd_1
X_07757_ u_interface.u_gelu_fp32.u_q16_to_fp32.s3_exp\[2\] u_interface.u_gelu_fp32.u_q16_to_fp32.s3_exp\[3\]
+ _01794_ VGND VGND VPWR VPWR _01798_ sky130_fd_sc_hd__and3_1
XFILLER_71_126 VGND VGND VPWR VPWR sky130_fd_sc_hd__decap_8
X_06708_ _01268_ _01270_ _01273_ net316 VGND VGND VPWR VPWR net140 sky130_fd_sc_hd__a22o_1
X_07688_ u_interface.u_gelu_fp32.u_synth_top.s1_hits\[18\] _01759_ VGND VGND VPWR
+ VPWR _01760_ sky130_fd_sc_hd__or2_1
X_09427_ _03169_ _03183_ VGND VGND VPWR VPWR _03185_ sky130_fd_sc_hd__xor2_1
X_06639_ net733 _01212_ VGND VGND VPWR VPWR _01213_ sky130_fd_sc_hd__or2_1
XFILLER_9_709 VPWR VGND VPWR VGND sky130_ef_sc_hd__decap_12
XFILLER_13_727 VGND VGND VPWR VPWR sky130_fd_sc_hd__fill_1
XTAP_TAPCELL_ROW_23_700 VGND VPWR sky130_fd_sc_hd__tapvpwrvgnd_1
XTAP_TAPCELL_ROW_23_711 VGND VPWR sky130_fd_sc_hd__tapvpwrvgnd_1
XFILLER_40_524 VGND VGND VPWR VPWR sky130_fd_sc_hd__fill_1
X_09358_ _03068_ _03115_ VGND VGND VPWR VPWR _03117_ sky130_fd_sc_hd__and2_1
XTAP_TAPCELL_ROW_117_2208 VGND VPWR sky130_fd_sc_hd__tapvpwrvgnd_1
X_08309_ net531 net1633 _02113_ net799 VGND VGND VPWR VPWR _02115_ sky130_fd_sc_hd__a31o_1
XFILLER_154_905 VPWR VGND VPWR VGND sky130_ef_sc_hd__decap_12
X_09289_ net583 net501 net506 net591 VGND VGND VPWR VPWR _03048_ sky130_fd_sc_hd__a22oi_2
X_11320_ _04973_ _04977_ _05059_ VGND VGND VPWR VPWR _05061_ sky130_fd_sc_hd__a21oi_1
XTAP_TAPCELL_ROW_130_2408 VGND VPWR sky130_fd_sc_hd__tapvpwrvgnd_1
XFILLER_119_692 VGND VGND VPWR VPWR sky130_fd_sc_hd__fill_2
XFILLER_119_670 VGND VGND VPWR VPWR sky130_fd_sc_hd__fill_2
XFILLER_114_3 VGND VGND VPWR VPWR sky130_fd_sc_hd__decap_6
XTAP_TAPCELL_ROW_130_2419 VGND VPWR sky130_fd_sc_hd__tapvpwrvgnd_1
X_11251_ _04983_ _04992_ VGND VGND VPWR VPWR _04993_ sky130_fd_sc_hd__xnor2_1
XFILLER_134_662 VGND VGND VPWR VPWR sky130_fd_sc_hd__fill_1
X_10202_ _03885_ _03886_ _03950_ _03951_ VGND VGND VPWR VPWR _03953_ sky130_fd_sc_hd__a22oi_2
XFILLER_69_55 VGND VGND VPWR VPWR sky130_fd_sc_hd__fill_1
X_11182_ _04922_ _04918_ VGND VGND VPWR VPWR _04924_ sky130_fd_sc_hd__and2b_1
XFILLER_4_469 VGND VGND VPWR VPWR sky130_fd_sc_hd__decap_6
XFILLER_133_194 VGND VGND VPWR VPWR sky130_fd_sc_hd__fill_1
XFILLER_122_857 VGND VGND VPWR VPWR sky130_fd_sc_hd__fill_1
X_10133_ _03863_ _03881_ _03882_ VGND VGND VPWR VPWR _03884_ sky130_fd_sc_hd__nand3_1
XFILLER_79_259 VGND VGND VPWR VPWR sky130_fd_sc_hd__fill_2
XFILLER_125_83 VGND VGND VPWR VPWR sky130_fd_sc_hd__fill_2
XFILLER_121_389 VGND VGND VPWR VPWR sky130_fd_sc_hd__decap_3
X_10064_ _03693_ _03695_ _03694_ VGND VGND VPWR VPWR _03816_ sky130_fd_sc_hd__a21bo_1
XFILLER_87_281 VGND VGND VPWR VPWR sky130_fd_sc_hd__decap_3
XTAP_TAPCELL_ROW_50_1134 VGND VPWR sky130_fd_sc_hd__tapvpwrvgnd_1
XTAP_TAPCELL_ROW_145_2662 VGND VPWR sky130_fd_sc_hd__tapvpwrvgnd_1
XTAP_TAPCELL_ROW_145_2651 VGND VPWR sky130_fd_sc_hd__tapvpwrvgnd_1
XFILLER_85_65 VGND VGND VPWR VPWR sky130_fd_sc_hd__fill_1
XFILLER_75_465 VGND VGND VPWR VPWR sky130_fd_sc_hd__decap_3
X_13823_ clknet_leaf_81_clk _00833_ VGND VGND VPWR VPWR u_interface.u_gelu_fp32.u_synth_top.s3_mult\[41\]
+ sky130_fd_sc_hd__dfxtp_1
XFILLER_35_307 VGND VGND VPWR VPWR sky130_fd_sc_hd__fill_1
X_10966_ _04578_ _04586_ _04585_ VGND VGND VPWR VPWR _04710_ sky130_fd_sc_hd__a21oi_1
X_13754_ clknet_leaf_84_clk _00764_ VGND VGND VPWR VPWR u_interface.u_gelu_fp32.u_q16_to_fp32.s1_mag\[20\]
+ sky130_fd_sc_hd__dfxtp_1
XFILLER_31_502 VGND VGND VPWR VPWR sky130_fd_sc_hd__fill_2
XFILLER_43_362 VGND VGND VPWR VPWR sky130_fd_sc_hd__fill_2
X_13685_ clknet_leaf_12_clk _00695_ VGND VGND VPWR VPWR u_interface.u_gelu_fp32.u_fp32_to_q16.s3_frac\[21\]
+ sky130_fd_sc_hd__dfxtp_1
X_12705_ _01743_ _01749_ _06361_ _01697_ VGND VGND VPWR VPWR _06362_ sky130_fd_sc_hd__o22a_1
X_10897_ _04640_ _04641_ _04528_ VGND VGND VPWR VPWR _04642_ sky130_fd_sc_hd__a21o_1
XTAP_TAPCELL_ROW_48_1096 VGND VPWR sky130_fd_sc_hd__tapvpwrvgnd_1
X_12636_ net186 _06332_ VGND VGND VPWR VPWR _06336_ sky130_fd_sc_hd__nor2_1
XFILLER_70_192 VGND VGND VPWR VPWR sky130_fd_sc_hd__decap_4
XFILLER_31_546 VGND VGND VPWR VPWR sky130_fd_sc_hd__fill_1
XFILLER_129_423 VGND VGND VPWR VPWR sky130_fd_sc_hd__fill_1
XFILLER_31_579 VPWR VGND VPWR VGND sky130_ef_sc_hd__decap_12
X_12567_ net773 net1768 VGND VGND VPWR VPWR _00865_ sky130_fd_sc_hd__and2_1
XFILLER_12_793 VPWR VGND VPWR VGND sky130_ef_sc_hd__decap_12
Xhold208 _01003_ VGND VGND VPWR VPWR net1073 sky130_fd_sc_hd__dlygate4sd3_1
XFILLER_144_415 VGND VGND VPWR VPWR sky130_fd_sc_hd__decap_4
X_12498_ _06081_ _06186_ VGND VGND VPWR VPWR _06223_ sky130_fd_sc_hd__nand2_1
X_11518_ net667 net676 net416 net411 VGND VGND VPWR VPWR _05257_ sky130_fd_sc_hd__nand4_2
Xhold219 u_interface.fifo_data\[2\]\[13\] VGND VGND VPWR VPWR net1084 sky130_fd_sc_hd__dlygate4sd3_1
XFILLER_116_139 VGND VGND VPWR VPWR sky130_fd_sc_hd__fill_1
X_11449_ _05186_ _05187_ VGND VGND VPWR VPWR _05189_ sky130_fd_sc_hd__nor2_1
X_14168_ clknet_leaf_39_clk _01094_ VGND VGND VPWR VPWR u_interface.fifo_data\[1\]\[28\]
+ sky130_fd_sc_hd__dfxtp_1
XFILLER_125_673 VGND VGND VPWR VPWR sky130_fd_sc_hd__fill_1
XFILLER_113_835 VGND VGND VPWR VPWR sky130_fd_sc_hd__decap_4
X_13119_ clknet_leaf_72_clk _00129_ VGND VGND VPWR VPWR u_interface.fifo_data\[2\]\[8\]
+ sky130_fd_sc_hd__dfxtp_1
X_06990_ net1250 net326 net255 VGND VGND VPWR VPWR _00045_ sky130_fd_sc_hd__mux2_1
X_14099_ clknet_leaf_33_clk _01025_ VGND VGND VPWR VPWR u_interface.meta_tuser_pipe\[8\]
+ sky130_fd_sc_hd__dfxtp_1
XFILLER_140_698 VGND VGND VPWR VPWR sky130_fd_sc_hd__fill_2
XFILLER_66_421 VGND VGND VPWR VPWR sky130_fd_sc_hd__decap_3
XFILLER_94_741 VGND VGND VPWR VPWR sky130_fd_sc_hd__fill_1
XFILLER_66_454 VGND VGND VPWR VPWR sky130_fd_sc_hd__decap_4
X_08660_ _02268_ _02418_ _02284_ VGND VGND VPWR VPWR _02425_ sky130_fd_sc_hd__a21o_1
X_07611_ _01114_ net339 net334 VGND VGND VPWR VPWR _01705_ sky130_fd_sc_hd__o21ai_1
XFILLER_81_402 VGND VGND VPWR VPWR sky130_fd_sc_hd__decap_8
XTAP_TAPCELL_ROW_68_1428 VGND VPWR sky130_fd_sc_hd__tapvpwrvgnd_1
XTAP_TAPCELL_ROW_68_1417 VGND VPWR sky130_fd_sc_hd__tapvpwrvgnd_1
X_08591_ _02198_ _02223_ VGND VGND VPWR VPWR _02375_ sky130_fd_sc_hd__xnor2_1
XFILLER_35_841 VPWR VGND VPWR VGND sky130_ef_sc_hd__decap_12
X_07542_ net811 net1726 net305 _01660_ VGND VGND VPWR VPWR _00447_ sky130_fd_sc_hd__a22o_1
XFILLER_35_885 VGND VGND VPWR VPWR sky130_fd_sc_hd__decap_8
X_07473_ _01603_ _01606_ net548 VGND VGND VPWR VPWR _01607_ sky130_fd_sc_hd__mux2_1
XTAP_TAPCELL_ROW_81_1639 VGND VPWR sky130_fd_sc_hd__tapvpwrvgnd_1
XTAP_TAPCELL_ROW_81_1628 VGND VPWR sky130_fd_sc_hd__tapvpwrvgnd_1
XFILLER_50_811 VGND VGND VPWR VPWR sky130_fd_sc_hd__fill_1
X_09212_ _02968_ _02969_ _02970_ VGND VGND VPWR VPWR _02971_ sky130_fd_sc_hd__or3_1
XFILLER_50_855 VGND VGND VPWR VPWR sky130_fd_sc_hd__fill_1
XFILLER_22_568 VPWR VGND VPWR VGND sky130_ef_sc_hd__decap_12
X_09143_ _02829_ _02901_ VGND VGND VPWR VPWR _02902_ sky130_fd_sc_hd__xor2_1
XFILLER_136_916 VGND VGND VPWR VPWR sky130_fd_sc_hd__decap_4
X_09074_ net654 net664 net515 net520 VGND VGND VPWR VPWR _02833_ sky130_fd_sc_hd__and4_1
XFILLER_30_27 VGND VGND VPWR VPWR sky130_fd_sc_hd__fill_1
Xhold720 u_interface.u_gelu_fp32.u_fp32_to_q16.s3_frac\[25\] VGND VGND VPWR VPWR net1585
+ sky130_fd_sc_hd__dlygate4sd3_1
XTAP_TAPCELL_ROW_112_2127 VGND VPWR sky130_fd_sc_hd__tapvpwrvgnd_1
X_08025_ u_interface.u_gelu_fp32.u_fp32_to_q16.s3_mag\[13\] u_interface.u_gelu_fp32.u_fp32_to_q16.s3_mag\[12\]
+ _01880_ VGND VGND VPWR VPWR _01882_ sky130_fd_sc_hd__and3_1
XTAP_TAPCELL_ROW_96_1871 VGND VPWR sky130_fd_sc_hd__tapvpwrvgnd_1
XFILLER_116_651 VGND VGND VPWR VPWR sky130_fd_sc_hd__fill_1
Xhold753 u_interface.u_gelu_fp32.s2_data\[2\] VGND VGND VPWR VPWR net1618 sky130_fd_sc_hd__dlygate4sd3_1
Xhold742 u_interface.u_gelu_fp32.s2_data\[9\] VGND VGND VPWR VPWR net1607 sky130_fd_sc_hd__dlygate4sd3_1
XFILLER_1_417 VPWR VGND VPWR VGND sky130_ef_sc_hd__decap_12
Xhold764 u_interface.u_gelu_fp32.s2_data\[28\] VGND VGND VPWR VPWR net1629 sky130_fd_sc_hd__dlygate4sd3_1
Xhold731 u_interface.fifo_data\[11\]\[8\] VGND VGND VPWR VPWR net1596 sky130_fd_sc_hd__dlygate4sd3_1
Xhold775 _01048_ VGND VGND VPWR VPWR net1640 sky130_fd_sc_hd__dlygate4sd3_1
Xhold797 _00955_ VGND VGND VPWR VPWR net1662 sky130_fd_sc_hd__dlygate4sd3_1
Xhold786 _00886_ VGND VGND VPWR VPWR net1651 sky130_fd_sc_hd__dlygate4sd3_1
X_09976_ _03727_ _03728_ _03617_ _03619_ VGND VGND VPWR VPWR _03729_ sky130_fd_sc_hd__a211oi_1
XFILLER_130_175 VGND VGND VPWR VPWR sky130_fd_sc_hd__fill_2
X_08927_ _02684_ _02685_ _02678_ VGND VGND VPWR VPWR _02686_ sky130_fd_sc_hd__a21o_1
X_08858_ _02614_ _02616_ VGND VGND VPWR VPWR _02617_ sky130_fd_sc_hd__nor2_1
XFILLER_29_145 VPWR VGND VPWR VGND sky130_ef_sc_hd__decap_12
XTAP_TAPCELL_ROW_127_2370 VGND VPWR sky130_fd_sc_hd__tapvpwrvgnd_1
X_07809_ net1413 net370 net231 VGND VGND VPWR VPWR _00570_ sky130_fd_sc_hd__mux2_1
XFILLER_85_796 VGND VGND VPWR VPWR sky130_fd_sc_hd__decap_3
XFILLER_85_785 VGND VGND VPWR VPWR sky130_fd_sc_hd__fill_2
XFILLER_72_413 VGND VGND VPWR VPWR sky130_fd_sc_hd__decap_6
XFILLER_57_476 VGND VGND VPWR VPWR sky130_fd_sc_hd__decap_4
X_08789_ _02498_ _02500_ _02545_ _02546_ VGND VGND VPWR VPWR _02548_ sky130_fd_sc_hd__a211oi_2
XFILLER_55_57 VGND VGND VPWR VPWR sky130_fd_sc_hd__decap_6
X_10820_ _04559_ _04564_ VGND VGND VPWR VPWR _04565_ sky130_fd_sc_hd__nand2_1
XFILLER_55_79 VGND VGND VPWR VPWR sky130_fd_sc_hd__decap_8
XFILLER_25_351 VGND VGND VPWR VPWR sky130_fd_sc_hd__decap_8
XTAP_TAPCELL_ROW_140_2581 VGND VPWR sky130_fd_sc_hd__tapvpwrvgnd_1
XTAP_TAPCELL_ROW_140_2570 VGND VPWR sky130_fd_sc_hd__tapvpwrvgnd_1
X_10751_ net635 net644 net431 net426 VGND VGND VPWR VPWR _04497_ sky130_fd_sc_hd__and4_1
XFILLER_53_682 VGND VGND VPWR VPWR sky130_fd_sc_hd__decap_6
XFILLER_13_502 VGND VGND VPWR VPWR sky130_fd_sc_hd__fill_2
XFILLER_25_373 VGND VGND VPWR VPWR sky130_fd_sc_hd__fill_1
X_13470_ clknet_leaf_63_clk _00480_ VGND VGND VPWR VPWR u_interface.u_gelu_fp32.u_q16_to_fp32.s3_norm_mag\[10\]
+ sky130_fd_sc_hd__dfxtp_1
XFILLER_71_23 VGND VGND VPWR VPWR sky130_fd_sc_hd__fill_2
XFILLER_9_517 VPWR VGND VPWR VGND sky130_ef_sc_hd__decap_12
X_10682_ _04427_ _04428_ VGND VGND VPWR VPWR _04429_ sky130_fd_sc_hd__nor2_1
X_12421_ _06081_ _06147_ VGND VGND VPWR VPWR _06148_ sky130_fd_sc_hd__nand2b_1
XFILLER_40_365 VGND VGND VPWR VPWR sky130_fd_sc_hd__decap_8
XFILLER_138_253 VGND VGND VPWR VPWR sky130_fd_sc_hd__fill_1
X_12352_ net203 _06078_ VGND VGND VPWR VPWR _06080_ sky130_fd_sc_hd__xnor2_2
XFILLER_154_757 VGND VGND VPWR VPWR sky130_fd_sc_hd__fill_2
XFILLER_153_223 VGND VGND VPWR VPWR sky130_fd_sc_hd__fill_1
X_11303_ _05029_ _05042_ VGND VGND VPWR VPWR _05044_ sky130_fd_sc_hd__xnor2_1
XFILLER_4_233 VPWR VGND VPWR VGND sky130_ef_sc_hd__decap_12
X_12283_ net203 _06011_ VGND VGND VPWR VPWR _06012_ sky130_fd_sc_hd__nand2b_1
XFILLER_153_278 VGND VGND VPWR VPWR sky130_fd_sc_hd__fill_2
XFILLER_107_673 VGND VGND VPWR VPWR sky130_fd_sc_hd__fill_1
X_14022_ clknet_leaf_71_clk _00948_ VGND VGND VPWR VPWR u_interface.core_data_out\[8\]
+ sky130_fd_sc_hd__dfxtp_1
X_11234_ _04966_ _04974_ VGND VGND VPWR VPWR _04976_ sky130_fd_sc_hd__and2_1
XFILLER_122_643 VGND VGND VPWR VPWR sky130_fd_sc_hd__fill_1
XFILLER_122_621 VGND VGND VPWR VPWR sky130_fd_sc_hd__fill_2
XFILLER_4_277 VPWR VGND VPWR VGND sky130_ef_sc_hd__decap_12
XFILLER_121_120 VGND VGND VPWR VPWR sky130_fd_sc_hd__decap_4
X_11165_ _04439_ _04907_ VGND VGND VPWR VPWR _04908_ sky130_fd_sc_hd__or2_1
XFILLER_96_64 VGND VGND VPWR VPWR sky130_fd_sc_hd__fill_2
X_10116_ net486 net491 VGND VGND VPWR VPWR _03867_ sky130_fd_sc_hd__or2_1
X_11096_ _04837_ _04838_ VGND VGND VPWR VPWR _04839_ sky130_fd_sc_hd__and2b_1
XFILLER_0_461 VPWR VGND VPWR VGND sky130_ef_sc_hd__decap_12
X_10047_ _03790_ _03798_ VGND VGND VPWR VPWR _03799_ sky130_fd_sc_hd__xnor2_1
XFILLER_48_421 VPWR VGND VPWR VGND sky130_ef_sc_hd__decap_12
Xhold91 u_interface.meta_tlast_pipe\[10\] VGND VGND VPWR VPWR net956 sky130_fd_sc_hd__dlygate4sd3_1
Xhold80 u_interface.fifo_data\[1\]\[11\] VGND VGND VPWR VPWR net945 sky130_fd_sc_hd__dlygate4sd3_1
XFILLER_75_240 VGND VGND VPWR VPWR sky130_fd_sc_hd__decap_8
XFILLER_75_295 VPWR VGND VPWR VGND sky130_ef_sc_hd__decap_12
XFILLER_17_841 VPWR VGND VPWR VGND sky130_ef_sc_hd__decap_12
XFILLER_90_265 VGND VGND VPWR VPWR sky130_fd_sc_hd__fill_2
X_13806_ clknet_leaf_58_clk _00816_ VGND VGND VPWR VPWR u_interface.u_gelu_fp32.u_synth_top.s3_mult\[24\]
+ sky130_fd_sc_hd__dfxtp_1
X_11998_ _05408_ _05729_ VGND VGND VPWR VPWR _05731_ sky130_fd_sc_hd__xnor2_1
X_13737_ clknet_leaf_57_clk _00747_ VGND VGND VPWR VPWR u_interface.u_gelu_fp32.u_q16_to_fp32.s1_mag\[3\]
+ sky130_fd_sc_hd__dfxtp_1
XFILLER_90_276 VGND VGND VPWR VPWR sky130_fd_sc_hd__decap_8
X_10949_ _04683_ _04692_ VGND VGND VPWR VPWR _04693_ sky130_fd_sc_hd__xnor2_1
XTAP_TAPCELL_ROW_63_1336 VGND VPWR sky130_fd_sc_hd__tapvpwrvgnd_1
XFILLER_50_118 VGND VGND VPWR VPWR sky130_fd_sc_hd__decap_6
XFILLER_16_362 VGND VGND VPWR VPWR sky130_fd_sc_hd__fill_2
XFILLER_32_811 VGND VGND VPWR VPWR sky130_fd_sc_hd__fill_1
XTAP_TAPCELL_ROW_63_1347 VGND VPWR sky130_fd_sc_hd__tapvpwrvgnd_1
Xclkbuf_leaf_70_clk clknet_3_5__leaf_clk VGND VGND VPWR VPWR clknet_leaf_70_clk sky130_fd_sc_hd__clkbuf_8
XFILLER_43_181 VGND VGND VPWR VPWR sky130_fd_sc_hd__decap_8
X_13668_ clknet_leaf_14_clk _00678_ VGND VGND VPWR VPWR u_interface.u_gelu_fp32.u_fp32_to_q16.s2_shift\[5\]
+ sky130_fd_sc_hd__dfxtp_1
XTAP_TAPCELL_ROW_14_552 VGND VPWR sky130_fd_sc_hd__tapvpwrvgnd_1
XTAP_TAPCELL_ROW_14_563 VGND VPWR sky130_fd_sc_hd__tapvpwrvgnd_1
X_13599_ clknet_leaf_43_clk _00609_ VGND VGND VPWR VPWR u_interface.fifo_data\[3\]\[14\]
+ sky130_fd_sc_hd__dfxtp_1
XFILLER_77_3 VPWR VGND VPWR VGND sky130_ef_sc_hd__decap_12
X_12619_ u_interface.u_gelu_fp32.u_q16_to_fp32.s1_mag\[9\] net212 net186 _06321_ u_interface.u_gelu_fp32.u_q16_to_fp32.s1_mag\[25\]
+ VGND VGND VPWR VPWR _06322_ sky130_fd_sc_hd__a221o_1
XFILLER_145_724 VGND VGND VPWR VPWR sky130_fd_sc_hd__decap_4
Xgelu_top_835 VGND VGND VPWR VPWR gelu_top_835/HI s_axil_rdata[3] sky130_fd_sc_hd__conb_1
Xgelu_top_857 VGND VGND VPWR VPWR gelu_top_857/HI s_axil_rdata[25] sky130_fd_sc_hd__conb_1
Xgelu_top_846 VGND VGND VPWR VPWR gelu_top_846/HI s_axil_rdata[14] sky130_fd_sc_hd__conb_1
XTAP_TAPCELL_ROW_78_1590 VGND VPWR sky130_fd_sc_hd__tapvpwrvgnd_1
Xfanout518 u_interface.u_gelu_fp32.u_synth_top.s2_dx\[0\] VGND VGND VPWR VPWR net518
+ sky130_fd_sc_hd__clkbuf_2
Xfanout507 net509 VGND VGND VPWR VPWR net507 sky130_fd_sc_hd__clkbuf_2
X_09830_ net472 net665 VGND VGND VPWR VPWR _03584_ sky130_fd_sc_hd__and2_1
Xfanout529 net531 VGND VGND VPWR VPWR net529 sky130_fd_sc_hd__buf_2
XFILLER_140_473 VGND VGND VPWR VPWR sky130_fd_sc_hd__decap_3
XFILLER_113_687 VGND VGND VPWR VPWR sky130_fd_sc_hd__fill_1
XFILLER_112_153 VGND VGND VPWR VPWR sky130_fd_sc_hd__decap_8
X_09761_ _03514_ _03515_ _03408_ _03410_ VGND VGND VPWR VPWR _03516_ sky130_fd_sc_hd__a211oi_1
XFILLER_101_849 VGND VGND VPWR VPWR sky130_fd_sc_hd__decap_4
XTAP_TAPCELL_ROW_91_1790 VGND VPWR sky130_fd_sc_hd__tapvpwrvgnd_1
X_06973_ u_interface.u_gelu_fp32.u_synth_top.s1_x\[31\] net273 VGND VGND VPWR VPWR
+ _01500_ sky130_fd_sc_hd__xnor2_1
X_08712_ _02463_ _02470_ VGND VGND VPWR VPWR _02471_ sky130_fd_sc_hd__and2_1
XFILLER_132_29 VGND VGND VPWR VPWR sky130_fd_sc_hd__decap_6
X_09692_ net601 net451 _03326_ _03325_ VGND VGND VPWR VPWR _03447_ sky130_fd_sc_hd__a31o_1
X_08643_ _02170_ _02253_ _02256_ _02264_ VGND VGND VPWR VPWR _02412_ sky130_fd_sc_hd__a31oi_2
X_08574_ _02214_ net158 _02363_ VGND VGND VPWR VPWR _02364_ sky130_fd_sc_hd__nand3b_1
XFILLER_82_766 VGND VGND VPWR VPWR sky130_fd_sc_hd__fill_2
XFILLER_25_27 VPWR VGND VPWR VGND sky130_ef_sc_hd__decap_12
X_07525_ _01622_ _01615_ net552 VGND VGND VPWR VPWR _01654_ sky130_fd_sc_hd__mux2_1
XFILLER_23_833 VGND VGND VPWR VPWR sky130_fd_sc_hd__decap_6
XFILLER_35_671 VGND VGND VPWR VPWR sky130_fd_sc_hd__fill_1
XFILLER_35_682 VPWR VGND VPWR VGND sky130_ef_sc_hd__decap_12
Xclkbuf_leaf_61_clk clknet_3_4__leaf_clk VGND VGND VPWR VPWR clknet_leaf_61_clk sky130_fd_sc_hd__clkbuf_8
XFILLER_50_641 VGND VGND VPWR VPWR sky130_fd_sc_hd__decap_3
XFILLER_22_332 VGND VGND VPWR VPWR sky130_fd_sc_hd__decap_8
X_07456_ u_interface.u_gelu_fp32.u_fp32_to_q16.s2_norm_mag\[13\] u_interface.u_gelu_fp32.u_fp32_to_q16.s2_norm_mag\[14\]
+ net558 VGND VGND VPWR VPWR _01591_ sky130_fd_sc_hd__mux2_1
XFILLER_10_505 VPWR VGND VPWR VGND sky130_ef_sc_hd__decap_12
XFILLER_22_365 VGND VGND VPWR VPWR sky130_fd_sc_hd__decap_4
XFILLER_23_877 VPWR VGND VPWR VGND sky130_ef_sc_hd__decap_12
XTAP_TAPCELL_ROW_33_861 VGND VPWR sky130_fd_sc_hd__tapvpwrvgnd_1
XTAP_TAPCELL_ROW_98_1911 VGND VPWR sky130_fd_sc_hd__tapvpwrvgnd_1
XTAP_TAPCELL_ROW_98_1900 VGND VPWR sky130_fd_sc_hd__tapvpwrvgnd_1
X_07387_ net1299 net344 net238 VGND VGND VPWR VPWR _00417_ sky130_fd_sc_hd__mux2_1
XFILLER_41_15 VPWR VGND VPWR VGND sky130_ef_sc_hd__decap_12
X_09126_ _02836_ _02838_ _02837_ VGND VGND VPWR VPWR _02885_ sky130_fd_sc_hd__o21ai_1
XFILLER_135_245 VGND VGND VPWR VPWR sky130_fd_sc_hd__decap_4
X_09057_ _02814_ _02815_ VGND VGND VPWR VPWR _02816_ sky130_fd_sc_hd__and2_1
XFILLER_135_278 VGND VGND VPWR VPWR sky130_fd_sc_hd__fill_2
XFILLER_135_267 VGND VGND VPWR VPWR sky130_fd_sc_hd__fill_2
X_08008_ net549 net305 _01655_ net278 VGND VGND VPWR VPWR _01870_ sky130_fd_sc_hd__a31o_1
Xhold572 u_interface.fifo_data\[7\]\[19\] VGND VGND VPWR VPWR net1437 sky130_fd_sc_hd__dlygate4sd3_1
Xhold550 u_interface.fifo_data\[15\]\[7\] VGND VGND VPWR VPWR net1415 sky130_fd_sc_hd__dlygate4sd3_1
XFILLER_104_621 VGND VGND VPWR VPWR sky130_fd_sc_hd__decap_3
Xhold561 u_interface.u_gelu_fp32.u_q16_to_fp32.s3_norm_mag\[2\] VGND VGND VPWR VPWR
+ net1426 sky130_fd_sc_hd__dlygate4sd3_1
XFILLER_1_225 VPWR VGND VPWR VGND sky130_ef_sc_hd__decap_12
XFILLER_2_737 VPWR VGND VPWR VGND sky130_ef_sc_hd__decap_12
Xhold594 u_interface.fifo_data\[7\]\[13\] VGND VGND VPWR VPWR net1459 sky130_fd_sc_hd__dlygate4sd3_1
Xhold583 u_interface.fifo_data\[11\]\[3\] VGND VGND VPWR VPWR net1448 sky130_fd_sc_hd__dlygate4sd3_1
X_09959_ _03710_ _03711_ _03704_ VGND VGND VPWR VPWR _03712_ sky130_fd_sc_hd__a21o_1
XFILLER_106_85 VPWR VGND VPWR VGND sky130_ef_sc_hd__decap_12
XFILLER_106_74 VGND VGND VPWR VPWR sky130_fd_sc_hd__fill_1
XFILLER_66_45 VGND VGND VPWR VPWR sky130_fd_sc_hd__decap_6
XFILLER_58_752 VGND VGND VPWR VPWR sky130_fd_sc_hd__decap_4
X_12970_ u_interface.fifo_count\[4\] _06467_ VGND VGND VPWR VPWR _06488_ sky130_fd_sc_hd__nand2_1
XTAP_TAPCELL_ROW_142_2610 VGND VPWR sky130_fd_sc_hd__tapvpwrvgnd_1
XTAP_TAPCELL_ROW_125_2329 VGND VPWR sky130_fd_sc_hd__tapvpwrvgnd_1
XFILLER_57_273 VGND VGND VPWR VPWR sky130_fd_sc_hd__decap_6
XFILLER_45_446 VGND VGND VPWR VPWR sky130_fd_sc_hd__fill_2
XFILLER_17_137 VPWR VGND VPWR VGND sky130_ef_sc_hd__decap_12
X_11921_ _05579_ net204 _05585_ VGND VGND VPWR VPWR _05655_ sky130_fd_sc_hd__o21ba_1
XFILLER_72_232 VGND VGND VPWR VPWR sky130_fd_sc_hd__decap_8
X_11852_ _05514_ _05516_ VGND VGND VPWR VPWR _05587_ sky130_fd_sc_hd__nand2_1
X_10803_ _04547_ _04548_ VGND VGND VPWR VPWR _04549_ sky130_fd_sc_hd__nand2_1
XFILLER_72_298 VGND VGND VPWR VPWR sky130_fd_sc_hd__decap_3
XFILLER_72_276 VGND VGND VPWR VPWR sky130_fd_sc_hd__fill_1
XFILLER_14_811 VGND VGND VPWR VPWR sky130_fd_sc_hd__fill_1
XFILLER_26_693 VGND VGND VPWR VPWR sky130_fd_sc_hd__decap_6
Xclkbuf_leaf_52_clk clknet_3_7__leaf_clk VGND VGND VPWR VPWR clknet_leaf_52_clk sky130_fd_sc_hd__clkbuf_8
X_13522_ clknet_leaf_54_clk _00532_ VGND VGND VPWR VPWR u_interface.fifo_data\[5\]\[1\]
+ sky130_fd_sc_hd__dfxtp_1
XFILLER_53_490 VGND VGND VPWR VPWR sky130_fd_sc_hd__fill_1
XTAP_TAPCELL_ROW_45_1055 VGND VPWR sky130_fd_sc_hd__tapvpwrvgnd_1
X_11783_ _05512_ _05516_ _05517_ VGND VGND VPWR VPWR _05519_ sky130_fd_sc_hd__nand3_1
X_10734_ _04477_ _04478_ _04479_ VGND VGND VPWR VPWR _04480_ sky130_fd_sc_hd__a21oi_1
XFILLER_15_93 VPWR VGND VPWR VGND sky130_ef_sc_hd__decap_12
X_13453_ clknet_leaf_9_clk _00463_ VGND VGND VPWR VPWR u_interface.u_gelu_fp32.u_fp32_to_q16.s3_mag\[24\]
+ sky130_fd_sc_hd__dfxtp_1
X_10665_ _04391_ _04392_ _04409_ _04410_ VGND VGND VPWR VPWR _04412_ sky130_fd_sc_hd__and4_1
XTAP_TAPCELL_ROW_11_511 VGND VPWR sky130_fd_sc_hd__tapvpwrvgnd_1
XFILLER_40_195 VGND VGND VPWR VPWR sky130_fd_sc_hd__fill_1
X_13384_ clknet_leaf_44_clk _00394_ VGND VGND VPWR VPWR u_interface.fifo_data\[7\]\[29\]
+ sky130_fd_sc_hd__dfxtp_1
X_12404_ net200 _06130_ VGND VGND VPWR VPWR _06131_ sky130_fd_sc_hd__nor2_1
XTAP_TAPCELL_ROW_153_2783 VGND VPWR sky130_fd_sc_hd__tapvpwrvgnd_1
XFILLER_126_223 VGND VGND VPWR VPWR sky130_fd_sc_hd__decap_4
X_10596_ net473 net722 VGND VGND VPWR VPWR _04343_ sky130_fd_sc_hd__nand2_1
X_12335_ _06060_ _06063_ VGND VGND VPWR VPWR _06064_ sky130_fd_sc_hd__nor2_1
XFILLER_5_553 VGND VGND VPWR VPWR sky130_fd_sc_hd__decap_6
XFILLER_31_81 VGND VGND VPWR VPWR sky130_fd_sc_hd__decap_8
XFILLER_147_92 VGND VGND VPWR VPWR sky130_fd_sc_hd__fill_2
XFILLER_5_597 VPWR VGND VPWR VGND sky130_ef_sc_hd__decap_12
X_12266_ _05924_ _05927_ _05994_ VGND VGND VPWR VPWR _05996_ sky130_fd_sc_hd__a21oi_1
X_14005_ clknet_leaf_54_clk net1541 VGND VGND VPWR VPWR u_interface.u_gelu_fp32.u_q16_to_fp32.s3_exp\[1\]
+ sky130_fd_sc_hd__dfxtp_1
X_11217_ _04955_ _04956_ _04957_ VGND VGND VPWR VPWR _04959_ sky130_fd_sc_hd__nand3_1
X_12197_ _05926_ _05927_ VGND VGND VPWR VPWR _05928_ sky130_fd_sc_hd__nand2_1
XFILLER_110_613 VPWR VGND VPWR VGND sky130_ef_sc_hd__decap_12
X_11148_ _04889_ _04890_ VGND VGND VPWR VPWR _04891_ sky130_fd_sc_hd__or2_1
XFILLER_96_869 VGND VGND VPWR VPWR sky130_fd_sc_hd__decap_6
XFILLER_95_357 VGND VGND VPWR VPWR sky130_fd_sc_hd__fill_2
X_11079_ _04813_ _04821_ VGND VGND VPWR VPWR _04822_ sky130_fd_sc_hd__xnor2_1
XFILLER_49_785 VGND VGND VPWR VPWR sky130_fd_sc_hd__fill_1
XFILLER_63_210 VPWR VGND VPWR VGND sky130_ef_sc_hd__decap_12
XFILLER_91_552 VGND VGND VPWR VPWR sky130_fd_sc_hd__decap_8
XTAP_TAPCELL_ROW_19_633 VGND VPWR sky130_fd_sc_hd__tapvpwrvgnd_1
XTAP_TAPCELL_ROW_19_644 VGND VPWR sky130_fd_sc_hd__tapvpwrvgnd_1
XFILLER_17_671 VGND VGND VPWR VPWR sky130_fd_sc_hd__fill_1
X_07310_ net1389 net370 net255 VGND VGND VPWR VPWR _00340_ sky130_fd_sc_hd__mux2_1
Xclkbuf_leaf_43_clk clknet_3_6__leaf_clk VGND VGND VPWR VPWR clknet_leaf_43_clk sky130_fd_sc_hd__clkbuf_8
X_08290_ _02099_ _02100_ VGND VGND VPWR VPWR _00756_ sky130_fd_sc_hd__nor2_1
XFILLER_20_825 VPWR VGND VPWR VGND sky130_ef_sc_hd__decap_12
X_07241_ net1374 net375 net250 VGND VGND VPWR VPWR _00273_ sky130_fd_sc_hd__mux2_1
XTAP_TAPCELL_ROW_30_820 VGND VPWR sky130_fd_sc_hd__tapvpwrvgnd_1
X_07172_ net1335 net360 net262 VGND VGND VPWR VPWR _00212_ sky130_fd_sc_hd__mux2_1
XFILLER_20_869 VPWR VGND VPWR VGND sky130_ef_sc_hd__decap_12
XFILLER_8_380 VPWR VGND VPWR VGND sky130_ef_sc_hd__decap_12
XTAP_TAPCELL_ROW_76_1549 VGND VPWR sky130_fd_sc_hd__tapvpwrvgnd_1
XFILLER_132_237 VGND VGND VPWR VPWR sky130_fd_sc_hd__decap_4
XFILLER_132_215 VGND VGND VPWR VPWR sky130_fd_sc_hd__fill_2
XTAP_TAPCELL_ROW_93_1830 VGND VPWR sky130_fd_sc_hd__tapvpwrvgnd_1
Xfanout304 net305 VGND VGND VPWR VPWR net304 sky130_fd_sc_hd__buf_2
Xfanout326 u_interface.meta_tuser_pipe\[11\] VGND VGND VPWR VPWR net326 sky130_fd_sc_hd__clkbuf_2
Xfanout315 _01109_ VGND VGND VPWR VPWR net315 sky130_fd_sc_hd__buf_2
Xfanout348 net349 VGND VGND VPWR VPWR net348 sky130_fd_sc_hd__clkbuf_2
X_09813_ net581 net593 net437 net433 VGND VGND VPWR VPWR _03567_ sky130_fd_sc_hd__and4_1
Xfanout337 u_interface.u_gelu_fp32.u_q16_to_fp32.s2_clz\[0\] VGND VGND VPWR VPWR net337
+ sky130_fd_sc_hd__clkbuf_4
XFILLER_59_505 VPWR VGND VPWR VGND sky130_ef_sc_hd__decap_12
Xfanout359 u_interface.core_data_out\[13\] VGND VGND VPWR VPWR net359 sky130_fd_sc_hd__buf_1
XFILLER_98_195 VGND VGND VPWR VPWR sky130_fd_sc_hd__fill_1
XFILLER_86_357 VGND VGND VPWR VPWR sky130_fd_sc_hd__decap_3
X_09744_ _03496_ _03498_ _03393_ _03395_ VGND VGND VPWR VPWR _03499_ sky130_fd_sc_hd__a211oi_1
XFILLER_86_368 VGND VGND VPWR VPWR sky130_fd_sc_hd__decap_4
X_06956_ _01483_ _01485_ VGND VGND VPWR VPWR _01486_ sky130_fd_sc_hd__nor2_1
XFILLER_39_240 VGND VGND VPWR VPWR sky130_fd_sc_hd__decap_3
XTAP_TAPCELL_ROW_107_2048 VGND VPWR sky130_fd_sc_hd__tapvpwrvgnd_1
X_09675_ net482 net681 VGND VGND VPWR VPWR _03430_ sky130_fd_sc_hd__nand2_1
XFILLER_100_178 VGND VGND VPWR VPWR sky130_fd_sc_hd__fill_2
X_06887_ u_interface.u_gelu_fp32.u_synth_top.s1_hits\[18\] u_interface.u_gelu_fp32.u_synth_top.s1_hits\[16\]
+ VGND VGND VPWR VPWR _01430_ sky130_fd_sc_hd__or2_1
XFILLER_82_530 VGND VGND VPWR VPWR sky130_fd_sc_hd__fill_2
XFILLER_27_424 VGND VGND VPWR VPWR sky130_fd_sc_hd__fill_1
XFILLER_36_15 VPWR VGND VPWR VGND sky130_ef_sc_hd__decap_12
XFILLER_94_390 VGND VGND VPWR VPWR sky130_fd_sc_hd__decap_4
X_08626_ net157 _02398_ _02399_ VGND VGND VPWR VPWR _02400_ sky130_fd_sc_hd__nand3_1
XTAP_TAPCELL_ROW_38_942 VGND VPWR sky130_fd_sc_hd__tapvpwrvgnd_1
XFILLER_82_574 VGND VGND VPWR VPWR sky130_fd_sc_hd__fill_1
XFILLER_54_265 VGND VGND VPWR VPWR sky130_fd_sc_hd__decap_4
XFILLER_42_405 VGND VGND VPWR VPWR sky130_fd_sc_hd__fill_1
Xclkbuf_leaf_34_clk clknet_3_6__leaf_clk VGND VGND VPWR VPWR clknet_leaf_34_clk sky130_fd_sc_hd__clkbuf_8
XTAP_TAPCELL_ROW_120_2259 VGND VPWR sky130_fd_sc_hd__tapvpwrvgnd_1
XTAP_TAPCELL_ROW_120_2248 VGND VPWR sky130_fd_sc_hd__tapvpwrvgnd_1
XFILLER_23_641 VPWR VGND VPWR VGND sky130_ef_sc_hd__decap_12
X_08557_ _02302_ _02321_ VGND VGND VPWR VPWR _02348_ sky130_fd_sc_hd__xor2_1
XFILLER_42_438 VGND VGND VPWR VPWR sky130_fd_sc_hd__fill_1
XFILLER_146_6 VPWR VGND VPWR VGND sky130_ef_sc_hd__decap_12
X_07508_ _01638_ VGND VGND VPWR VPWR _01639_ sky130_fd_sc_hd__inv_2
XFILLER_23_685 VPWR VGND VPWR VGND sky130_ef_sc_hd__decap_12
X_08488_ _02277_ _02278_ VGND VGND VPWR VPWR _02279_ sky130_fd_sc_hd__and2_1
X_07439_ u_interface.u_gelu_fp32.u_fp32_to_q16.s2_norm_mag\[23\] u_interface.u_gelu_fp32.u_fp32_to_q16.s2_norm_mag\[24\]
+ net559 VGND VGND VPWR VPWR _01574_ sky130_fd_sc_hd__mux2_1
XTAP_TAPCELL_ROW_102_1970 VGND VPWR sky130_fd_sc_hd__tapvpwrvgnd_1
XFILLER_22_173 VGND VGND VPWR VPWR sky130_fd_sc_hd__decap_4
XFILLER_155_307 VGND VGND VPWR VPWR sky130_fd_sc_hd__fill_1
XFILLER_149_871 VGND VGND VPWR VPWR sky130_fd_sc_hd__decap_8
X_10450_ _04195_ _04197_ _04194_ VGND VGND VPWR VPWR _04199_ sky130_fd_sc_hd__a21oi_1
XFILLER_6_317 VGND VGND VPWR VPWR sky130_fd_sc_hd__fill_1
XFILLER_22_195 VGND VGND VPWR VPWR sky130_fd_sc_hd__fill_1
XFILLER_148_392 VPWR VGND VPWR VGND sky130_ef_sc_hd__decap_12
X_09109_ _02812_ _02818_ _02867_ VGND VGND VPWR VPWR _02868_ sky130_fd_sc_hd__a21oi_1
XFILLER_10_379 VGND VGND VPWR VPWR sky130_fd_sc_hd__fill_1
XTAP_TAPCELL_ROW_135_2491 VGND VPWR sky130_fd_sc_hd__tapvpwrvgnd_1
XFILLER_108_267 VGND VGND VPWR VPWR sky130_fd_sc_hd__decap_8
X_10381_ _04124_ _04127_ _04128_ VGND VGND VPWR VPWR _04130_ sky130_fd_sc_hd__nand3_1
XFILLER_2_501 VPWR VGND VPWR VGND sky130_ef_sc_hd__decap_12
X_12120_ _05849_ _05850_ VGND VGND VPWR VPWR _05852_ sky130_fd_sc_hd__xnor2_1
Xhold380 u_interface.u_gelu_fp32.u_fp32_to_q16.s1_mant\[19\] VGND VGND VPWR VPWR net1245
+ sky130_fd_sc_hd__dlygate4sd3_1
XFILLER_7_3 VPWR VGND VPWR VGND sky130_ef_sc_hd__decap_12
XFILLER_2_545 VPWR VGND VPWR VGND sky130_ef_sc_hd__decap_12
X_12051_ _05781_ _05782_ VGND VGND VPWR VPWR _05784_ sky130_fd_sc_hd__xor2_1
Xhold391 u_interface.fifo_data\[4\]\[11\] VGND VGND VPWR VPWR net1256 sky130_fd_sc_hd__dlygate4sd3_1
X_11002_ _04744_ _04745_ VGND VGND VPWR VPWR _04746_ sky130_fd_sc_hd__nor2_1
XFILLER_2_589 VPWR VGND VPWR VGND sky130_ef_sc_hd__decap_12
XFILLER_131_281 VGND VGND VPWR VPWR sky130_fd_sc_hd__fill_2
X_12953_ _06470_ _06471_ u_interface.fifo_count\[0\] VGND VGND VPWR VPWR _06474_ sky130_fd_sc_hd__o21bai_1
XFILLER_18_413 VGND VGND VPWR VPWR sky130_fd_sc_hd__decap_6
X_11904_ net194 _05559_ _05558_ VGND VGND VPWR VPWR _05639_ sky130_fd_sc_hd__a21oi_1
XFILLER_34_917 VGND VGND VPWR VPWR sky130_fd_sc_hd__decap_4
X_12884_ net791 net927 VGND VGND VPWR VPWR _01026_ sky130_fd_sc_hd__and2_1
XFILLER_45_276 VGND VGND VPWR VPWR sky130_fd_sc_hd__fill_1
XFILLER_33_405 VGND VGND VPWR VPWR sky130_fd_sc_hd__decap_6
Xclkbuf_leaf_25_clk clknet_3_1__leaf_clk VGND VGND VPWR VPWR clknet_leaf_25_clk sky130_fd_sc_hd__clkbuf_8
X_11835_ net184 _05569_ VGND VGND VPWR VPWR _05570_ sky130_fd_sc_hd__xnor2_1
X_11766_ net429 net424 net719 VGND VGND VPWR VPWR _05502_ sky130_fd_sc_hd__o21ai_1
XTAP_TAPCELL_ROW_155_2834 VGND VPWR sky130_fd_sc_hd__tapvpwrvgnd_1
XTAP_TAPCELL_ROW_155_2823 VGND VPWR sky130_fd_sc_hd__tapvpwrvgnd_1
XTAP_TAPCELL_ROW_155_2812 VGND VPWR sky130_fd_sc_hd__tapvpwrvgnd_1
X_13505_ clknet_leaf_3_clk _00515_ VGND VGND VPWR VPWR u_interface.u_gelu_fp32.u_synth_top.s2_m\[6\]
+ sky130_fd_sc_hd__dfxtp_1
X_10717_ net464 net712 net722 net468 VGND VGND VPWR VPWR _04463_ sky130_fd_sc_hd__a22o_1
XFILLER_9_111 VGND VGND VPWR VPWR sky130_fd_sc_hd__fill_1
X_13436_ clknet_leaf_11_clk _00446_ VGND VGND VPWR VPWR u_interface.u_gelu_fp32.u_fp32_to_q16.s3_mag\[7\]
+ sky130_fd_sc_hd__dfxtp_1
X_11697_ _05432_ _05433_ _05429_ VGND VGND VPWR VPWR _05434_ sky130_fd_sc_hd__a21o_1
XFILLER_155_841 VGND VGND VPWR VPWR sky130_fd_sc_hd__fill_2
X_10648_ net586 net405 net400 net579 VGND VGND VPWR VPWR _04395_ sky130_fd_sc_hd__a22o_1
XFILLER_155_874 VGND VGND VPWR VPWR sky130_fd_sc_hd__decap_4
XFILLER_155_863 VGND VGND VPWR VPWR sky130_fd_sc_hd__fill_1
X_13367_ clknet_leaf_63_clk _00377_ VGND VGND VPWR VPWR u_interface.fifo_data\[7\]\[12\]
+ sky130_fd_sc_hd__dfxtp_1
X_10579_ _04324_ _04325_ _03979_ VGND VGND VPWR VPWR _04326_ sky130_fd_sc_hd__a21o_1
X_13298_ clknet_leaf_45_clk _00308_ VGND VGND VPWR VPWR u_interface.fifo_data\[8\]\[7\]
+ sky130_fd_sc_hd__dfxtp_1
XTAP_TAPCELL_ROW_58_1268 VGND VPWR sky130_fd_sc_hd__tapvpwrvgnd_1
XTAP_TAPCELL_ROW_58_1257 VGND VPWR sky130_fd_sc_hd__tapvpwrvgnd_1
XFILLER_5_383 VGND VGND VPWR VPWR sky130_fd_sc_hd__fill_2
X_12318_ _05942_ _05983_ _05982_ VGND VGND VPWR VPWR _06047_ sky130_fd_sc_hd__o21ai_1
X_12249_ _05976_ _05977_ VGND VGND VPWR VPWR _05979_ sky130_fd_sc_hd__xnor2_1
XFILLER_110_421 VGND VGND VPWR VPWR sky130_fd_sc_hd__fill_2
XTAP_TAPCELL_ROW_71_1479 VGND VPWR sky130_fd_sc_hd__tapvpwrvgnd_1
XTAP_TAPCELL_ROW_71_1468 VGND VPWR sky130_fd_sc_hd__tapvpwrvgnd_1
XFILLER_68_335 VGND VGND VPWR VPWR sky130_fd_sc_hd__decap_4
X_06810_ u_interface.fifo_data\[4\]\[22\] u_interface.fifo_data\[5\]\[22\] u_interface.fifo_data\[6\]\[22\]
+ u_interface.fifo_data\[7\]\[22\] net767 net750 VGND VGND VPWR VPWR _01363_ sky130_fd_sc_hd__mux4_1
XFILLER_96_699 VGND VGND VPWR VPWR sky130_fd_sc_hd__fill_1
XFILLER_96_677 VGND VGND VPWR VPWR sky130_fd_sc_hd__fill_2
XFILLER_95_154 VGND VGND VPWR VPWR sky130_fd_sc_hd__decap_3
X_07790_ net1200 net344 net234 VGND VGND VPWR VPWR _00551_ sky130_fd_sc_hd__mux2_1
XPHY_EDGE_ROW_147_Right_147 VGND VGND VPWR VPWR sky130_fd_sc_hd__decap_3
X_06741_ u_interface.fifo_data\[8\]\[14\] u_interface.fifo_data\[9\]\[14\] u_interface.fifo_data\[10\]\[14\]
+ u_interface.fifo_data\[11\]\[14\] net766 net749 VGND VGND VPWR VPWR _01302_ sky130_fd_sc_hd__mux4_1
XFILLER_110_487 VGND VGND VPWR VPWR sky130_fd_sc_hd__decap_4
XFILLER_95_176 VPWR VGND VPWR VGND sky130_ef_sc_hd__decap_12
X_09460_ _03216_ _03217_ _02673_ _02675_ VGND VGND VPWR VPWR _03218_ sky130_fd_sc_hd__o211a_1
XFILLER_37_766 VGND VGND VPWR VPWR sky130_fd_sc_hd__fill_2
X_08411_ u_interface.u_gelu_fp32.u_synth_top.s3_mult\[21\] u_interface.u_gelu_fp32.u_synth_top.s3_b\[5\]
+ VGND VGND VPWR VPWR _02202_ sky130_fd_sc_hd__nand2_1
X_06672_ net729 _01239_ net725 VGND VGND VPWR VPWR _01242_ sky130_fd_sc_hd__o21a_1
XFILLER_52_736 VGND VGND VPWR VPWR sky130_fd_sc_hd__decap_4
XTAP_TAPCELL_ROW_35_901 VGND VPWR sky130_fd_sc_hd__tapvpwrvgnd_1
Xclkbuf_leaf_16_clk clknet_3_2__leaf_clk VGND VGND VPWR VPWR clknet_leaf_16_clk sky130_fd_sc_hd__clkbuf_8
X_09391_ _03146_ _03148_ VGND VGND VPWR VPWR _03149_ sky130_fd_sc_hd__nor2_1
XFILLER_91_393 VGND VGND VPWR VPWR sky130_fd_sc_hd__decap_3
X_08342_ _02138_ _02139_ VGND VGND VPWR VPWR _00769_ sky130_fd_sc_hd__nor2_1
XFILLER_149_123 VGND VGND VPWR VPWR sky130_fd_sc_hd__fill_1
X_08273_ net533 net1643 _02086_ net805 VGND VGND VPWR VPWR _02088_ sky130_fd_sc_hd__a31o_1
XFILLER_32_493 VPWR VGND VPWR VGND sky130_ef_sc_hd__decap_12
X_07224_ net1 net143 VGND VGND VPWR VPWR _01527_ sky130_fd_sc_hd__nand2_1
XFILLER_149_167 VGND VGND VPWR VPWR sky130_fd_sc_hd__fill_1
XFILLER_137_307 VGND VGND VPWR VPWR sky130_fd_sc_hd__decap_8
XFILLER_146_830 VGND VGND VPWR VPWR sky130_fd_sc_hd__fill_1
XFILLER_20_699 VGND VGND VPWR VPWR sky130_fd_sc_hd__fill_1
X_07155_ net1355 net569 net218 VGND VGND VPWR VPWR _00195_ sky130_fd_sc_hd__mux2_1
X_07086_ net1199 net374 net226 VGND VGND VPWR VPWR _00126_ sky130_fd_sc_hd__mux2_1
XFILLER_113_281 VPWR VGND VPWR VGND sky130_ef_sc_hd__decap_12
Xfanout156 net159 VGND VGND VPWR VPWR net156 sky130_fd_sc_hd__buf_2
X_07988_ net545 net305 _01598_ VGND VGND VPWR VPWR _01856_ sky130_fd_sc_hd__and3_1
Xfanout167 _01896_ VGND VGND VPWR VPWR net167 sky130_fd_sc_hd__clkbuf_2
Xfanout189 _03757_ VGND VGND VPWR VPWR net189 sky130_fd_sc_hd__clkbuf_4
XFILLER_47_519 VGND VGND VPWR VPWR sky130_fd_sc_hd__decap_8
Xfanout178 _04921_ VGND VGND VPWR VPWR net178 sky130_fd_sc_hd__dlymetal6s2s_1
XPHY_EDGE_ROW_114_Right_114 VGND VGND VPWR VPWR sky130_fd_sc_hd__decap_3
X_09727_ _03171_ _03480_ VGND VGND VPWR VPWR _03482_ sky130_fd_sc_hd__xnor2_1
X_06939_ _01471_ _01472_ VGND VGND VPWR VPWR _00024_ sky130_fd_sc_hd__nor2_1
XFILLER_75_839 VGND VGND VPWR VPWR sky130_fd_sc_hd__fill_1
XFILLER_68_891 VGND VGND VPWR VPWR sky130_fd_sc_hd__decap_4
XFILLER_83_861 VGND VGND VPWR VPWR sky130_fd_sc_hd__fill_1
XFILLER_55_541 VGND VGND VPWR VPWR sky130_fd_sc_hd__decap_3
XTAP_TAPCELL_ROW_2_364 VGND VPWR sky130_fd_sc_hd__tapvpwrvgnd_1
XFILLER_16_917 VGND VGND VPWR VPWR sky130_fd_sc_hd__decap_4
XFILLER_28_755 VGND VGND VPWR VPWR sky130_fd_sc_hd__fill_1
X_09658_ _03240_ _03242_ _03411_ _03412_ VGND VGND VPWR VPWR _03414_ sky130_fd_sc_hd__a211oi_2
XTAP_TAPCELL_ROW_2_375 VGND VPWR sky130_fd_sc_hd__tapvpwrvgnd_1
XFILLER_15_405 VGND VGND VPWR VPWR sky130_fd_sc_hd__fill_2
X_09589_ net462 net612 _03275_ _03273_ VGND VGND VPWR VPWR _03345_ sky130_fd_sc_hd__a31o_1
XFILLER_82_393 VGND VGND VPWR VPWR sky130_fd_sc_hd__decap_3
X_08609_ net158 _02387_ VGND VGND VPWR VPWR _02388_ sky130_fd_sc_hd__nand2_1
XFILLER_63_57 VPWR VGND VPWR VGND sky130_ef_sc_hd__decap_12
XFILLER_63_46 VGND VGND VPWR VPWR sky130_fd_sc_hd__fill_2
XFILLER_63_35 VGND VGND VPWR VPWR sky130_fd_sc_hd__fill_1
XFILLER_15_449 VPWR VGND VPWR VGND sky130_ef_sc_hd__decap_12
XFILLER_31_909 VGND VGND VPWR VPWR sky130_fd_sc_hd__decap_8
X_11620_ net666 net406 VGND VGND VPWR VPWR _05358_ sky130_fd_sc_hd__nand2_1
XFILLER_42_279 VGND VGND VPWR VPWR sky130_fd_sc_hd__fill_1
XTAP_TAPCELL_ROW_137_2520 VGND VPWR sky130_fd_sc_hd__tapvpwrvgnd_1
XTAP_TAPCELL_ROW_100_1929 VGND VPWR sky130_fd_sc_hd__tapvpwrvgnd_1
XFILLER_23_493 VGND VGND VPWR VPWR sky130_fd_sc_hd__decap_8
XTAP_TAPCELL_ROW_42_1003 VGND VPWR sky130_fd_sc_hd__tapvpwrvgnd_1
X_11551_ _05287_ _05288_ VGND VGND VPWR VPWR _05290_ sky130_fd_sc_hd__nor2_1
XTAP_TAPCELL_ROW_42_1014 VGND VPWR sky130_fd_sc_hd__tapvpwrvgnd_1
XTAP_TAPCELL_ROW_137_2531 VGND VPWR sky130_fd_sc_hd__tapvpwrvgnd_1
XFILLER_129_819 VPWR VGND VPWR VGND sky130_ef_sc_hd__decap_12
X_10502_ _04247_ _04248_ _04249_ VGND VGND VPWR VPWR _04250_ sky130_fd_sc_hd__a21oi_1
XFILLER_10_121 VPWR VGND VPWR VGND sky130_ef_sc_hd__decap_12
XFILLER_7_615 VGND VGND VPWR VPWR sky130_fd_sc_hd__fill_1
XFILLER_137_841 VGND VGND VPWR VPWR sky130_fd_sc_hd__decap_3
X_11482_ _05136_ _05138_ VGND VGND VPWR VPWR _05221_ sky130_fd_sc_hd__or2_1
XFILLER_10_165 VPWR VGND VPWR VGND sky130_ef_sc_hd__decap_12
XTAP_TAPCELL_ROW_21_672 VGND VPWR sky130_fd_sc_hd__tapvpwrvgnd_1
XTAP_TAPCELL_ROW_150_2731 VGND VPWR sky130_fd_sc_hd__tapvpwrvgnd_1
X_10433_ _04104_ _04105_ _04179_ _04180_ VGND VGND VPWR VPWR _04182_ sky130_fd_sc_hd__nor4_1
X_13221_ clknet_leaf_75_clk _00231_ VGND VGND VPWR VPWR u_interface.fifo_data\[12\]\[31\]
+ sky130_fd_sc_hd__dfxtp_1
XTAP_TAPCELL_ROW_150_2742 VGND VPWR sky130_fd_sc_hd__tapvpwrvgnd_1
X_13152_ clknet_leaf_36_clk _00162_ VGND VGND VPWR VPWR u_interface.fifo_tlast\[5\]
+ sky130_fd_sc_hd__dfxtp_1
X_10364_ net465 net469 net688 net699 VGND VGND VPWR VPWR _04113_ sky130_fd_sc_hd__nand4_1
XFILLER_3_821 VPWR VGND VPWR VGND sky130_ef_sc_hd__decap_12
XFILLER_12_83 VGND VGND VPWR VPWR sky130_fd_sc_hd__fill_1
XFILLER_152_877 VGND VGND VPWR VPWR sky130_fd_sc_hd__decap_6
XFILLER_128_94 VGND VGND VPWR VPWR sky130_fd_sc_hd__fill_1
XFILLER_124_546 VPWR VGND VPWR VGND sky130_ef_sc_hd__decap_12
X_12103_ _05833_ _05834_ VGND VGND VPWR VPWR _05835_ sky130_fd_sc_hd__and2_1
XFILLER_3_865 VPWR VGND VPWR VGND sky130_ef_sc_hd__decap_12
XFILLER_105_771 VGND VGND VPWR VPWR sky130_fd_sc_hd__decap_4
X_13083_ clknet_leaf_67_clk _00093_ VGND VGND VPWR VPWR u_interface.fifo_data\[15\]\[4\]
+ sky130_fd_sc_hd__dfxtp_1
X_10295_ net635 net446 net441 net626 VGND VGND VPWR VPWR _04045_ sky130_fd_sc_hd__a22o_1
XFILLER_120_741 VGND VGND VPWR VPWR sky130_fd_sc_hd__decap_4
X_12034_ _05765_ _05766_ VGND VGND VPWR VPWR _05767_ sky130_fd_sc_hd__or2_1
XFILLER_144_93 VGND VGND VPWR VPWR sky130_fd_sc_hd__decap_3
XFILLER_78_677 VGND VGND VPWR VPWR sky130_fd_sc_hd__fill_2
XTAP_TAPCELL_ROW_53_1187 VGND VPWR sky130_fd_sc_hd__tapvpwrvgnd_1
XTAP_TAPCELL_ROW_53_1176 VGND VPWR sky130_fd_sc_hd__tapvpwrvgnd_1
Xfanout690 net691 VGND VGND VPWR VPWR net690 sky130_fd_sc_hd__dlymetal6s2s_1
XFILLER_78_699 VGND VGND VPWR VPWR sky130_fd_sc_hd__fill_1
XFILLER_65_349 VGND VGND VPWR VPWR sky130_fd_sc_hd__decap_6
X_13985_ clknet_leaf_83_clk net1363 VGND VGND VPWR VPWR u_interface.u_gelu_fp32.u_q16_to_fp32.s2_mag\[30\]
+ sky130_fd_sc_hd__dfxtp_1
X_12936_ u_interface.in_flight_count\[4\] _06439_ VGND VGND VPWR VPWR _06460_ sky130_fd_sc_hd__xnor2_1
XFILLER_18_265 VPWR VGND VPWR VGND sky130_ef_sc_hd__decap_12
XFILLER_19_777 VGND VGND VPWR VPWR sky130_fd_sc_hd__decap_6
XFILLER_34_725 VPWR VGND VPWR VGND sky130_ef_sc_hd__decap_12
X_12867_ net1333 u_interface.u_gelu_fp32.u_fp32_to_q16.s2_norm_mag\[22\] net818 VGND
+ VGND VPWR VPWR _01011_ sky130_fd_sc_hd__mux2_1
XFILLER_73_393 VPWR VGND VPWR VGND sky130_ef_sc_hd__decap_12
XTAP_TAPCELL_ROW_29_794 VGND VPWR sky130_fd_sc_hd__tapvpwrvgnd_1
XFILLER_33_257 VPWR VGND VPWR VGND sky130_ef_sc_hd__decap_12
X_11818_ _05552_ _05553_ VGND VGND VPWR VPWR _05554_ sky130_fd_sc_hd__nor2_1
X_12798_ _01788_ net294 _06415_ VGND VGND VPWR VPWR _00959_ sky130_fd_sc_hd__and3b_1
X_11749_ _05480_ _05482_ _05484_ net793 VGND VGND VPWR VPWR _05486_ sky130_fd_sc_hd__a31o_1
XTAP_TAPCELL_ROW_40_970 VGND VPWR sky130_fd_sc_hd__tapvpwrvgnd_1
XTAP_TAPCELL_ROW_40_981 VGND VPWR sky130_fd_sc_hd__tapvpwrvgnd_1
XFILLER_146_159 VGND VGND VPWR VPWR sky130_fd_sc_hd__decap_4
X_13419_ clknet_leaf_9_clk _00429_ VGND VGND VPWR VPWR u_interface.u_gelu_fp32.u_fp32_to_q16.s3_mag\[31\]
+ sky130_fd_sc_hd__dfxtp_1
XFILLER_155_693 VGND VGND VPWR VPWR sky130_fd_sc_hd__decap_3
XFILLER_155_671 VGND VGND VPWR VPWR sky130_fd_sc_hd__fill_1
XFILLER_6_681 VPWR VGND VPWR VGND sky130_ef_sc_hd__decap_12
XFILLER_142_321 VGND VGND VPWR VPWR sky130_fd_sc_hd__fill_1
XTAP_TAPCELL_ROW_73_1508 VGND VPWR sky130_fd_sc_hd__tapvpwrvgnd_1
XFILLER_142_365 VPWR VGND VPWR VGND sky130_ef_sc_hd__decap_12
X_08960_ net582 net477 net480 net590 VGND VGND VPWR VPWR _02719_ sky130_fd_sc_hd__a22o_1
XFILLER_103_719 VGND VGND VPWR VPWR sky130_fd_sc_hd__fill_1
XFILLER_102_207 VGND VGND VPWR VPWR sky130_fd_sc_hd__fill_2
Xclkbuf_leaf_5_clk clknet_3_2__leaf_clk VGND VGND VPWR VPWR clknet_leaf_5_clk sky130_fd_sc_hd__clkbuf_8
XFILLER_88_419 VGND VGND VPWR VPWR sky130_fd_sc_hd__fill_1
X_07911_ net775 net95 VGND VGND VPWR VPWR _00670_ sky130_fd_sc_hd__and2_1
X_08891_ _02645_ _02646_ _02647_ VGND VGND VPWR VPWR _02650_ sky130_fd_sc_hd__and3_1
XFILLER_96_463 VGND VGND VPWR VPWR sky130_fd_sc_hd__fill_1
X_07842_ net369 net1506 net282 VGND VGND VPWR VPWR _00603_ sky130_fd_sc_hd__mux2_1
X_09512_ net589 net451 net446 net585 VGND VGND VPWR VPWR _03269_ sky130_fd_sc_hd__a22oi_1
XTAP_TAPCELL_ROW_104_2007 VGND VPWR sky130_fd_sc_hd__tapvpwrvgnd_1
XTAP_TAPCELL_ROW_88_1751 VGND VPWR sky130_fd_sc_hd__tapvpwrvgnd_1
XTAP_TAPCELL_ROW_88_1740 VGND VPWR sky130_fd_sc_hd__tapvpwrvgnd_1
XFILLER_83_157 VGND VGND VPWR VPWR sky130_fd_sc_hd__decap_8
XFILLER_65_850 VGND VGND VPWR VPWR sky130_fd_sc_hd__decap_6
X_07773_ net1442 net379 net233 VGND VGND VPWR VPWR _00534_ sky130_fd_sc_hd__mux2_1
XFILLER_140_29 VPWR VGND VPWR VGND sky130_ef_sc_hd__decap_12
X_06724_ _01283_ _01284_ _01287_ net318 VGND VGND VPWR VPWR net111 sky130_fd_sc_hd__a22o_1
XFILLER_17_39 VPWR VGND VPWR VGND sky130_ef_sc_hd__decap_12
XFILLER_37_585 VPWR VGND VPWR VGND sky130_ef_sc_hd__decap_12
X_09443_ _02685_ _02687_ _03198_ _03199_ VGND VGND VPWR VPWR _03201_ sky130_fd_sc_hd__a211oi_2
XFILLER_52_533 VPWR VGND VPWR VGND sky130_ef_sc_hd__decap_12
XFILLER_13_909 VPWR VGND VPWR VGND sky130_ef_sc_hd__decap_12
X_06655_ u_interface.fifo_data\[12\]\[3\] u_interface.fifo_data\[13\]\[3\] u_interface.fifo_data\[14\]\[3\]
+ u_interface.fifo_data\[15\]\[3\] net757 net740 VGND VGND VPWR VPWR _01227_ sky130_fd_sc_hd__mux4_1
X_09374_ _02816_ _03131_ VGND VGND VPWR VPWR _03133_ sky130_fd_sc_hd__nand2_1
XFILLER_80_875 VGND VGND VPWR VPWR sky130_fd_sc_hd__fill_1
XFILLER_24_246 VGND VGND VPWR VPWR sky130_fd_sc_hd__decap_6
X_06586_ u_interface.u_gelu_fp32.s1_data\[16\] _01173_ VGND VGND VPWR VPWR _01174_
+ sky130_fd_sc_hd__and2_1
X_08325_ net529 net1634 _02125_ net796 VGND VGND VPWR VPWR _02127_ sky130_fd_sc_hd__a31o_1
XFILLER_33_27 VPWR VGND VPWR VGND sky130_ef_sc_hd__decap_12
XFILLER_40_739 VGND VGND VPWR VPWR sky130_fd_sc_hd__fill_1
X_08256_ net982 _02074_ _02075_ VGND VGND VPWR VPWR _00747_ sky130_fd_sc_hd__a21oi_1
XFILLER_153_608 VGND VGND VPWR VPWR sky130_fd_sc_hd__fill_1
XFILLER_118_351 VPWR VGND VPWR VGND sky130_ef_sc_hd__decap_12
X_08187_ net315 _02020_ _02019_ VGND VGND VPWR VPWR _02022_ sky130_fd_sc_hd__o21ai_1
X_07207_ net354 net1382 net258 VGND VGND VPWR VPWR _00247_ sky130_fd_sc_hd__mux2_1
X_07138_ net1111 net365 net220 VGND VGND VPWR VPWR _00178_ sky130_fd_sc_hd__mux2_1
XFILLER_152_129 VGND VGND VPWR VPWR sky130_fd_sc_hd__fill_2
XFILLER_146_671 VGND VGND VPWR VPWR sky130_fd_sc_hd__fill_1
XFILLER_134_811 VGND VGND VPWR VPWR sky130_fd_sc_hd__fill_1
XTAP_TAPCELL_ROW_132_2450 VGND VPWR sky130_fd_sc_hd__tapvpwrvgnd_1
XTAP_TAPCELL_ROW_115_2169 VGND VPWR sky130_fd_sc_hd__tapvpwrvgnd_1
XFILLER_134_866 VGND VGND VPWR VPWR sky130_fd_sc_hd__fill_2
XFILLER_121_505 VPWR VGND VPWR VGND sky130_ef_sc_hd__decap_12
X_07069_ net1031 net345 net207 VGND VGND VPWR VPWR _00109_ sky130_fd_sc_hd__mux2_1
XFILLER_0_813 VPWR VGND VPWR VGND sky130_ef_sc_hd__decap_12
X_10080_ _03704_ _03710_ _03711_ VGND VGND VPWR VPWR _03832_ sky130_fd_sc_hd__a21bo_1
XTAP_TAPCELL_ROW_7_445 VGND VPWR sky130_fd_sc_hd__tapvpwrvgnd_1
XFILLER_102_774 VGND VGND VPWR VPWR sky130_fd_sc_hd__decap_8
XFILLER_87_441 VGND VGND VPWR VPWR sky130_fd_sc_hd__decap_6
XFILLER_59_132 VGND VGND VPWR VPWR sky130_fd_sc_hd__decap_6
XFILLER_87_474 VGND VGND VPWR VPWR sky130_fd_sc_hd__fill_1
XFILLER_59_165 VGND VGND VPWR VPWR sky130_fd_sc_hd__decap_3
XFILLER_114_85 VGND VGND VPWR VPWR sky130_fd_sc_hd__decap_3
XFILLER_28_541 VGND VGND VPWR VPWR sky130_fd_sc_hd__fill_1
X_13770_ clknet_leaf_57_clk _00780_ VGND VGND VPWR VPWR u_interface.u_gelu_fp32.s2_data\[4\]
+ sky130_fd_sc_hd__dfxtp_1
X_10982_ net652 net660 net431 net426 VGND VGND VPWR VPWR _04726_ sky130_fd_sc_hd__and4_1
XFILLER_16_725 VPWR VGND VPWR VGND sky130_ef_sc_hd__decap_12
X_12721_ u_interface.u_gelu_fp32.u_q16_to_fp32.s2_mag\[25\] u_interface.u_gelu_fp32.u_q16_to_fp32.s2_mag\[24\]
+ u_interface.u_gelu_fp32.u_q16_to_fp32.s2_mag\[23\] u_interface.u_gelu_fp32.u_q16_to_fp32.s2_mag\[22\]
+ net336 net332 VGND VGND VPWR VPWR _06374_ sky130_fd_sc_hd__mux4_1
XFILLER_55_393 VPWR VGND VPWR VGND sky130_ef_sc_hd__decap_12
XFILLER_130_62 VGND VGND VPWR VPWR sky130_fd_sc_hd__decap_3
X_12652_ net1621 u_interface.u_gelu_fp32.u_q16_to_fp32.s2_mag\[7\] net805 VGND VGND
+ VPWR VPWR _00888_ sky130_fd_sc_hd__mux2_1
XFILLER_70_341 VGND VGND VPWR VPWR sky130_fd_sc_hd__fill_2
XFILLER_16_769 VPWR VGND VPWR VGND sky130_ef_sc_hd__decap_12
XTAP_TAPCELL_ROW_26_753 VGND VPWR sky130_fd_sc_hd__tapvpwrvgnd_1
XFILLER_70_385 VGND VGND VPWR VPWR sky130_fd_sc_hd__decap_3
XFILLER_43_588 VGND VGND VPWR VPWR sky130_fd_sc_hd__fill_1
XFILLER_15_279 VGND VGND VPWR VPWR sky130_fd_sc_hd__fill_1
X_11603_ _05339_ _05340_ _05330_ VGND VGND VPWR VPWR _05341_ sky130_fd_sc_hd__a21oi_1
X_12583_ net29 net32 net31 net34 VGND VGND VPWR VPWR _06287_ sky130_fd_sc_hd__or4_1
XFILLER_129_605 VGND VGND VPWR VPWR sky130_fd_sc_hd__decap_6
XFILLER_11_474 VGND VGND VPWR VPWR sky130_fd_sc_hd__decap_3
X_11534_ net625 net389 VGND VGND VPWR VPWR _05273_ sky130_fd_sc_hd__nand2_1
X_11465_ _05203_ _05204_ VGND VGND VPWR VPWR _05205_ sky130_fd_sc_hd__nor2_1
XFILLER_7_467 VPWR VGND VPWR VGND sky130_ef_sc_hd__decap_12
XFILLER_7_456 VGND VGND VPWR VPWR sky130_fd_sc_hd__fill_1
XFILLER_23_93 VPWR VGND VPWR VGND sky130_ef_sc_hd__decap_12
X_13204_ clknet_leaf_42_clk _00214_ VGND VGND VPWR VPWR u_interface.fifo_data\[12\]\[14\]
+ sky130_fd_sc_hd__dfxtp_1
X_10416_ _04162_ _04163_ _04164_ VGND VGND VPWR VPWR _04165_ sky130_fd_sc_hd__a21o_1
XFILLER_124_343 VPWR VGND VPWR VGND sky130_ef_sc_hd__decap_12
XTAP_TAPCELL_ROW_55_1216 VGND VPWR sky130_fd_sc_hd__tapvpwrvgnd_1
X_11396_ _05130_ _05135_ VGND VGND VPWR VPWR _05136_ sky130_fd_sc_hd__and2b_1
XFILLER_125_877 VGND VGND VPWR VPWR sky130_fd_sc_hd__fill_1
XFILLER_124_365 VGND VGND VPWR VPWR sky130_fd_sc_hd__decap_6
X_13135_ clknet_leaf_47_clk _00145_ VGND VGND VPWR VPWR u_interface.fifo_data\[2\]\[24\]
+ sky130_fd_sc_hd__dfxtp_1
XFILLER_98_717 VGND VGND VPWR VPWR sky130_fd_sc_hd__fill_2
X_10347_ _04094_ _04095_ _04087_ VGND VGND VPWR VPWR _04096_ sky130_fd_sc_hd__a21o_1
XFILLER_3_673 VPWR VGND VPWR VGND sky130_ef_sc_hd__decap_12
XFILLER_140_869 VGND VGND VPWR VPWR sky130_fd_sc_hd__fill_1
X_13066_ clknet_leaf_42_clk _00076_ VGND VGND VPWR VPWR u_interface.fifo_data\[14\]\[19\]
+ sky130_fd_sc_hd__dfxtp_1
X_10278_ _04024_ _04025_ _04026_ VGND VGND VPWR VPWR _04028_ sky130_fd_sc_hd__and3_1
X_12017_ _05748_ _05749_ VGND VGND VPWR VPWR _05750_ sky130_fd_sc_hd__nand2_1
XFILLER_120_560 VGND VGND VPWR VPWR sky130_fd_sc_hd__decap_3
XFILLER_65_113 VGND VGND VPWR VPWR sky130_fd_sc_hd__fill_1
XFILLER_38_327 VPWR VGND VPWR VGND sky130_ef_sc_hd__decap_12
XFILLER_39_839 VGND VGND VPWR VPWR sky130_fd_sc_hd__fill_1
X_13968_ clknet_leaf_61_clk net1695 VGND VGND VPWR VPWR u_interface.u_gelu_fp32.u_q16_to_fp32.s2_mag\[13\]
+ sky130_fd_sc_hd__dfxtp_1
XFILLER_0_53 VGND VGND VPWR VPWR sky130_fd_sc_hd__decap_3
X_12919_ _01099_ _06445_ VGND VGND VPWR VPWR _06446_ sky130_fd_sc_hd__nand2_1
XFILLER_62_831 VGND VGND VPWR VPWR sky130_fd_sc_hd__decap_3
XFILLER_34_533 VPWR VGND VPWR VGND sky130_ef_sc_hd__decap_12
X_13899_ clknet_leaf_19_clk net885 VGND VGND VPWR VPWR u_interface.u_gelu_fp32.u_synth_top.s1_x\[3\]
+ sky130_fd_sc_hd__dfxtp_1
XFILLER_0_97 VPWR VGND VPWR VGND sky130_ef_sc_hd__decap_12
XTAP_TAPCELL_ROW_83_1670 VGND VPWR sky130_fd_sc_hd__tapvpwrvgnd_1
XTAP_TAPCELL_ROW_66_1389 VGND VPWR sky130_fd_sc_hd__tapvpwrvgnd_1
XFILLER_9_51 VGND VGND VPWR VPWR sky130_fd_sc_hd__decap_4
XFILLER_147_435 VPWR VGND VPWR VGND sky130_ef_sc_hd__decap_12
X_09090_ _02833_ _02847_ _02848_ VGND VGND VPWR VPWR _02849_ sky130_fd_sc_hd__and3_1
XFILLER_119_126 VGND VGND VPWR VPWR sky130_fd_sc_hd__fill_2
X_08110_ _01879_ _01956_ VGND VGND VPWR VPWR _01957_ sky130_fd_sc_hd__nand2b_1
X_08041_ u_interface.u_gelu_fp32.u_fp32_to_q16.s3_frac\[5\] u_interface.u_gelu_fp32.u_fp32_to_q16.s3_frac\[4\]
+ u_interface.u_gelu_fp32.u_fp32_to_q16.s3_frac\[7\] u_interface.u_gelu_fp32.u_fp32_to_q16.s3_frac\[6\]
+ VGND VGND VPWR VPWR _01898_ sky130_fd_sc_hd__or4_1
Xhold902 u_interface.u_gelu_fp32.u_fp32_to_q16.s3_frac\[13\] VGND VGND VPWR VPWR net1767
+ sky130_fd_sc_hd__dlygate4sd3_1
Xhold913 u_interface.u_gelu_fp32.u_q16_to_fp32.s3_norm_mag\[29\] VGND VGND VPWR VPWR
+ net1778 sky130_fd_sc_hd__dlygate4sd3_1
XFILLER_115_365 VGND VGND VPWR VPWR sky130_fd_sc_hd__fill_1
X_09992_ _03530_ _03628_ _03744_ VGND VGND VPWR VPWR _03745_ sky130_fd_sc_hd__o21ba_1
XFILLER_0_109 VGND VGND VPWR VPWR sky130_fd_sc_hd__decap_3
XFILLER_142_184 VGND VGND VPWR VPWR sky130_fd_sc_hd__fill_1
XFILLER_131_858 VPWR VGND VPWR VGND sky130_ef_sc_hd__decap_12
X_08943_ _02659_ _02698_ _02700_ VGND VGND VPWR VPWR _02702_ sky130_fd_sc_hd__and3_1
XTAP_TAPCELL_ROW_110_2099 VGND VPWR sky130_fd_sc_hd__tapvpwrvgnd_1
XTAP_TAPCELL_ROW_110_2088 VGND VPWR sky130_fd_sc_hd__tapvpwrvgnd_1
XFILLER_69_430 VPWR VGND VPWR VGND sky130_ef_sc_hd__decap_12
XTAP_TAPCELL_ROW_4_404 VGND VPWR sky130_fd_sc_hd__tapvpwrvgnd_1
X_08874_ _02620_ _02631_ _02632_ VGND VGND VPWR VPWR _02633_ sky130_fd_sc_hd__a21oi_1
XFILLER_97_783 VGND VGND VPWR VPWR sky130_fd_sc_hd__fill_1
XFILLER_84_400 VPWR VGND VPWR VGND sky130_ef_sc_hd__decap_12
XFILLER_56_113 VGND VGND VPWR VPWR sky130_fd_sc_hd__decap_8
XFILLER_28_27 VGND VGND VPWR VPWR sky130_fd_sc_hd__fill_1
XFILLER_29_305 VPWR VGND VPWR VGND sky130_ef_sc_hd__decap_12
X_07825_ net1558 net577 net232 VGND VGND VPWR VPWR _00586_ sky130_fd_sc_hd__mux2_1
XFILLER_84_433 VPWR VGND VPWR VGND sky130_ef_sc_hd__decap_12
XFILLER_57_669 VGND VGND VPWR VPWR sky130_fd_sc_hd__decap_3
XFILLER_29_349 VGND VGND VPWR VPWR sky130_fd_sc_hd__decap_8
XFILLER_38_850 VGND VGND VPWR VPWR sky130_fd_sc_hd__fill_2
X_07756_ _01796_ _01797_ VGND VGND VPWR VPWR _00524_ sky130_fd_sc_hd__nor2_1
XFILLER_84_477 VGND VGND VPWR VPWR sky130_fd_sc_hd__decap_4
X_06707_ _01271_ _01272_ net730 VGND VGND VPWR VPWR _01273_ sky130_fd_sc_hd__mux2_1
XFILLER_44_15 VPWR VGND VPWR VGND sky130_ef_sc_hd__decap_12
XFILLER_25_533 VGND VGND VPWR VPWR sky130_fd_sc_hd__fill_2
XFILLER_37_393 VGND VGND VPWR VPWR sky130_fd_sc_hd__decap_6
X_09426_ _03183_ _03169_ VGND VGND VPWR VPWR _03184_ sky130_fd_sc_hd__and2b_1
X_07687_ u_interface.u_gelu_fp32.u_synth_top.s1_hits\[1\] _01128_ _01428_ _01759_
+ VGND VGND VPWR VPWR _00492_ sky130_fd_sc_hd__or4_1
XFILLER_53_853 VGND VGND VPWR VPWR sky130_fd_sc_hd__decap_3
XFILLER_25_555 VGND VGND VPWR VPWR sky130_fd_sc_hd__decap_4
X_06638_ u_interface.fifo_data\[8\]\[1\] u_interface.fifo_data\[9\]\[1\] u_interface.fifo_data\[10\]\[1\]
+ u_interface.fifo_data\[11\]\[1\] net763 net746 VGND VGND VPWR VPWR _01212_ sky130_fd_sc_hd__mux4_1
XTAP_TAPCELL_ROW_23_701 VGND VPWR sky130_fd_sc_hd__tapvpwrvgnd_1
X_09357_ _03035_ _03067_ _03066_ VGND VGND VPWR VPWR _03116_ sky130_fd_sc_hd__a21boi_1
X_06569_ _01159_ _01161_ VGND VGND VPWR VPWR _00009_ sky130_fd_sc_hd__and2_1
X_09288_ net597 net512 VGND VGND VPWR VPWR _03047_ sky130_fd_sc_hd__nand2_1
XTAP_TAPCELL_ROW_117_2209 VGND VPWR sky130_fd_sc_hd__tapvpwrvgnd_1
X_08308_ net530 _02113_ net1633 VGND VGND VPWR VPWR _02114_ sky130_fd_sc_hd__a21oi_1
XFILLER_21_783 VGND VGND VPWR VPWR sky130_fd_sc_hd__fill_1
XFILLER_154_917 VGND VGND VPWR VPWR sky130_fd_sc_hd__decap_4
X_08239_ _02063_ _02065_ VGND VGND VPWR VPWR _02066_ sky130_fd_sc_hd__xnor2_1
XFILLER_20_293 VGND VGND VPWR VPWR sky130_fd_sc_hd__fill_1
XTAP_TAPCELL_ROW_130_2409 VGND VPWR sky130_fd_sc_hd__tapvpwrvgnd_1
XFILLER_125_129 VGND VGND VPWR VPWR sky130_fd_sc_hd__decap_8
XFILLER_153_449 VPWR VGND VPWR VGND sky130_ef_sc_hd__decap_12
XFILLER_118_192 VGND VGND VPWR VPWR sky130_fd_sc_hd__decap_4
XFILLER_109_52 VGND VGND VPWR VPWR sky130_fd_sc_hd__decap_4
XFILLER_107_3 VGND VGND VPWR VPWR sky130_fd_sc_hd__decap_8
X_11250_ _04989_ _04990_ VGND VGND VPWR VPWR _04992_ sky130_fd_sc_hd__xor2_1
XPHY_EDGE_ROW_152_Left_308 VGND VGND VPWR VPWR sky130_fd_sc_hd__decap_3
XFILLER_106_376 VGND VGND VPWR VPWR sky130_fd_sc_hd__decap_6
XFILLER_106_365 VGND VGND VPWR VPWR sky130_fd_sc_hd__fill_1
X_10201_ _03951_ VGND VGND VPWR VPWR _03952_ sky130_fd_sc_hd__inv_2
X_11181_ _04918_ _04922_ VGND VGND VPWR VPWR _04923_ sky130_fd_sc_hd__and2b_1
XFILLER_106_387 VGND VGND VPWR VPWR sky130_fd_sc_hd__fill_1
X_10132_ _03881_ _03882_ _03863_ VGND VGND VPWR VPWR _03883_ sky130_fd_sc_hd__a21o_1
XFILLER_125_73 VGND VGND VPWR VPWR sky130_fd_sc_hd__fill_1
XFILLER_87_271 VGND VGND VPWR VPWR sky130_fd_sc_hd__decap_8
XFILLER_87_260 VGND VGND VPWR VPWR sky130_fd_sc_hd__decap_8
X_10063_ _03811_ _03812_ _03813_ VGND VGND VPWR VPWR _03815_ sky130_fd_sc_hd__nand3_1
XTAP_TAPCELL_ROW_50_1135 VGND VPWR sky130_fd_sc_hd__tapvpwrvgnd_1
XTAP_TAPCELL_ROW_145_2663 VGND VPWR sky130_fd_sc_hd__tapvpwrvgnd_1
XTAP_TAPCELL_ROW_145_2652 VGND VPWR sky130_fd_sc_hd__tapvpwrvgnd_1
XFILLER_85_99 VGND VGND VPWR VPWR sky130_fd_sc_hd__decap_4
XFILLER_63_617 VGND VGND VPWR VPWR sky130_fd_sc_hd__decap_3
XFILLER_62_105 VGND VGND VPWR VPWR sky130_fd_sc_hd__fill_1
X_13822_ clknet_leaf_81_clk _00832_ VGND VGND VPWR VPWR u_interface.u_gelu_fp32.u_synth_top.s3_mult\[40\]
+ sky130_fd_sc_hd__dfxtp_1
XFILLER_62_116 VGND VGND VPWR VPWR sky130_fd_sc_hd__decap_6
X_13753_ clknet_leaf_84_clk _00763_ VGND VGND VPWR VPWR u_interface.u_gelu_fp32.u_q16_to_fp32.s1_mag\[19\]
+ sky130_fd_sc_hd__dfxtp_1
XFILLER_28_393 VGND VGND VPWR VPWR sky130_fd_sc_hd__fill_1
XFILLER_90_469 VGND VGND VPWR VPWR sky130_fd_sc_hd__decap_6
X_12704_ _06360_ _06346_ net328 VGND VGND VPWR VPWR _06361_ sky130_fd_sc_hd__mux2_1
XFILLER_62_149 VGND VGND VPWR VPWR sky130_fd_sc_hd__fill_1
X_10965_ _04700_ _04708_ VGND VGND VPWR VPWR _04709_ sky130_fd_sc_hd__xor2_1
X_13684_ clknet_leaf_12_clk _00694_ VGND VGND VPWR VPWR u_interface.u_gelu_fp32.u_fp32_to_q16.s3_frac\[20\]
+ sky130_fd_sc_hd__dfxtp_1
X_10896_ _04627_ _04639_ VGND VGND VPWR VPWR _04641_ sky130_fd_sc_hd__nand2_1
XTAP_TAPCELL_ROW_48_1097 VGND VPWR sky130_fd_sc_hd__tapvpwrvgnd_1
X_12635_ net186 _06332_ VGND VGND VPWR VPWR _06335_ sky130_fd_sc_hd__and2_1
X_12566_ net784 net1761 VGND VGND VPWR VPWR _00864_ sky130_fd_sc_hd__and2_1
X_11517_ _05172_ _05174_ _05173_ VGND VGND VPWR VPWR _05256_ sky130_fd_sc_hd__o21bai_2
X_12497_ _06221_ VGND VGND VPWR VPWR _06222_ sky130_fd_sc_hd__inv_2
Xhold209 u_interface.fifo_data\[5\]\[16\] VGND VGND VPWR VPWR net1074 sky130_fd_sc_hd__dlygate4sd3_1
XFILLER_109_181 VGND VGND VPWR VPWR sky130_fd_sc_hd__fill_1
X_11448_ _05186_ _05187_ VGND VGND VPWR VPWR _05188_ sky130_fd_sc_hd__nand2_1
X_14167_ clknet_leaf_66_clk _01093_ VGND VGND VPWR VPWR u_interface.fifo_data\[1\]\[27\]
+ sky130_fd_sc_hd__dfxtp_1
X_11379_ _05117_ _05119_ _05116_ VGND VGND VPWR VPWR _05120_ sky130_fd_sc_hd__a21oi_1
X_13118_ clknet_leaf_45_clk _00128_ VGND VGND VPWR VPWR u_interface.fifo_data\[2\]\[7\]
+ sky130_fd_sc_hd__dfxtp_1
XFILLER_98_536 VPWR VGND VPWR VGND sky130_ef_sc_hd__decap_12
X_14098_ clknet_leaf_33_clk _01024_ VGND VGND VPWR VPWR u_interface.meta_tuser_pipe\[9\]
+ sky130_fd_sc_hd__dfxtp_1
XFILLER_124_195 VGND VGND VPWR VPWR sky130_fd_sc_hd__fill_1
XFILLER_113_869 VGND VGND VPWR VPWR sky130_fd_sc_hd__decap_3
XFILLER_86_709 VPWR VGND VPWR VGND sky130_ef_sc_hd__decap_12
XFILLER_85_208 VPWR VGND VPWR VGND sky130_ef_sc_hd__decap_12
XFILLER_22_3 VPWR VGND VPWR VGND sky130_ef_sc_hd__decap_12
X_13049_ clknet_leaf_74_clk _00059_ VGND VGND VPWR VPWR u_interface.fifo_data\[14\]\[2\]
+ sky130_fd_sc_hd__dfxtp_1
XFILLER_27_809 VPWR VGND VPWR VGND sky130_ef_sc_hd__decap_12
XFILLER_38_113 VGND VGND VPWR VPWR sky130_fd_sc_hd__decap_8
X_08590_ net155 _02374_ net823 VGND VGND VPWR VPWR _00782_ sky130_fd_sc_hd__a21oi_1
X_07610_ u_interface.u_gelu_fp32.u_q16_to_fp32.s2_mag\[2\] u_interface.u_gelu_fp32.u_q16_to_fp32.s2_mag\[1\]
+ net338 VGND VGND VPWR VPWR _01704_ sky130_fd_sc_hd__mux2_1
XTAP_TAPCELL_ROW_68_1429 VGND VPWR sky130_fd_sc_hd__tapvpwrvgnd_1
XTAP_TAPCELL_ROW_68_1418 VGND VPWR sky130_fd_sc_hd__tapvpwrvgnd_1
XFILLER_66_477 VPWR VGND VPWR VGND sky130_ef_sc_hd__decap_12
X_07541_ net822 net1658 net305 _01657_ VGND VGND VPWR VPWR _00446_ sky130_fd_sc_hd__a22o_1
XFILLER_19_393 VGND VGND VPWR VPWR sky130_fd_sc_hd__decap_6
X_07472_ _01604_ _01605_ net550 VGND VGND VPWR VPWR _01606_ sky130_fd_sc_hd__mux2_1
XTAP_TAPCELL_ROW_81_1629 VGND VPWR sky130_fd_sc_hd__tapvpwrvgnd_1
XFILLER_61_160 VGND VGND VPWR VPWR sky130_fd_sc_hd__decap_8
XFILLER_34_363 VGND VGND VPWR VPWR sky130_fd_sc_hd__fill_1
XFILLER_35_897 VPWR VGND VPWR VGND sky130_ef_sc_hd__decap_12
X_09211_ net597 net501 net506 net604 VGND VGND VPWR VPWR _02970_ sky130_fd_sc_hd__a22oi_2
XFILLER_14_29 VPWR VGND VPWR VGND sky130_ef_sc_hd__decap_12
X_09142_ _02880_ _02881_ _02828_ VGND VGND VPWR VPWR _02901_ sky130_fd_sc_hd__a21boi_1
XFILLER_50_889 VGND VGND VPWR VPWR sky130_fd_sc_hd__fill_1
X_09073_ _02828_ _02829_ _02830_ _02780_ VGND VGND VPWR VPWR _02832_ sky130_fd_sc_hd__or4bb_1
XFILLER_135_427 VPWR VGND VPWR VGND sky130_ef_sc_hd__decap_12
XFILLER_128_490 VGND VGND VPWR VPWR sky130_fd_sc_hd__fill_1
X_08024_ u_interface.u_gelu_fp32.u_fp32_to_q16.s3_mag\[12\] _01880_ VGND VGND VPWR
+ VPWR _01881_ sky130_fd_sc_hd__nand2_1
XFILLER_107_129 VGND VGND VPWR VPWR sky130_fd_sc_hd__fill_1
XTAP_TAPCELL_ROW_96_1872 VGND VPWR sky130_fd_sc_hd__tapvpwrvgnd_1
Xhold710 u_interface.fifo_data\[11\]\[18\] VGND VGND VPWR VPWR net1575 sky130_fd_sc_hd__dlygate4sd3_1
Xhold721 u_interface.fifo_data\[7\]\[20\] VGND VGND VPWR VPWR net1586 sky130_fd_sc_hd__dlygate4sd3_1
Xhold754 u_interface.u_gelu_fp32.u_fp32_to_q16.s1_mant\[22\] VGND VGND VPWR VPWR net1619
+ sky130_fd_sc_hd__dlygate4sd3_1
Xhold743 u_interface.u_gelu_fp32.u_fp32_to_q16.s3_mag\[22\] VGND VGND VPWR VPWR net1608
+ sky130_fd_sc_hd__dlygate4sd3_1
XTAP_TAPCELL_ROW_112_2128 VGND VPWR sky130_fd_sc_hd__tapvpwrvgnd_1
Xhold732 u_interface.u_gelu_fp32.s2_data\[14\] VGND VGND VPWR VPWR net1597 sky130_fd_sc_hd__dlygate4sd3_1
XFILLER_104_825 VGND VGND VPWR VPWR sky130_fd_sc_hd__fill_1
Xhold787 u_interface.u_gelu_fp32.s2_data\[11\] VGND VGND VPWR VPWR net1652 sky130_fd_sc_hd__dlygate4sd3_1
Xhold765 u_interface.u_gelu_fp32.s2_data\[23\] VGND VGND VPWR VPWR net1630 sky130_fd_sc_hd__dlygate4sd3_1
XFILLER_1_429 VPWR VGND VPWR VGND sky130_ef_sc_hd__decap_12
XFILLER_39_15 VPWR VGND VPWR VGND sky130_ef_sc_hd__decap_12
Xhold776 u_interface.u_gelu_fp32.s2_data\[29\] VGND VGND VPWR VPWR net1641 sky130_fd_sc_hd__dlygate4sd3_1
X_09975_ _03667_ _03668_ _03725_ _03726_ VGND VGND VPWR VPWR _03728_ sky130_fd_sc_hd__or4bb_2
XFILLER_89_558 VGND VGND VPWR VPWR sky130_fd_sc_hd__fill_2
Xhold798 u_interface.u_gelu_fp32.u_q16_to_fp32.s1_mag\[10\] VGND VGND VPWR VPWR net1663
+ sky130_fd_sc_hd__dlygate4sd3_1
X_08926_ _02679_ _02682_ _02683_ VGND VGND VPWR VPWR _02685_ sky130_fd_sc_hd__nand3_2
XFILLER_69_271 VGND VGND VPWR VPWR sky130_fd_sc_hd__decap_4
XFILLER_57_411 VPWR VGND VPWR VGND sky130_ef_sc_hd__decap_12
X_08857_ _02611_ _02612_ _02613_ VGND VGND VPWR VPWR _02616_ sky130_fd_sc_hd__and3_1
XFILLER_97_591 VGND VGND VPWR VPWR sky130_fd_sc_hd__fill_1
XFILLER_84_230 VPWR VGND VPWR VGND sky130_ef_sc_hd__decap_12
XFILLER_29_113 VPWR VGND VPWR VGND sky130_ef_sc_hd__decap_12
XTAP_TAPCELL_ROW_127_2371 VGND VPWR sky130_fd_sc_hd__tapvpwrvgnd_1
XTAP_TAPCELL_ROW_127_2360 VGND VPWR sky130_fd_sc_hd__tapvpwrvgnd_1
XFILLER_72_403 VGND VGND VPWR VPWR sky130_fd_sc_hd__decap_6
XFILLER_57_455 VGND VGND VPWR VPWR sky130_fd_sc_hd__decap_4
X_07808_ net1397 net372 net229 VGND VGND VPWR VPWR _00569_ sky130_fd_sc_hd__mux2_1
XFILLER_45_617 VGND VGND VPWR VPWR sky130_fd_sc_hd__decap_6
XFILLER_29_157 VGND VGND VPWR VPWR sky130_fd_sc_hd__decap_8
X_08788_ _02545_ _02546_ _02498_ _02500_ VGND VGND VPWR VPWR _02547_ sky130_fd_sc_hd__o211a_1
XFILLER_55_36 VGND VGND VPWR VPWR sky130_fd_sc_hd__fill_1
XFILLER_44_105 VGND VGND VPWR VPWR sky130_fd_sc_hd__fill_1
X_07739_ u_interface.u_gelu_fp32.u_q16_to_fp32.s3_norm_mag\[19\] _01782_ VGND VGND
+ VPWR VPWR _01783_ sky130_fd_sc_hd__and2_1
XFILLER_41_801 VGND VGND VPWR VPWR sky130_fd_sc_hd__decap_3
XTAP_TAPCELL_ROW_140_2582 VGND VPWR sky130_fd_sc_hd__tapvpwrvgnd_1
XTAP_TAPCELL_ROW_140_2571 VGND VPWR sky130_fd_sc_hd__tapvpwrvgnd_1
X_10750_ _04492_ _04495_ VGND VGND VPWR VPWR _04496_ sky130_fd_sc_hd__xnor2_1
XFILLER_41_812 VGND VGND VPWR VPWR sky130_fd_sc_hd__decap_4
X_09409_ _03134_ _03165_ VGND VGND VPWR VPWR _03167_ sky130_fd_sc_hd__nand2_1
X_10681_ _04306_ _04308_ _04425_ _04426_ VGND VGND VPWR VPWR _04428_ sky130_fd_sc_hd__o211a_1
XFILLER_71_57 VGND VGND VPWR VPWR sky130_fd_sc_hd__fill_2
XFILLER_9_529 VPWR VGND VPWR VGND sky130_ef_sc_hd__decap_12
X_12420_ _06144_ _06145_ VGND VGND VPWR VPWR _06147_ sky130_fd_sc_hd__xnor2_1
XFILLER_126_427 VGND VGND VPWR VPWR sky130_fd_sc_hd__fill_2
X_12351_ net203 _06078_ VGND VGND VPWR VPWR _06079_ sky130_fd_sc_hd__or2_1
XFILLER_153_246 VPWR VGND VPWR VGND sky130_ef_sc_hd__decap_12
XFILLER_126_438 VPWR VGND VPWR VGND sky130_ef_sc_hd__decap_12
X_11302_ _05029_ _05042_ VGND VGND VPWR VPWR _05043_ sky130_fd_sc_hd__and2b_1
X_12282_ _05743_ _05744_ _05953_ _05954_ _05815_ VGND VGND VPWR VPWR _06011_ sky130_fd_sc_hd__a32o_1
X_14021_ clknet_leaf_44_clk _00947_ VGND VGND VPWR VPWR u_interface.core_data_out\[7\]
+ sky130_fd_sc_hd__dfxtp_1
X_11233_ _04966_ _04974_ VGND VGND VPWR VPWR _04975_ sky130_fd_sc_hd__nor2_1
XFILLER_4_245 VGND VGND VPWR VPWR sky130_fd_sc_hd__decap_6
XFILLER_4_289 VPWR VGND VPWR VGND sky130_ef_sc_hd__decap_12
XFILLER_20_83 VGND VGND VPWR VPWR sky130_fd_sc_hd__fill_1
XFILLER_106_195 VGND VGND VPWR VPWR sky130_fd_sc_hd__fill_1
X_11164_ _04435_ _04554_ _04668_ _04790_ VGND VGND VPWR VPWR _04907_ sky130_fd_sc_hd__or4_1
X_10115_ _03764_ _03766_ VGND VGND VPWR VPWR _03866_ sky130_fd_sc_hd__nand2_1
XFILLER_76_720 VGND VGND VPWR VPWR sky130_fd_sc_hd__decap_6
X_11095_ net668 net430 net425 net659 VGND VGND VPWR VPWR _04838_ sky130_fd_sc_hd__a22o_1
XFILLER_0_473 VGND VGND VPWR VPWR sky130_fd_sc_hd__decap_3
X_10046_ _03795_ _03796_ VGND VGND VPWR VPWR _03798_ sky130_fd_sc_hd__xor2_1
XFILLER_48_433 VGND VGND VPWR VPWR sky130_fd_sc_hd__fill_2
Xhold92 u_interface.fifo_data\[8\]\[16\] VGND VGND VPWR VPWR net957 sky130_fd_sc_hd__dlygate4sd3_1
Xhold81 u_interface.u_gelu_fp32.u_fp32_to_q16.s3_valid VGND VGND VPWR VPWR net946
+ sky130_fd_sc_hd__dlygate4sd3_1
Xhold70 _00680_ VGND VGND VPWR VPWR net935 sky130_fd_sc_hd__dlygate4sd3_1
XFILLER_29_81 VPWR VGND VPWR VGND sky130_ef_sc_hd__decap_12
XFILLER_35_138 VPWR VGND VPWR VGND sky130_ef_sc_hd__decap_12
X_13805_ clknet_leaf_58_clk _00815_ VGND VGND VPWR VPWR u_interface.u_gelu_fp32.u_synth_top.s3_mult\[23\]
+ sky130_fd_sc_hd__dfxtp_1
XFILLER_16_330 VPWR VGND VPWR VGND sky130_ef_sc_hd__decap_12
XFILLER_17_853 VPWR VGND VPWR VGND sky130_ef_sc_hd__decap_12
X_11997_ _05408_ _05729_ VGND VGND VPWR VPWR _05730_ sky130_fd_sc_hd__nor2_1
X_13736_ clknet_leaf_56_clk _00746_ VGND VGND VPWR VPWR u_interface.u_gelu_fp32.u_q16_to_fp32.s1_mag\[2\]
+ sky130_fd_sc_hd__dfxtp_1
X_10948_ _04684_ _04690_ VGND VGND VPWR VPWR _04692_ sky130_fd_sc_hd__xnor2_1
XFILLER_16_385 VPWR VGND VPWR VGND sky130_ef_sc_hd__decap_12
XFILLER_17_897 VPWR VGND VPWR VGND sky130_ef_sc_hd__decap_12
XFILLER_43_160 VGND VGND VPWR VPWR sky130_fd_sc_hd__decap_8
XTAP_TAPCELL_ROW_63_1348 VGND VPWR sky130_fd_sc_hd__tapvpwrvgnd_1
XTAP_TAPCELL_ROW_63_1337 VGND VPWR sky130_fd_sc_hd__tapvpwrvgnd_1
XFILLER_32_867 VGND VGND VPWR VPWR sky130_fd_sc_hd__fill_1
X_13667_ clknet_leaf_14_clk _00677_ VGND VGND VPWR VPWR u_interface.u_gelu_fp32.u_fp32_to_q16.s2_shift\[4\]
+ sky130_fd_sc_hd__dfxtp_2
X_10879_ _04618_ _04623_ VGND VGND VPWR VPWR _04624_ sky130_fd_sc_hd__nand2b_1
XTAP_TAPCELL_ROW_14_553 VGND VPWR sky130_fd_sc_hd__tapvpwrvgnd_1
XTAP_TAPCELL_ROW_14_564 VGND VPWR sky130_fd_sc_hd__tapvpwrvgnd_1
X_13598_ clknet_leaf_26_clk _00608_ VGND VGND VPWR VPWR u_interface.fifo_data\[3\]\[13\]
+ sky130_fd_sc_hd__dfxtp_1
X_12618_ u_interface.u_gelu_fp32.u_q16_to_fp32.s1_mag\[1\] net213 u_interface.u_gelu_fp32.u_q16_to_fp32.s1_mag\[17\]
+ VGND VGND VPWR VPWR _06321_ sky130_fd_sc_hd__a21o_1
XFILLER_31_399 VGND VGND VPWR VPWR sky130_fd_sc_hd__decap_8
XFILLER_145_703 VGND VGND VPWR VPWR sky130_fd_sc_hd__fill_2
X_12549_ _06271_ _06272_ VGND VGND VPWR VPWR _06273_ sky130_fd_sc_hd__nor2_1
Xgelu_top_847 VGND VGND VPWR VPWR gelu_top_847/HI s_axil_rdata[15] sky130_fd_sc_hd__conb_1
Xgelu_top_836 VGND VGND VPWR VPWR gelu_top_836/HI s_axil_rdata[4] sky130_fd_sc_hd__conb_1
XFILLER_117_449 VPWR VGND VPWR VGND sky130_ef_sc_hd__decap_12
XANTENNA_1 _00003_ VGND VGND VPWR VPWR sky130_fd_sc_hd__diode_2
XFILLER_6_41 VPWR VGND VPWR VGND sky130_ef_sc_hd__decap_12
Xgelu_top_858 VGND VGND VPWR VPWR gelu_top_858/HI s_axil_rdata[26] sky130_fd_sc_hd__conb_1
XFILLER_132_419 VGND VGND VPWR VPWR sky130_fd_sc_hd__fill_1
XTAP_TAPCELL_ROW_78_1591 VGND VPWR sky130_fd_sc_hd__tapvpwrvgnd_1
XTAP_TAPCELL_ROW_78_1580 VGND VPWR sky130_fd_sc_hd__tapvpwrvgnd_1
XFILLER_6_85 VPWR VGND VPWR VGND sky130_ef_sc_hd__decap_12
Xfanout519 u_interface.u_gelu_fp32.u_synth_top.s2_dx\[0\] VGND VGND VPWR VPWR net519
+ sky130_fd_sc_hd__buf_2
Xfanout508 net509 VGND VGND VPWR VPWR net508 sky130_fd_sc_hd__buf_2
XFILLER_112_121 VGND VGND VPWR VPWR sky130_fd_sc_hd__fill_1
XFILLER_113_677 VGND VGND VPWR VPWR sky130_fd_sc_hd__fill_1
XFILLER_112_165 VGND VGND VPWR VPWR sky130_fd_sc_hd__decap_4
X_09760_ _03401_ _03403_ _03512_ _03513_ VGND VGND VPWR VPWR _03515_ sky130_fd_sc_hd__o211ai_4
XFILLER_101_839 VGND VGND VPWR VPWR sky130_fd_sc_hd__fill_1
XFILLER_100_305 VGND VGND VPWR VPWR sky130_fd_sc_hd__decap_3
XTAP_TAPCELL_ROW_91_1791 VGND VPWR sky130_fd_sc_hd__tapvpwrvgnd_1
X_06972_ _01490_ _01496_ _01491_ VGND VGND VPWR VPWR _01499_ sky130_fd_sc_hd__a21o_1
X_08711_ _02454_ _02468_ VGND VGND VPWR VPWR _02470_ sky130_fd_sc_hd__xnor2_1
X_09691_ net463 net620 _03349_ _03347_ VGND VGND VPWR VPWR _03446_ sky130_fd_sc_hd__a31o_1
XFILLER_39_433 VPWR VGND VPWR VGND sky130_ef_sc_hd__decap_12
XFILLER_55_915 VGND VGND VPWR VPWR sky130_fd_sc_hd__decap_6
X_08642_ net153 _02411_ net794 VGND VGND VPWR VPWR _00797_ sky130_fd_sc_hd__a21oi_1
XFILLER_27_617 VPWR VGND VPWR VGND sky130_ef_sc_hd__decap_12
X_08573_ _02212_ _02213_ VGND VGND VPWR VPWR _02363_ sky130_fd_sc_hd__nand2b_1
XFILLER_54_447 VPWR VGND VPWR VGND sky130_ef_sc_hd__decap_12
XFILLER_26_138 VGND VGND VPWR VPWR sky130_fd_sc_hd__fill_2
XFILLER_26_149 VGND VGND VPWR VPWR sky130_fd_sc_hd__fill_1
X_07524_ _01652_ _01539_ net549 VGND VGND VPWR VPWR _01653_ sky130_fd_sc_hd__mux2_1
XFILLER_81_288 VGND VGND VPWR VPWR sky130_fd_sc_hd__decap_8
XFILLER_25_39 VPWR VGND VPWR VGND sky130_ef_sc_hd__decap_12
X_07455_ _01588_ _01589_ net555 VGND VGND VPWR VPWR _01590_ sky130_fd_sc_hd__mux2_1
XTAP_TAPCELL_ROW_122_2290 VGND VPWR sky130_fd_sc_hd__tapvpwrvgnd_1
XFILLER_50_631 VGND VGND VPWR VPWR sky130_fd_sc_hd__fill_1
XFILLER_34_182 VGND VGND VPWR VPWR sky130_fd_sc_hd__fill_2
XFILLER_35_694 VPWR VGND VPWR VGND sky130_ef_sc_hd__decap_12
XFILLER_10_517 VPWR VGND VPWR VGND sky130_ef_sc_hd__decap_12
XFILLER_23_889 VGND VGND VPWR VPWR sky130_fd_sc_hd__decap_6
XTAP_TAPCELL_ROW_33_862 VGND VPWR sky130_fd_sc_hd__tapvpwrvgnd_1
X_07386_ net1086 net346 net239 VGND VGND VPWR VPWR _00416_ sky130_fd_sc_hd__mux2_1
XTAP_TAPCELL_ROW_98_1901 VGND VPWR sky130_fd_sc_hd__tapvpwrvgnd_1
XFILLER_22_399 VGND VGND VPWR VPWR sky130_fd_sc_hd__fill_2
XFILLER_148_574 VPWR VGND VPWR VGND sky130_ef_sc_hd__decap_12
X_09125_ _02841_ _02844_ _02843_ VGND VGND VPWR VPWR _02884_ sky130_fd_sc_hd__a21o_1
XFILLER_136_725 VGND VGND VPWR VPWR sky130_fd_sc_hd__decap_6
XFILLER_135_202 VGND VGND VPWR VPWR sky130_fd_sc_hd__decap_6
XFILLER_108_416 VGND VGND VPWR VPWR sky130_fd_sc_hd__decap_4
X_09056_ _02763_ _02764_ _02813_ VGND VGND VPWR VPWR _02815_ sky130_fd_sc_hd__a21o_1
X_08007_ net813 net1592 net301 _01694_ _01869_ VGND VGND VPWR VPWR _00704_ sky130_fd_sc_hd__a221o_1
XFILLER_123_419 VGND VGND VPWR VPWR sky130_fd_sc_hd__fill_1
Xhold562 u_interface.meta_tuser_pipe\[10\] VGND VGND VPWR VPWR net1427 sky130_fd_sc_hd__dlygate4sd3_1
Xhold551 u_interface.fifo_data\[15\]\[29\] VGND VGND VPWR VPWR net1416 sky130_fd_sc_hd__dlygate4sd3_1
Xhold540 u_interface.fifo_data\[3\]\[15\] VGND VGND VPWR VPWR net1405 sky130_fd_sc_hd__dlygate4sd3_1
XFILLER_2_749 VGND VGND VPWR VPWR sky130_fd_sc_hd__decap_6
Xhold595 u_interface.fifo_data\[9\]\[19\] VGND VGND VPWR VPWR net1460 sky130_fd_sc_hd__dlygate4sd3_1
XTAP_TAPCELL_ROW_129_2400 VGND VPWR sky130_fd_sc_hd__tapvpwrvgnd_1
XFILLER_103_121 VGND VGND VPWR VPWR sky130_fd_sc_hd__fill_1
Xhold584 u_interface.fifo_data\[7\]\[4\] VGND VGND VPWR VPWR net1449 sky130_fd_sc_hd__dlygate4sd3_1
XFILLER_1_237 VPWR VGND VPWR VGND sky130_ef_sc_hd__decap_12
Xhold573 u_interface.fifo_data\[8\]\[6\] VGND VGND VPWR VPWR net1438 sky130_fd_sc_hd__dlygate4sd3_1
XFILLER_106_53 VGND VGND VPWR VPWR sky130_fd_sc_hd__fill_1
X_09958_ _03705_ _03708_ _03709_ VGND VGND VPWR VPWR _03711_ sky130_fd_sc_hd__nand3_1
XFILLER_131_496 VGND VGND VPWR VPWR sky130_fd_sc_hd__fill_1
X_08909_ _02664_ _02667_ VGND VGND VPWR VPWR _02668_ sky130_fd_sc_hd__xnor2_1
XTAP_TAPCELL_ROW_142_2611 VGND VPWR sky130_fd_sc_hd__tapvpwrvgnd_1
XTAP_TAPCELL_ROW_142_2600 VGND VPWR sky130_fd_sc_hd__tapvpwrvgnd_1
XFILLER_106_97 VPWR VGND VPWR VGND sky130_ef_sc_hd__decap_12
X_09889_ _03640_ _03641_ _03636_ VGND VGND VPWR VPWR _03642_ sky130_fd_sc_hd__a21o_1
XFILLER_57_252 VGND VGND VPWR VPWR sky130_fd_sc_hd__decap_4
XFILLER_57_241 VGND VGND VPWR VPWR sky130_fd_sc_hd__fill_1
XFILLER_122_41 VGND VGND VPWR VPWR sky130_fd_sc_hd__decap_4
XFILLER_73_723 VGND VGND VPWR VPWR sky130_fd_sc_hd__decap_4
XFILLER_72_211 VGND VGND VPWR VPWR sky130_fd_sc_hd__decap_3
XFILLER_17_105 VGND VGND VPWR VPWR sky130_fd_sc_hd__decap_6
X_11920_ net184 _05653_ VGND VGND VPWR VPWR _05654_ sky130_fd_sc_hd__xnor2_1
XFILLER_72_244 VGND VGND VPWR VPWR sky130_fd_sc_hd__decap_8
XFILLER_61_918 VGND VGND VPWR VPWR sky130_fd_sc_hd__decap_3
XFILLER_17_149 VPWR VGND VPWR VGND sky130_ef_sc_hd__decap_12
X_11851_ _05584_ _05585_ VGND VGND VPWR VPWR _05586_ sky130_fd_sc_hd__nor2_1
XFILLER_33_609 VGND VGND VPWR VPWR sky130_fd_sc_hd__decap_6
XFILLER_73_789 VGND VGND VPWR VPWR sky130_fd_sc_hd__fill_1
X_10802_ _04339_ _04341_ _04545_ _04546_ VGND VGND VPWR VPWR _04548_ sky130_fd_sc_hd__a211o_1
X_11782_ _05516_ _05517_ _05512_ VGND VGND VPWR VPWR _05518_ sky130_fd_sc_hd__a21o_1
X_10733_ _04352_ _04358_ _04359_ VGND VGND VPWR VPWR _04479_ sky130_fd_sc_hd__a21bo_1
X_13521_ clknet_leaf_62_clk _00531_ VGND VGND VPWR VPWR u_interface.fifo_data\[5\]\[0\]
+ sky130_fd_sc_hd__dfxtp_1
XFILLER_13_322 VGND VGND VPWR VPWR sky130_fd_sc_hd__fill_1
XFILLER_14_867 VGND VGND VPWR VPWR sky130_fd_sc_hd__fill_1
XTAP_TAPCELL_ROW_45_1056 VGND VPWR sky130_fd_sc_hd__tapvpwrvgnd_1
XFILLER_40_141 VGND VGND VPWR VPWR sky130_fd_sc_hd__decap_6
XFILLER_41_686 VGND VGND VPWR VPWR sky130_fd_sc_hd__decap_4
X_13452_ clknet_leaf_9_clk _00462_ VGND VGND VPWR VPWR u_interface.u_gelu_fp32.u_fp32_to_q16.s3_mag\[23\]
+ sky130_fd_sc_hd__dfxtp_1
X_10664_ _04391_ _04392_ _04409_ _04410_ VGND VGND VPWR VPWR _04411_ sky130_fd_sc_hd__a22oi_1
XTAP_TAPCELL_ROW_11_512 VGND VPWR sky130_fd_sc_hd__tapvpwrvgnd_1
XFILLER_9_337 VGND VGND VPWR VPWR sky130_fd_sc_hd__fill_1
X_13383_ clknet_leaf_39_clk _00393_ VGND VGND VPWR VPWR u_interface.fifo_data\[7\]\[28\]
+ sky130_fd_sc_hd__dfxtp_1
X_10595_ _04251_ _04253_ VGND VGND VPWR VPWR _04342_ sky130_fd_sc_hd__or2_1
X_12403_ net202 _06080_ _06079_ VGND VGND VPWR VPWR _06130_ sky130_fd_sc_hd__o21a_1
X_12334_ _05936_ _06061_ _06062_ VGND VGND VPWR VPWR _06063_ sky130_fd_sc_hd__o21a_1
XTAP_TAPCELL_ROW_153_2784 VGND VPWR sky130_fd_sc_hd__tapvpwrvgnd_1
XPHY_EDGE_ROW_128_Right_128 VGND VGND VPWR VPWR sky130_fd_sc_hd__decap_3
X_14004_ clknet_leaf_56_clk net1517 VGND VGND VPWR VPWR u_interface.u_gelu_fp32.u_q16_to_fp32.s3_exp\[0\]
+ sky130_fd_sc_hd__dfxtp_1
X_12265_ _05924_ _05927_ _05994_ VGND VGND VPWR VPWR _05995_ sky130_fd_sc_hd__and3_1
XFILLER_141_238 VPWR VGND VPWR VGND sky130_ef_sc_hd__decap_12
XFILLER_122_430 VGND VGND VPWR VPWR sky130_fd_sc_hd__fill_2
X_11216_ _04955_ _04956_ _04957_ VGND VGND VPWR VPWR _04958_ sky130_fd_sc_hd__a21o_1
X_12196_ net191 _05925_ VGND VGND VPWR VPWR _05927_ sky130_fd_sc_hd__nand2_1
XFILLER_110_625 VGND VGND VPWR VPWR sky130_fd_sc_hd__decap_8
X_11147_ _04719_ _04774_ _04773_ VGND VGND VPWR VPWR _04890_ sky130_fd_sc_hd__a21oi_1
XFILLER_0_281 VPWR VGND VPWR VGND sky130_ef_sc_hd__decap_12
X_11078_ _04814_ _04820_ VGND VGND VPWR VPWR _04821_ sky130_fd_sc_hd__xnor2_1
X_10029_ _03779_ _03780_ _03755_ VGND VGND VPWR VPWR _03781_ sky130_fd_sc_hd__a21o_1
XFILLER_63_222 VGND VGND VPWR VPWR sky130_fd_sc_hd__fill_2
XFILLER_52_918 VGND VGND VPWR VPWR sky130_fd_sc_hd__decap_3
XTAP_TAPCELL_ROW_19_634 VGND VPWR sky130_fd_sc_hd__tapvpwrvgnd_1
XTAP_TAPCELL_ROW_19_645 VGND VPWR sky130_fd_sc_hd__tapvpwrvgnd_1
XFILLER_91_586 VGND VGND VPWR VPWR sky130_fd_sc_hd__fill_1
XFILLER_63_266 VPWR VGND VPWR VGND sky130_ef_sc_hd__decap_12
XFILLER_149_305 VGND VGND VPWR VPWR sky130_fd_sc_hd__fill_1
X_13719_ clknet_leaf_8_clk _00729_ VGND VGND VPWR VPWR u_interface.u_gelu_fp32.s1_data\[19\]
+ sky130_fd_sc_hd__dfxtp_1
X_07240_ net1251 net376 net250 VGND VGND VPWR VPWR _00272_ sky130_fd_sc_hd__mux2_1
XFILLER_20_837 VPWR VGND VPWR VGND sky130_ef_sc_hd__decap_12
XTAP_TAPCELL_ROW_30_810 VGND VPWR sky130_fd_sc_hd__tapvpwrvgnd_1
XTAP_TAPCELL_ROW_30_821 VGND VPWR sky130_fd_sc_hd__tapvpwrvgnd_1
XFILLER_118_725 VGND VGND VPWR VPWR sky130_fd_sc_hd__fill_2
X_07171_ net1544 net363 net264 VGND VGND VPWR VPWR _00211_ sky130_fd_sc_hd__mux2_1
XFILLER_145_511 VPWR VGND VPWR VGND sky130_ef_sc_hd__decap_12
XFILLER_117_202 VGND VGND VPWR VPWR sky130_fd_sc_hd__decap_4
XFILLER_117_257 VGND VGND VPWR VPWR sky130_fd_sc_hd__fill_1
XTAP_TAPCELL_ROW_93_1820 VGND VPWR sky130_fd_sc_hd__tapvpwrvgnd_1
XFILLER_8_392 VGND VGND VPWR VPWR sky130_fd_sc_hd__decap_4
XFILLER_132_227 VGND VGND VPWR VPWR sky130_fd_sc_hd__fill_1
XFILLER_132_205 VGND VGND VPWR VPWR sky130_fd_sc_hd__fill_1
XFILLER_114_920 VGND VGND VPWR VPWR sky130_fd_sc_hd__fill_1
XTAP_TAPCELL_ROW_93_1831 VGND VPWR sky130_fd_sc_hd__tapvpwrvgnd_1
Xfanout305 _01536_ VGND VGND VPWR VPWR net305 sky130_fd_sc_hd__buf_2
Xfanout327 u_interface.meta_tuser_pipe\[11\] VGND VGND VPWR VPWR net327 sky130_fd_sc_hd__buf_1
XFILLER_113_452 VPWR VGND VPWR VGND sky130_ef_sc_hd__decap_12
XFILLER_98_141 VGND VGND VPWR VPWR sky130_fd_sc_hd__decap_6
Xfanout338 u_interface.u_gelu_fp32.u_q16_to_fp32.s2_clz\[0\] VGND VGND VPWR VPWR net338
+ sky130_fd_sc_hd__clkbuf_4
XFILLER_87_837 VGND VGND VPWR VPWR sky130_fd_sc_hd__decap_3
X_09812_ net593 net437 net433 net581 VGND VGND VPWR VPWR _03566_ sky130_fd_sc_hd__a22oi_1
Xfanout316 net317 VGND VGND VPWR VPWR net316 sky130_fd_sc_hd__clkbuf_4
XFILLER_59_517 VPWR VGND VPWR VGND sky130_ef_sc_hd__decap_12
XFILLER_113_485 VGND VGND VPWR VPWR sky130_fd_sc_hd__decap_4
XFILLER_100_102 VGND VGND VPWR VPWR sky130_fd_sc_hd__decap_8
Xfanout349 u_interface.core_data_out\[18\] VGND VGND VPWR VPWR net349 sky130_fd_sc_hd__dlymetal6s2s_1
X_09743_ _03389_ _03391_ _03494_ _03495_ VGND VGND VPWR VPWR _03498_ sky130_fd_sc_hd__a211o_1
X_06955_ u_interface.u_gelu_fp32.u_synth_top.s1_x\[27\] net275 _01484_ VGND VGND VPWR
+ VPWR _01485_ sky130_fd_sc_hd__a21o_1
XFILLER_74_509 VGND VGND VPWR VPWR sky130_fd_sc_hd__decap_6
XTAP_TAPCELL_ROW_107_2049 VGND VPWR sky130_fd_sc_hd__tapvpwrvgnd_1
X_09674_ _03422_ _03427_ VGND VGND VPWR VPWR _03429_ sky130_fd_sc_hd__xnor2_1
X_06886_ u_interface.u_gelu_fp32.u_synth_top.s1_hits\[13\] u_interface.u_gelu_fp32.u_synth_top.s1_hits\[5\]
+ u_interface.u_gelu_fp32.u_synth_top.s1_hits\[4\] u_interface.u_gelu_fp32.u_synth_top.s1_hits\[2\]
+ VGND VGND VPWR VPWR _01429_ sky130_fd_sc_hd__or4_1
XFILLER_55_734 VGND VGND VPWR VPWR sky130_fd_sc_hd__fill_1
XFILLER_36_27 VGND VGND VPWR VPWR sky130_fd_sc_hd__fill_1
X_08625_ _02174_ _02241_ _02173_ VGND VGND VPWR VPWR _02399_ sky130_fd_sc_hd__a21o_1
XFILLER_15_609 VGND VGND VPWR VPWR sky130_fd_sc_hd__decap_6
XTAP_TAPCELL_ROW_38_943 VGND VPWR sky130_fd_sc_hd__tapvpwrvgnd_1
XFILLER_54_277 VGND VGND VPWR VPWR sky130_fd_sc_hd__decap_8
X_08556_ _02161_ _02316_ VGND VGND VPWR VPWR _02347_ sky130_fd_sc_hd__xor2_1
X_07507_ net553 _01584_ VGND VGND VPWR VPWR _01638_ sky130_fd_sc_hd__or2_1
XTAP_TAPCELL_ROW_120_2249 VGND VPWR sky130_fd_sc_hd__tapvpwrvgnd_1
XFILLER_52_15 VPWR VGND VPWR VGND sky130_ef_sc_hd__decap_12
XFILLER_52_37 VGND VGND VPWR VPWR sky130_fd_sc_hd__fill_1
XFILLER_22_141 VPWR VGND VPWR VGND sky130_ef_sc_hd__decap_12
XFILLER_23_653 VPWR VGND VPWR VGND sky130_ef_sc_hd__decap_12
X_08487_ net522 u_interface.u_gelu_fp32.u_synth_top.s3_mult\[44\] VGND VGND VPWR VPWR
+ _02278_ sky130_fd_sc_hd__or2_1
X_07438_ u_interface.u_gelu_fp32.u_fp32_to_q16.s2_norm_mag\[21\] u_interface.u_gelu_fp32.u_fp32_to_q16.s2_norm_mag\[22\]
+ net558 VGND VGND VPWR VPWR _01573_ sky130_fd_sc_hd__mux2_1
XFILLER_139_6 VGND VGND VPWR VPWR sky130_fd_sc_hd__fill_1
XTAP_TAPCELL_ROW_102_1971 VGND VPWR sky130_fd_sc_hd__tapvpwrvgnd_1
XTAP_TAPCELL_ROW_102_1960 VGND VPWR sky130_fd_sc_hd__tapvpwrvgnd_1
XFILLER_10_325 VGND VGND VPWR VPWR sky130_fd_sc_hd__fill_1
XFILLER_23_697 VPWR VGND VPWR VGND sky130_ef_sc_hd__decap_12
X_07369_ net1015 net381 net237 VGND VGND VPWR VPWR _00399_ sky130_fd_sc_hd__mux2_1
XFILLER_6_307 VGND VGND VPWR VPWR sky130_fd_sc_hd__fill_1
X_09108_ _02864_ _02865_ _02863_ VGND VGND VPWR VPWR _02867_ sky130_fd_sc_hd__a21bo_1
XFILLER_136_533 VGND VGND VPWR VPWR sky130_fd_sc_hd__decap_8
XTAP_TAPCELL_ROW_135_2492 VGND VPWR sky130_fd_sc_hd__tapvpwrvgnd_1
X_10380_ _04127_ _04128_ _04124_ VGND VGND VPWR VPWR _04129_ sky130_fd_sc_hd__a21o_1
X_09039_ _02784_ _02796_ VGND VGND VPWR VPWR _02798_ sky130_fd_sc_hd__xnor2_1
XFILLER_124_739 VGND VGND VPWR VPWR sky130_fd_sc_hd__fill_1
XFILLER_2_513 VPWR VGND VPWR VGND sky130_ef_sc_hd__decap_12
Xhold381 _01016_ VGND VGND VPWR VPWR net1246 sky130_fd_sc_hd__dlygate4sd3_1
Xhold370 u_interface.fifo_data\[15\]\[18\] VGND VGND VPWR VPWR net1235 sky130_fd_sc_hd__dlygate4sd3_1
XFILLER_2_557 VPWR VGND VPWR VGND sky130_ef_sc_hd__decap_12
X_12050_ _05781_ _05782_ VGND VGND VPWR VPWR _05783_ sky130_fd_sc_hd__and2_1
XFILLER_89_163 VGND VGND VPWR VPWR sky130_fd_sc_hd__decap_4
X_11001_ net634 net418 net413 net628 VGND VGND VPWR VPWR _04745_ sky130_fd_sc_hd__a22oi_1
Xhold392 u_interface.fifo_data\[15\]\[2\] VGND VGND VPWR VPWR net1257 sky130_fd_sc_hd__dlygate4sd3_1
XFILLER_89_185 VGND VGND VPWR VPWR sky130_fd_sc_hd__fill_2
XFILLER_77_347 VGND VGND VPWR VPWR sky130_fd_sc_hd__fill_2
XFILLER_92_306 VGND VGND VPWR VPWR sky130_fd_sc_hd__fill_2
X_12952_ _06470_ _06471_ u_interface.fifo_count\[0\] VGND VGND VPWR VPWR _06473_ sky130_fd_sc_hd__or3b_1
XFILLER_92_317 VGND VGND VPWR VPWR sky130_fd_sc_hd__fill_1
XFILLER_73_520 VGND VGND VPWR VPWR sky130_fd_sc_hd__decap_3
X_11903_ _05636_ _05637_ VGND VGND VPWR VPWR _05638_ sky130_fd_sc_hd__nand2_1
X_12883_ net787 net944 VGND VGND VPWR VPWR _01025_ sky130_fd_sc_hd__and2_1
XFILLER_93_88 VGND VGND VPWR VPWR sky130_fd_sc_hd__fill_1
XFILLER_61_748 VGND VGND VPWR VPWR sky130_fd_sc_hd__decap_4
XFILLER_45_288 VPWR VGND VPWR VGND sky130_ef_sc_hd__decap_12
X_11834_ _05567_ _05568_ VGND VGND VPWR VPWR _05569_ sky130_fd_sc_hd__nor2_1
X_11765_ _05428_ _05434_ _05435_ VGND VGND VPWR VPWR _05501_ sky130_fd_sc_hd__a21boi_1
XTAP_TAPCELL_ROW_155_2835 VGND VPWR sky130_fd_sc_hd__tapvpwrvgnd_1
XTAP_TAPCELL_ROW_155_2824 VGND VPWR sky130_fd_sc_hd__tapvpwrvgnd_1
XTAP_TAPCELL_ROW_155_2813 VGND VPWR sky130_fd_sc_hd__tapvpwrvgnd_1
X_13504_ clknet_leaf_5_clk _00514_ VGND VGND VPWR VPWR u_interface.u_gelu_fp32.u_synth_top.s2_m\[7\]
+ sky130_fd_sc_hd__dfxtp_1
X_10716_ net464 net468 net712 net722 VGND VGND VPWR VPWR _04462_ sky130_fd_sc_hd__nand4_1
X_11696_ net701 net420 _05430_ _05431_ VGND VGND VPWR VPWR _05433_ sky130_fd_sc_hd__nand4_1
X_13435_ clknet_leaf_11_clk _00445_ VGND VGND VPWR VPWR u_interface.u_gelu_fp32.u_fp32_to_q16.s3_mag\[6\]
+ sky130_fd_sc_hd__dfxtp_1
X_10647_ net579 net586 net405 net400 VGND VGND VPWR VPWR _04394_ sky130_fd_sc_hd__and4_1
XFILLER_9_167 VGND VGND VPWR VPWR sky130_fd_sc_hd__fill_1
XFILLER_139_393 VGND VGND VPWR VPWR sky130_fd_sc_hd__decap_6
XFILLER_10_881 VPWR VGND VPWR VGND sky130_ef_sc_hd__decap_12
X_13366_ clknet_leaf_53_clk _00376_ VGND VGND VPWR VPWR u_interface.fifo_data\[7\]\[11\]
+ sky130_fd_sc_hd__dfxtp_1
X_10578_ net277 _03869_ _04323_ VGND VGND VPWR VPWR _04325_ sky130_fd_sc_hd__nand3_1
XFILLER_155_897 VPWR VGND VPWR VGND sky130_ef_sc_hd__decap_12
XTAP_TAPCELL_ROW_58_1269 VGND VPWR sky130_fd_sc_hd__tapvpwrvgnd_1
XTAP_TAPCELL_ROW_58_1258 VGND VPWR sky130_fd_sc_hd__tapvpwrvgnd_1
X_12317_ _06004_ _06045_ VGND VGND VPWR VPWR _06046_ sky130_fd_sc_hd__xor2_1
X_13297_ clknet_leaf_72_clk _00307_ VGND VGND VPWR VPWR u_interface.fifo_data\[8\]\[6\]
+ sky130_fd_sc_hd__dfxtp_1
X_12248_ _05976_ _05977_ VGND VGND VPWR VPWR _05978_ sky130_fd_sc_hd__and2b_1
XPHY_EDGE_ROW_39_Left_195 VGND VGND VPWR VPWR sky130_fd_sc_hd__decap_3
XFILLER_96_601 VPWR VGND VPWR VGND sky130_ef_sc_hd__decap_12
XFILLER_123_794 VGND VGND VPWR VPWR sky130_fd_sc_hd__decap_6
XFILLER_96_645 VGND VGND VPWR VPWR sky130_fd_sc_hd__decap_8
XTAP_TAPCELL_ROW_71_1469 VGND VPWR sky130_fd_sc_hd__tapvpwrvgnd_1
XFILLER_68_347 VPWR VGND VPWR VGND sky130_ef_sc_hd__decap_12
XFILLER_68_325 VGND VGND VPWR VPWR sky130_fd_sc_hd__fill_2
X_12179_ _05882_ _05909_ VGND VGND VPWR VPWR _05910_ sky130_fd_sc_hd__xnor2_1
XFILLER_84_829 VGND VGND VPWR VPWR sky130_fd_sc_hd__decap_3
X_06740_ _01297_ _01298_ _01301_ net319 VGND VGND VPWR VPWR net113 sky130_fd_sc_hd__a22o_1
XFILLER_95_188 VGND VGND VPWR VPWR sky130_fd_sc_hd__decap_8
XFILLER_76_391 VGND VGND VPWR VPWR sky130_fd_sc_hd__decap_4
X_06671_ net320 _01240_ VGND VGND VPWR VPWR _01241_ sky130_fd_sc_hd__or2_1
XFILLER_37_745 VGND VGND VPWR VPWR sky130_fd_sc_hd__decap_4
X_08410_ _02199_ _02200_ VGND VGND VPWR VPWR _02201_ sky130_fd_sc_hd__nand2_1
XFILLER_64_586 VGND VGND VPWR VPWR sky130_fd_sc_hd__fill_2
XTAP_TAPCELL_ROW_35_902 VGND VPWR sky130_fd_sc_hd__tapvpwrvgnd_1
XFILLER_36_277 VPWR VGND VPWR VGND sky130_ef_sc_hd__decap_12
X_09390_ _03143_ _03144_ _03145_ VGND VGND VPWR VPWR _03148_ sky130_fd_sc_hd__and3_1
XFILLER_51_225 VGND VGND VPWR VPWR sky130_fd_sc_hd__fill_1
XFILLER_51_247 VGND VGND VPWR VPWR sky130_fd_sc_hd__fill_2
X_08341_ net531 net1672 _02137_ net797 VGND VGND VPWR VPWR _02139_ sky130_fd_sc_hd__a31o_1
XFILLER_32_450 VGND VGND VPWR VPWR sky130_fd_sc_hd__fill_2
XFILLER_149_113 VGND VGND VPWR VPWR sky130_fd_sc_hd__fill_1
X_08272_ net533 _02086_ net1643 VGND VGND VPWR VPWR _02087_ sky130_fd_sc_hd__a21oi_1
XFILLER_20_601 VPWR VGND VPWR VGND sky130_ef_sc_hd__decap_12
XFILLER_20_645 VPWR VGND VPWR VGND sky130_ef_sc_hd__decap_12
XFILLER_22_29 VPWR VGND VPWR VGND sky130_ef_sc_hd__decap_12
X_07223_ net561 net1351 net257 VGND VGND VPWR VPWR _00263_ sky130_fd_sc_hd__mux2_1
XFILLER_138_29 VGND VGND VPWR VPWR sky130_fd_sc_hd__decap_4
X_07154_ net1128 net571 net220 VGND VGND VPWR VPWR _00194_ sky130_fd_sc_hd__mux2_1
XFILLER_146_897 VGND VGND VPWR VPWR sky130_fd_sc_hd__fill_1
XFILLER_133_503 VGND VGND VPWR VPWR sky130_fd_sc_hd__fill_1
X_07085_ net1277 net376 net226 VGND VGND VPWR VPWR _00125_ sky130_fd_sc_hd__mux2_1
XFILLER_59_325 VGND VGND VPWR VPWR sky130_fd_sc_hd__fill_1
X_07987_ net774 net975 _01855_ VGND VGND VPWR VPWR _00698_ sky130_fd_sc_hd__o21a_1
XFILLER_113_293 VPWR VGND VPWR VGND sky130_ef_sc_hd__decap_12
Xfanout168 _01896_ VGND VGND VPWR VPWR net168 sky130_fd_sc_hd__buf_2
Xfanout157 net159 VGND VGND VPWR VPWR net157 sky130_fd_sc_hd__clkbuf_2
XFILLER_47_15 VPWR VGND VPWR VGND sky130_ef_sc_hd__decap_12
Xfanout179 _04921_ VGND VGND VPWR VPWR net179 sky130_fd_sc_hd__clkbuf_4
X_09726_ _03171_ _03480_ VGND VGND VPWR VPWR _03481_ sky130_fd_sc_hd__nand2_1
X_06938_ _01469_ _01470_ _01468_ VGND VGND VPWR VPWR _01472_ sky130_fd_sc_hd__a21oi_1
XFILLER_28_701 VPWR VGND VPWR VGND sky130_ef_sc_hd__decap_12
XFILLER_103_21 VGND VGND VPWR VPWR sky130_fd_sc_hd__fill_1
XFILLER_67_391 VGND VGND VPWR VPWR sky130_fd_sc_hd__fill_1
XTAP_TAPCELL_ROW_2_365 VGND VPWR sky130_fd_sc_hd__tapvpwrvgnd_1
XFILLER_27_222 VGND VGND VPWR VPWR sky130_fd_sc_hd__fill_2
X_09657_ _03411_ _03412_ _03240_ _03242_ VGND VGND VPWR VPWR _03413_ sky130_fd_sc_hd__o211a_1
XFILLER_103_76 VGND VGND VPWR VPWR sky130_fd_sc_hd__decap_3
X_06869_ u_interface.fifo_data\[8\]\[30\] u_interface.fifo_data\[9\]\[30\] u_interface.fifo_data\[10\]\[30\]
+ u_interface.fifo_data\[11\]\[30\] net760 net743 VGND VGND VPWR VPWR _01414_ sky130_fd_sc_hd__mux4_1
XFILLER_43_726 VGND VGND VPWR VPWR sky130_fd_sc_hd__fill_2
X_09588_ _03333_ _03343_ VGND VGND VPWR VPWR _03344_ sky130_fd_sc_hd__xnor2_1
X_08608_ _02186_ _02233_ VGND VGND VPWR VPWR _02387_ sky130_fd_sc_hd__xnor2_1
XFILLER_43_748 VGND VGND VPWR VPWR sky130_fd_sc_hd__decap_8
XFILLER_43_737 VGND VGND VPWR VPWR sky130_fd_sc_hd__decap_3
XFILLER_27_288 VGND VGND VPWR VPWR sky130_fd_sc_hd__decap_6
XFILLER_27_299 VGND VGND VPWR VPWR sky130_fd_sc_hd__decap_8
XFILLER_70_556 VGND VGND VPWR VPWR sky130_fd_sc_hd__decap_4
XFILLER_63_69 VPWR VGND VPWR VGND sky130_ef_sc_hd__decap_12
X_08539_ _02163_ _02166_ _02290_ VGND VGND VPWR VPWR _02330_ sky130_fd_sc_hd__and3_1
XTAP_TAPCELL_ROW_42_1004 VGND VPWR sky130_fd_sc_hd__tapvpwrvgnd_1
X_11550_ _05287_ _05288_ VGND VGND VPWR VPWR _05289_ sky130_fd_sc_hd__nand2_1
XTAP_TAPCELL_ROW_42_1015 VGND VPWR sky130_fd_sc_hd__tapvpwrvgnd_1
XTAP_TAPCELL_ROW_137_2532 VGND VPWR sky130_fd_sc_hd__tapvpwrvgnd_1
XTAP_TAPCELL_ROW_137_2521 VGND VPWR sky130_fd_sc_hd__tapvpwrvgnd_1
X_10501_ _04123_ _04129_ _04130_ VGND VGND VPWR VPWR _04249_ sky130_fd_sc_hd__a21bo_1
XFILLER_10_133 VGND VGND VPWR VPWR sky130_fd_sc_hd__decap_6
XFILLER_137_820 VGND VGND VPWR VPWR sky130_fd_sc_hd__decap_4
X_13220_ clknet_leaf_67_clk _00230_ VGND VGND VPWR VPWR u_interface.fifo_data\[12\]\[30\]
+ sky130_fd_sc_hd__dfxtp_1
X_11481_ net185 _05219_ VGND VGND VPWR VPWR _05220_ sky130_fd_sc_hd__xor2_1
XFILLER_10_177 VGND VGND VPWR VPWR sky130_fd_sc_hd__decap_8
XTAP_TAPCELL_ROW_21_673 VGND VPWR sky130_fd_sc_hd__tapvpwrvgnd_1
X_10432_ _04104_ _04105_ _04179_ _04180_ VGND VGND VPWR VPWR _04181_ sky130_fd_sc_hd__o22a_1
XTAP_TAPCELL_ROW_150_2743 VGND VPWR sky130_fd_sc_hd__tapvpwrvgnd_1
XTAP_TAPCELL_ROW_150_2732 VGND VPWR sky130_fd_sc_hd__tapvpwrvgnd_1
X_13151_ clknet_leaf_36_clk _00161_ VGND VGND VPWR VPWR u_interface.fifo_tlast\[6\]
+ sky130_fd_sc_hd__dfxtp_1
XFILLER_137_897 VGND VGND VPWR VPWR sky130_fd_sc_hd__fill_1
XFILLER_136_363 VGND VGND VPWR VPWR sky130_fd_sc_hd__fill_1
XFILLER_124_503 VGND VGND VPWR VPWR sky130_fd_sc_hd__decap_3
XFILLER_109_577 VGND VGND VPWR VPWR sky130_fd_sc_hd__fill_1
XFILLER_88_11 VGND VGND VPWR VPWR sky130_fd_sc_hd__fill_1
X_10363_ net473 net707 VGND VGND VPWR VPWR _04112_ sky130_fd_sc_hd__and2_1
XFILLER_152_867 VGND VGND VPWR VPWR sky130_fd_sc_hd__fill_1
XFILLER_124_558 VPWR VGND VPWR VGND sky130_ef_sc_hd__decap_12
XFILLER_3_833 VGND VGND VPWR VPWR sky130_fd_sc_hd__decap_6
XFILLER_2_321 VPWR VGND VPWR VGND sky130_ef_sc_hd__decap_12
X_12102_ net684 net395 _05760_ _05759_ VGND VGND VPWR VPWR _05834_ sky130_fd_sc_hd__a31o_1
X_13082_ clknet_leaf_74_clk _00092_ VGND VGND VPWR VPWR u_interface.fifo_data\[15\]\[3\]
+ sky130_fd_sc_hd__dfxtp_1
XFILLER_88_88 VGND VGND VPWR VPWR sky130_fd_sc_hd__decap_6
X_10294_ net626 net635 net446 net441 VGND VGND VPWR VPWR _04044_ sky130_fd_sc_hd__and4_1
XFILLER_3_877 VPWR VGND VPWR VGND sky130_ef_sc_hd__decap_12
XFILLER_2_365 VPWR VGND VPWR VGND sky130_ef_sc_hd__decap_12
X_12033_ _05682_ _05691_ _05690_ VGND VGND VPWR VPWR _05766_ sky130_fd_sc_hd__a21oi_1
XFILLER_105_794 VGND VGND VPWR VPWR sky130_fd_sc_hd__fill_1
XFILLER_77_111 VGND VGND VPWR VPWR sky130_fd_sc_hd__fill_1
XFILLER_120_775 VGND VGND VPWR VPWR sky130_fd_sc_hd__decap_8
XTAP_TAPCELL_ROW_53_1188 VGND VPWR sky130_fd_sc_hd__tapvpwrvgnd_1
XTAP_TAPCELL_ROW_53_1177 VGND VPWR sky130_fd_sc_hd__tapvpwrvgnd_1
Xfanout680 net681 VGND VGND VPWR VPWR net680 sky130_fd_sc_hd__buf_2
Xfanout691 u_interface.u_gelu_fp32.u_synth_top.s2_m\[13\] VGND VGND VPWR VPWR net691
+ sky130_fd_sc_hd__clkbuf_2
XFILLER_77_177 VGND VGND VPWR VPWR sky130_fd_sc_hd__decap_3
XFILLER_18_200 VGND VGND VPWR VPWR sky130_fd_sc_hd__decap_8
XFILLER_74_851 VGND VGND VPWR VPWR sky130_fd_sc_hd__decap_4
XFILLER_58_380 VPWR VGND VPWR VGND sky130_ef_sc_hd__decap_12
X_13984_ clknet_leaf_83_clk _00910_ VGND VGND VPWR VPWR u_interface.u_gelu_fp32.u_q16_to_fp32.s2_mag\[29\]
+ sky130_fd_sc_hd__dfxtp_1
X_12935_ u_interface.in_flight_count\[3\] _06438_ _06458_ VGND VGND VPWR VPWR _06459_
+ sky130_fd_sc_hd__o21a_1
XFILLER_18_277 VPWR VGND VPWR VGND sky130_ef_sc_hd__decap_12
XFILLER_37_92 VGND VGND VPWR VPWR sky130_fd_sc_hd__fill_1
X_12866_ net1242 u_interface.u_gelu_fp32.u_fp32_to_q16.s2_norm_mag\[21\] net818 VGND
+ VGND VPWR VPWR _01010_ sky130_fd_sc_hd__mux2_1
XTAP_TAPCELL_ROW_29_795 VGND VPWR sky130_fd_sc_hd__tapvpwrvgnd_1
XFILLER_33_225 VPWR VGND VPWR VGND sky130_ef_sc_hd__decap_12
XFILLER_34_737 VPWR VGND VPWR VGND sky130_ef_sc_hd__decap_12
XFILLER_33_269 VGND VGND VPWR VPWR sky130_fd_sc_hd__decap_8
X_11817_ _05404_ _05467_ _05466_ VGND VGND VPWR VPWR _05553_ sky130_fd_sc_hd__a21boi_1
X_12797_ u_interface.u_gelu_fp32.u_q16_to_fp32.s3_norm_mag\[26\] u_interface.u_gelu_fp32.u_q16_to_fp32.s3_norm_mag\[25\]
+ _01786_ u_interface.u_gelu_fp32.u_q16_to_fp32.s3_norm_mag\[27\] VGND VGND VPWR VPWR
+ _06415_ sky130_fd_sc_hd__a31o_1
XFILLER_147_628 VGND VGND VPWR VPWR sky130_fd_sc_hd__decap_3
X_11748_ _05482_ _05484_ _05480_ VGND VGND VPWR VPWR _05485_ sky130_fd_sc_hd__a21o_1
X_11679_ net719 net429 net424 VGND VGND VPWR VPWR _05416_ sky130_fd_sc_hd__and3_1
XTAP_TAPCELL_ROW_40_971 VGND VPWR sky130_fd_sc_hd__tapvpwrvgnd_1
XTAP_TAPCELL_ROW_40_982 VGND VPWR sky130_fd_sc_hd__tapvpwrvgnd_1
XFILLER_155_650 VGND VGND VPWR VPWR sky130_fd_sc_hd__decap_4
X_13418_ clknet_leaf_76_clk _00428_ VGND VGND VPWR VPWR u_interface.fifo_data\[6\]\[31\]
+ sky130_fd_sc_hd__dfxtp_1
X_13349_ clknet_leaf_40_clk _00359_ VGND VGND VPWR VPWR u_interface.fifo_data\[10\]\[26\]
+ sky130_fd_sc_hd__dfxtp_1
XFILLER_115_503 VGND VGND VPWR VPWR sky130_fd_sc_hd__fill_1
XFILLER_52_3 VPWR VGND VPWR VGND sky130_ef_sc_hd__decap_12
XPHY_EDGE_ROW_47_Left_203 VGND VGND VPWR VPWR sky130_fd_sc_hd__decap_3
XTAP_TAPCELL_ROW_73_1509 VGND VPWR sky130_fd_sc_hd__tapvpwrvgnd_1
XFILLER_6_693 VGND VGND VPWR VPWR sky130_fd_sc_hd__decap_6
XFILLER_5_181 VPWR VGND VPWR VGND sky130_ef_sc_hd__decap_12
XFILLER_142_377 VPWR VGND VPWR VGND sky130_ef_sc_hd__decap_12
XFILLER_130_506 VGND VGND VPWR VPWR sky130_fd_sc_hd__decap_8
X_07910_ net775 net94 VGND VGND VPWR VPWR _00669_ sky130_fd_sc_hd__and2_1
X_08890_ _02645_ _02646_ _02647_ VGND VGND VPWR VPWR _02649_ sky130_fd_sc_hd__a21o_1
X_07841_ net370 net1531 net284 VGND VGND VPWR VPWR _00602_ sky130_fd_sc_hd__mux2_1
XFILLER_111_775 VGND VGND VPWR VPWR sky130_fd_sc_hd__fill_1
XFILLER_69_689 VGND VGND VPWR VPWR sky130_fd_sc_hd__fill_2
X_07772_ net1003 net381 net233 VGND VGND VPWR VPWR _00533_ sky130_fd_sc_hd__mux2_1
X_09511_ _03227_ _03265_ _03266_ VGND VGND VPWR VPWR _03268_ sky130_fd_sc_hd__nand3_2
X_06723_ _01285_ _01286_ net733 VGND VGND VPWR VPWR _01287_ sky130_fd_sc_hd__mux2_1
XTAP_TAPCELL_ROW_88_1741 VGND VPWR sky130_fd_sc_hd__tapvpwrvgnd_1
XFILLER_84_648 VGND VGND VPWR VPWR sky130_fd_sc_hd__decap_8
XPHY_EDGE_ROW_56_Left_212 VGND VGND VPWR VPWR sky130_fd_sc_hd__decap_3
XFILLER_49_391 VGND VGND VPWR VPWR sky130_fd_sc_hd__fill_1
XFILLER_37_542 VGND VGND VPWR VPWR sky130_fd_sc_hd__fill_2
XFILLER_83_169 VGND VGND VPWR VPWR sky130_fd_sc_hd__decap_8
X_09442_ _03198_ _03199_ _02685_ _02687_ VGND VGND VPWR VPWR _03200_ sky130_fd_sc_hd__o211a_1
XFILLER_52_545 VGND VGND VPWR VPWR sky130_fd_sc_hd__fill_1
X_06654_ net729 _01225_ VGND VGND VPWR VPWR _01226_ sky130_fd_sc_hd__or2_1
XFILLER_37_597 VPWR VGND VPWR VGND sky130_ef_sc_hd__decap_12
X_09373_ _02816_ _03131_ VGND VGND VPWR VPWR _03132_ sky130_fd_sc_hd__or2_1
X_06585_ u_interface.u_gelu_fp32.s1_data\[23\] u_interface.u_gelu_fp32.s1_data\[22\]
+ _01171_ _01172_ VGND VGND VPWR VPWR _01173_ sky130_fd_sc_hd__and4_1
X_08324_ net529 _02125_ net1634 VGND VGND VPWR VPWR _02126_ sky130_fd_sc_hd__a21oi_1
XFILLER_33_39 VPWR VGND VPWR VGND sky130_ef_sc_hd__decap_12
XTAP_TAPCELL_ROW_119_2240 VGND VPWR sky130_fd_sc_hd__tapvpwrvgnd_1
X_08255_ net982 _02074_ net782 VGND VGND VPWR VPWR _02075_ sky130_fd_sc_hd__o21ai_1
X_07206_ net357 net1567 net259 VGND VGND VPWR VPWR _00246_ sky130_fd_sc_hd__mux2_1
X_08186_ net315 _02019_ _02020_ VGND VGND VPWR VPWR _02021_ sky130_fd_sc_hd__or3_1
XPHY_EDGE_ROW_65_Left_221 VGND VGND VPWR VPWR sky130_fd_sc_hd__decap_3
XFILLER_134_801 VGND VGND VPWR VPWR sky130_fd_sc_hd__fill_2
XTAP_TAPCELL_ROW_132_2440 VGND VPWR sky130_fd_sc_hd__tapvpwrvgnd_1
XFILLER_118_363 VGND VGND VPWR VPWR sky130_fd_sc_hd__fill_1
X_07137_ net1412 net367 net217 VGND VGND VPWR VPWR _00177_ sky130_fd_sc_hd__mux2_1
XTAP_TAPCELL_ROW_132_2451 VGND VPWR sky130_fd_sc_hd__tapvpwrvgnd_1
XFILLER_134_878 VGND VGND VPWR VPWR sky130_fd_sc_hd__fill_1
X_07068_ net1125 net347 net210 VGND VGND VPWR VPWR _00108_ sky130_fd_sc_hd__mux2_1
XFILLER_121_517 VPWR VGND VPWR VGND sky130_ef_sc_hd__decap_12
XFILLER_59_111 VGND VGND VPWR VPWR sky130_fd_sc_hd__fill_1
XTAP_TAPCELL_ROW_7_446 VGND VPWR sky130_fd_sc_hd__tapvpwrvgnd_1
XFILLER_0_825 VPWR VGND VPWR VGND sky130_ef_sc_hd__decap_12
XFILLER_0_869 VGND VGND VPWR VPWR sky130_fd_sc_hd__decap_8
XFILLER_101_263 VGND VGND VPWR VPWR sky130_fd_sc_hd__fill_1
XPHY_EDGE_ROW_74_Left_230 VGND VGND VPWR VPWR sky130_fd_sc_hd__decap_3
XFILLER_48_829 VGND VGND VPWR VPWR sky130_fd_sc_hd__decap_3
XFILLER_101_296 VGND VGND VPWR VPWR sky130_fd_sc_hd__fill_2
XFILLER_75_659 VGND VGND VPWR VPWR sky130_fd_sc_hd__fill_2
XFILLER_74_147 VPWR VGND VPWR VGND sky130_ef_sc_hd__decap_12
XFILLER_74_136 VGND VGND VPWR VPWR sky130_fd_sc_hd__fill_1
XFILLER_28_531 VGND VGND VPWR VPWR sky130_fd_sc_hd__fill_1
X_09709_ _03429_ _03462_ _03463_ VGND VGND VPWR VPWR _03464_ sky130_fd_sc_hd__and3_1
XFILLER_83_670 VGND VGND VPWR VPWR sky130_fd_sc_hd__fill_2
XFILLER_62_309 VPWR VGND VPWR VGND sky130_ef_sc_hd__decap_12
X_10981_ _04721_ _04724_ VGND VGND VPWR VPWR _04725_ sky130_fd_sc_hd__xnor2_1
X_12720_ _01728_ net288 _06373_ VGND VGND VPWR VPWR _00923_ sky130_fd_sc_hd__a21o_1
XFILLER_16_737 VPWR VGND VPWR VGND sky130_ef_sc_hd__decap_12
X_12651_ net1656 u_interface.u_gelu_fp32.u_q16_to_fp32.s2_mag\[6\] net805 VGND VGND
+ VPWR VPWR _00887_ sky130_fd_sc_hd__mux2_1
XTAP_TAPCELL_ROW_26_754 VGND VPWR sky130_fd_sc_hd__tapvpwrvgnd_1
XFILLER_130_85 VGND VGND VPWR VPWR sky130_fd_sc_hd__fill_1
XFILLER_24_781 VPWR VGND VPWR VGND sky130_ef_sc_hd__decap_12
XFILLER_31_729 VPWR VGND VPWR VGND sky130_ef_sc_hd__decap_12
X_11602_ _05337_ _05338_ _05240_ VGND VGND VPWR VPWR _05340_ sky130_fd_sc_hd__or3b_1
X_12582_ net33 net5 net4 net7 VGND VGND VPWR VPWR _06286_ sky130_fd_sc_hd__or4_1
XFILLER_129_617 VGND VGND VPWR VPWR sky130_fd_sc_hd__decap_3
XFILLER_90_56 VGND VGND VPWR VPWR sky130_fd_sc_hd__decap_8
XFILLER_129_639 VGND VGND VPWR VPWR sky130_fd_sc_hd__fill_1
XFILLER_129_628 VGND VGND VPWR VPWR sky130_fd_sc_hd__decap_6
XFILLER_11_464 VGND VGND VPWR VPWR sky130_fd_sc_hd__decap_4
X_11533_ net617 net387 VGND VGND VPWR VPWR _05272_ sky130_fd_sc_hd__and2b_1
X_11464_ _05028_ _05105_ _05104_ VGND VGND VPWR VPWR _05204_ sky130_fd_sc_hd__a21boi_1
X_13203_ clknet_leaf_34_clk _00213_ VGND VGND VPWR VPWR u_interface.fifo_data\[12\]\[13\]
+ sky130_fd_sc_hd__dfxtp_1
XFILLER_125_801 VPWR VGND VPWR VGND sky130_ef_sc_hd__decap_12
X_10415_ net618 net436 _04050_ _04049_ VGND VGND VPWR VPWR _04164_ sky130_fd_sc_hd__a31o_1
XFILLER_7_479 VPWR VGND VPWR VGND sky130_ef_sc_hd__decap_12
X_11395_ _05031_ _05134_ VGND VGND VPWR VPWR _05135_ sky130_fd_sc_hd__xnor2_1
XFILLER_124_355 VGND VGND VPWR VPWR sky130_fd_sc_hd__decap_8
X_13134_ clknet_leaf_53_clk _00144_ VGND VGND VPWR VPWR u_interface.fifo_data\[2\]\[23\]
+ sky130_fd_sc_hd__dfxtp_1
X_10346_ _04088_ _04092_ _04093_ VGND VGND VPWR VPWR _04095_ sky130_fd_sc_hd__nand3_1
XTAP_TAPCELL_ROW_55_1217 VGND VPWR sky130_fd_sc_hd__tapvpwrvgnd_1
XFILLER_3_641 VPWR VGND VPWR VGND sky130_ef_sc_hd__decap_12
X_13065_ clknet_leaf_50_clk _00075_ VGND VGND VPWR VPWR u_interface.fifo_data\[14\]\[18\]
+ sky130_fd_sc_hd__dfxtp_1
X_10277_ _04024_ _04025_ _04026_ VGND VGND VPWR VPWR _04027_ sky130_fd_sc_hd__a21oi_1
XFILLER_3_685 VPWR VGND VPWR VGND sky130_ef_sc_hd__decap_12
XFILLER_2_195 VGND VGND VPWR VPWR sky130_fd_sc_hd__fill_1
X_12016_ _05740_ _05747_ VGND VGND VPWR VPWR _05749_ sky130_fd_sc_hd__nand2_1
XFILLER_93_401 VGND VGND VPWR VPWR sky130_fd_sc_hd__decap_8
XFILLER_65_103 VGND VGND VPWR VPWR sky130_fd_sc_hd__decap_8
XFILLER_38_339 VGND VGND VPWR VPWR sky130_fd_sc_hd__decap_8
X_13967_ clknet_leaf_59_clk net1554 VGND VGND VPWR VPWR u_interface.u_gelu_fp32.u_q16_to_fp32.s2_mag\[12\]
+ sky130_fd_sc_hd__dfxtp_1
XFILLER_65_169 VGND VGND VPWR VPWR sky130_fd_sc_hd__decap_8
X_12918_ _06443_ _06444_ VGND VGND VPWR VPWR _06445_ sky130_fd_sc_hd__nand2_1
XFILLER_80_128 VGND VGND VPWR VPWR sky130_fd_sc_hd__fill_1
X_13898_ clknet_leaf_19_clk net887 VGND VGND VPWR VPWR u_interface.u_gelu_fp32.u_synth_top.s1_x\[2\]
+ sky130_fd_sc_hd__dfxtp_1
X_12849_ _06423_ _06430_ u_interface.pipeline_enable VGND VGND VPWR VPWR _06431_ sky130_fd_sc_hd__o21bai_1
XTAP_TAPCELL_ROW_83_1671 VGND VPWR sky130_fd_sc_hd__tapvpwrvgnd_1
XTAP_TAPCELL_ROW_83_1660 VGND VPWR sky130_fd_sc_hd__tapvpwrvgnd_1
XFILLER_61_386 VGND VGND VPWR VPWR sky130_fd_sc_hd__decap_6
XFILLER_34_589 VPWR VGND VPWR VGND sky130_ef_sc_hd__decap_12
XFILLER_61_397 VGND VGND VPWR VPWR sky130_fd_sc_hd__fill_1
XFILLER_147_414 VGND VGND VPWR VPWR sky130_fd_sc_hd__fill_1
XFILLER_147_447 VGND VGND VPWR VPWR sky130_fd_sc_hd__fill_1
X_08040_ net541 net168 VGND VGND VPWR VPWR _01897_ sky130_fd_sc_hd__nor2_1
Xhold903 u_interface.u_gelu_fp32.u_synth_top.s2_b\[11\] VGND VGND VPWR VPWR net1768
+ sky130_fd_sc_hd__dlygate4sd3_1
Xhold914 u_interface.u_gelu_fp32.u_fp32_to_q16.s3_mag\[21\] VGND VGND VPWR VPWR net1779
+ sky130_fd_sc_hd__dlygate4sd3_1
XFILLER_142_152 VGND VGND VPWR VPWR sky130_fd_sc_hd__decap_8
XFILLER_116_867 VGND VGND VPWR VPWR sky130_fd_sc_hd__fill_1
X_09991_ _03530_ _03628_ _03519_ _03520_ VGND VGND VPWR VPWR _03744_ sky130_fd_sc_hd__o2bb2a_1
XFILLER_89_729 VGND VGND VPWR VPWR sky130_fd_sc_hd__decap_8
XFILLER_130_303 VGND VGND VPWR VPWR sky130_fd_sc_hd__decap_4
X_08942_ _02698_ _02700_ _02659_ VGND VGND VPWR VPWR _02701_ sky130_fd_sc_hd__a21oi_1
XTAP_TAPCELL_ROW_110_2089 VGND VPWR sky130_fd_sc_hd__tapvpwrvgnd_1
XFILLER_69_442 VGND VGND VPWR VPWR sky130_fd_sc_hd__decap_6
XTAP_TAPCELL_ROW_4_405 VGND VPWR sky130_fd_sc_hd__tapvpwrvgnd_1
X_08873_ net454 net585 net458 net589 VGND VGND VPWR VPWR _02632_ sky130_fd_sc_hd__and4_1
XFILLER_96_250 VGND VGND VPWR VPWR sky130_fd_sc_hd__fill_2
XFILLER_84_412 VGND VGND VPWR VPWR sky130_fd_sc_hd__decap_8
XFILLER_29_317 VPWR VGND VPWR VGND sky130_ef_sc_hd__decap_12
XFILLER_151_18 VPWR VGND VPWR VGND sky130_ef_sc_hd__decap_12
X_07824_ net1161 net340 net231 VGND VGND VPWR VPWR _00585_ sky130_fd_sc_hd__mux2_1
XFILLER_84_445 VPWR VGND VPWR VGND sky130_ef_sc_hd__decap_12
X_07755_ net1788 _01794_ net294 VGND VGND VPWR VPWR _01797_ sky130_fd_sc_hd__o21ai_1
X_07686_ u_interface.u_gelu_fp32.u_synth_top.s1_hits\[17\] u_interface.u_gelu_fp32.u_synth_top.s1_hits\[3\]
+ VGND VGND VPWR VPWR _01759_ sky130_fd_sc_hd__or2_1
X_06706_ u_interface.fifo_data\[4\]\[9\] u_interface.fifo_data\[5\]\[9\] u_interface.fifo_data\[6\]\[9\]
+ u_interface.fifo_data\[7\]\[9\] net759 net742 VGND VGND VPWR VPWR _01272_ sky130_fd_sc_hd__mux4_1
XFILLER_25_512 VGND VGND VPWR VPWR sky130_fd_sc_hd__decap_8
X_09425_ _03174_ _03182_ VGND VGND VPWR VPWR _03183_ sky130_fd_sc_hd__xnor2_1
X_06637_ u_interface.fifo_data\[12\]\[1\] u_interface.fifo_data\[13\]\[1\] u_interface.fifo_data\[14\]\[1\]
+ u_interface.fifo_data\[15\]\[1\] net764 net747 VGND VGND VPWR VPWR _01211_ sky130_fd_sc_hd__mux4_1
XFILLER_80_662 VGND VGND VPWR VPWR sky130_fd_sc_hd__decap_8
XFILLER_44_27 VGND VGND VPWR VPWR sky130_fd_sc_hd__fill_1
XFILLER_13_729 VPWR VGND VPWR VGND sky130_ef_sc_hd__decap_12
XTAP_TAPCELL_ROW_23_702 VGND VPWR sky130_fd_sc_hd__tapvpwrvgnd_1
X_09356_ _03036_ _03114_ VGND VGND VPWR VPWR _03115_ sky130_fd_sc_hd__nor2_1
X_06568_ _01153_ _01161_ VGND VGND VPWR VPWR _00010_ sky130_fd_sc_hd__nor2_1
XFILLER_100_44 VGND VGND VPWR VPWR sky130_fd_sc_hd__fill_1
X_06499_ u_interface.in_flight_count\[0\] VGND VGND VPWR VPWR _01099_ sky130_fd_sc_hd__inv_2
X_09287_ net583 net591 net501 net506 VGND VGND VPWR VPWR _03046_ sky130_fd_sc_hd__and4_1
X_08307_ u_interface.u_gelu_fp32.s2_data\[16\] _02110_ VGND VGND VPWR VPWR _02113_
+ sky130_fd_sc_hd__or2_1
XFILLER_60_15 VGND VGND VPWR VPWR sky130_fd_sc_hd__decap_6
XFILLER_20_250 VGND VGND VPWR VPWR sky130_fd_sc_hd__fill_2
X_08238_ net539 _02064_ _02047_ VGND VGND VPWR VPWR _02065_ sky130_fd_sc_hd__a21o_1
XFILLER_60_48 VGND VGND VPWR VPWR sky130_fd_sc_hd__fill_1
XFILLER_125_119 VGND VGND VPWR VPWR sky130_fd_sc_hd__fill_1
XFILLER_106_300 VGND VGND VPWR VPWR sky130_fd_sc_hd__decap_3
X_08169_ net167 _02005_ _02006_ net162 VGND VGND VPWR VPWR _02007_ sky130_fd_sc_hd__a31oi_1
X_10200_ _03841_ _03948_ _03949_ VGND VGND VPWR VPWR _03951_ sky130_fd_sc_hd__nand3_2
XFILLER_106_344 VGND VGND VPWR VPWR sky130_fd_sc_hd__fill_1
XFILLER_69_57 VPWR VGND VPWR VGND sky130_ef_sc_hd__decap_12
XFILLER_69_35 VGND VGND VPWR VPWR sky130_fd_sc_hd__fill_1
X_11180_ _04919_ net180 VGND VGND VPWR VPWR _04922_ sky130_fd_sc_hd__xnor2_1
X_10131_ net190 _03879_ _03880_ VGND VGND VPWR VPWR _03882_ sky130_fd_sc_hd__nand3_1
X_10062_ _03812_ _03813_ _03811_ VGND VGND VPWR VPWR _03814_ sky130_fd_sc_hd__a21o_1
XFILLER_85_34 VGND VGND VPWR VPWR sky130_fd_sc_hd__decap_8
XFILLER_75_412 VPWR VGND VPWR VGND sky130_ef_sc_hd__decap_12
XFILLER_75_401 VGND VGND VPWR VPWR sky130_fd_sc_hd__decap_4
XTAP_TAPCELL_ROW_50_1136 VGND VPWR sky130_fd_sc_hd__tapvpwrvgnd_1
XTAP_TAPCELL_ROW_145_2653 VGND VPWR sky130_fd_sc_hd__tapvpwrvgnd_1
X_13821_ clknet_leaf_81_clk _00831_ VGND VGND VPWR VPWR u_interface.u_gelu_fp32.u_synth_top.s3_mult\[39\]
+ sky130_fd_sc_hd__dfxtp_1
XFILLER_47_169 VGND VGND VPWR VPWR sky130_fd_sc_hd__decap_8
XFILLER_28_350 VGND VGND VPWR VPWR sky130_fd_sc_hd__fill_1
X_13752_ clknet_leaf_84_clk _00762_ VGND VGND VPWR VPWR u_interface.u_gelu_fp32.u_q16_to_fp32.s1_mag\[18\]
+ sky130_fd_sc_hd__dfxtp_1
XFILLER_18_83 VGND VGND VPWR VPWR sky130_fd_sc_hd__fill_1
XFILLER_29_895 VGND VGND VPWR VPWR sky130_fd_sc_hd__fill_1
X_12703_ u_interface.u_gelu_fp32.u_q16_to_fp32.s2_mag\[21\] u_interface.u_gelu_fp32.u_q16_to_fp32.s2_mag\[20\]
+ u_interface.u_gelu_fp32.u_q16_to_fp32.s2_mag\[19\] u_interface.u_gelu_fp32.u_q16_to_fp32.s2_mag\[18\]
+ net336 net332 VGND VGND VPWR VPWR _06360_ sky130_fd_sc_hd__mux4_1
X_10964_ _04706_ _04707_ VGND VGND VPWR VPWR _04708_ sky130_fd_sc_hd__nor2_1
X_13683_ clknet_leaf_10_clk _00693_ VGND VGND VPWR VPWR u_interface.u_gelu_fp32.u_fp32_to_q16.s3_frac\[19\]
+ sky130_fd_sc_hd__dfxtp_1
X_10895_ _04627_ _04639_ VGND VGND VPWR VPWR _04640_ sky130_fd_sc_hd__or2_1
XTAP_TAPCELL_ROW_48_1098 VGND VPWR sky130_fd_sc_hd__tapvpwrvgnd_1
XFILLER_16_589 VPWR VGND VPWR VGND sky130_ef_sc_hd__decap_12
X_12634_ net825 net1510 _06329_ _06334_ VGND VGND VPWR VPWR _00876_ sky130_fd_sc_hd__a22o_1
XFILLER_31_559 VGND VGND VPWR VPWR sky130_fd_sc_hd__fill_1
XFILLER_34_71 VGND VGND VPWR VPWR sky130_fd_sc_hd__decap_8
XFILLER_34_82 VGND VGND VPWR VPWR sky130_fd_sc_hd__fill_2
X_12565_ net784 net1741 VGND VGND VPWR VPWR _00863_ sky130_fd_sc_hd__and2_1
XFILLER_145_918 VGND VGND VPWR VPWR sky130_fd_sc_hd__decap_3
XFILLER_129_447 VGND VGND VPWR VPWR sky130_fd_sc_hd__fill_1
XFILLER_117_609 VGND VGND VPWR VPWR sky130_fd_sc_hd__decap_6
XFILLER_8_755 VGND VGND VPWR VPWR sky130_fd_sc_hd__fill_1
X_11516_ _05164_ _05167_ VGND VGND VPWR VPWR _05255_ sky130_fd_sc_hd__nand2_1
X_12496_ net182 _06183_ _06182_ VGND VGND VPWR VPWR _06221_ sky130_fd_sc_hd__a21oi_1
X_11447_ _05081_ _05090_ _05089_ VGND VGND VPWR VPWR _05187_ sky130_fd_sc_hd__a21boi_2
XFILLER_152_450 VPWR VGND VPWR VGND sky130_ef_sc_hd__decap_12
X_14166_ clknet_leaf_42_clk _01092_ VGND VGND VPWR VPWR u_interface.fifo_data\[1\]\[26\]
+ sky130_fd_sc_hd__dfxtp_1
XFILLER_125_653 VGND VGND VPWR VPWR sky130_fd_sc_hd__decap_4
X_11378_ _04912_ _05118_ VGND VGND VPWR VPWR _05119_ sky130_fd_sc_hd__or2_1
XFILLER_98_548 VGND VGND VPWR VPWR sky130_fd_sc_hd__decap_4
X_10329_ _03974_ _04075_ _04076_ VGND VGND VPWR VPWR _04079_ sky130_fd_sc_hd__and3_1
X_13117_ clknet_leaf_71_clk _00127_ VGND VGND VPWR VPWR u_interface.fifo_data\[2\]\[6\]
+ sky130_fd_sc_hd__dfxtp_1
XFILLER_140_645 VGND VGND VPWR VPWR sky130_fd_sc_hd__fill_2
X_14097_ clknet_leaf_33_clk _01023_ VGND VGND VPWR VPWR u_interface.meta_tuser_pipe\[10\]
+ sky130_fd_sc_hd__dfxtp_1
XFILLER_121_881 VGND VGND VPWR VPWR sky130_fd_sc_hd__decap_6
X_13048_ clknet_leaf_53_clk _00058_ VGND VGND VPWR VPWR u_interface.fifo_data\[14\]\[1\]
+ sky130_fd_sc_hd__dfxtp_1
XFILLER_100_509 VGND VGND VPWR VPWR sky130_fd_sc_hd__fill_2
XFILLER_39_615 VGND VGND VPWR VPWR sky130_fd_sc_hd__fill_1
XFILLER_94_754 VGND VGND VPWR VPWR sky130_fd_sc_hd__fill_2
XFILLER_15_3 VPWR VGND VPWR VGND sky130_ef_sc_hd__decap_12
XTAP_TAPCELL_ROW_85_1700 VGND VPWR sky130_fd_sc_hd__tapvpwrvgnd_1
XTAP_TAPCELL_ROW_68_1419 VGND VPWR sky130_fd_sc_hd__tapvpwrvgnd_1
XFILLER_26_309 VPWR VGND VPWR VGND sky130_ef_sc_hd__decap_12
XFILLER_38_147 VGND VGND VPWR VPWR sky130_fd_sc_hd__fill_1
X_07540_ net822 net1751 net304 _01651_ VGND VGND VPWR VPWR _00445_ sky130_fd_sc_hd__a22o_1
XFILLER_81_426 VPWR VGND VPWR VGND sky130_ef_sc_hd__decap_12
XFILLER_66_489 VPWR VGND VPWR VGND sky130_ef_sc_hd__decap_12
XFILLER_53_128 VPWR VGND VPWR VGND sky130_ef_sc_hd__decap_12
XFILLER_19_372 VPWR VGND VPWR VGND sky130_ef_sc_hd__decap_12
XFILLER_35_821 VPWR VGND VPWR VGND sky130_ef_sc_hd__decap_12
XFILLER_46_180 VGND VGND VPWR VPWR sky130_fd_sc_hd__decap_3
X_07471_ net557 _01556_ VGND VGND VPWR VPWR _01605_ sky130_fd_sc_hd__nor2_1
XFILLER_62_662 VGND VGND VPWR VPWR sky130_fd_sc_hd__fill_1
XFILLER_50_813 VGND VGND VPWR VPWR sky130_fd_sc_hd__decap_6
XFILLER_148_701 VGND VGND VPWR VPWR sky130_fd_sc_hd__decap_3
X_09210_ net615 net512 VGND VGND VPWR VPWR _02969_ sky130_fd_sc_hd__nand2_1
XFILLER_34_397 VGND VGND VPWR VPWR sky130_fd_sc_hd__fill_2
X_09141_ _02897_ _02898_ _02883_ VGND VGND VPWR VPWR _02900_ sky130_fd_sc_hd__a21o_1
XFILLER_147_244 VGND VGND VPWR VPWR sky130_fd_sc_hd__decap_4
X_09072_ _02828_ _02829_ _02830_ _02780_ VGND VGND VPWR VPWR _02831_ sky130_fd_sc_hd__and4bb_1
X_08023_ u_interface.u_gelu_fp32.u_fp32_to_q16.s3_mag\[11\] _01879_ VGND VGND VPWR
+ VPWR _01880_ sky130_fd_sc_hd__and2_1
XFILLER_30_29 VPWR VGND VPWR VGND sky130_ef_sc_hd__decap_12
XFILLER_146_29 VPWR VGND VPWR VGND sky130_ef_sc_hd__decap_12
XFILLER_146_18 VGND VGND VPWR VPWR sky130_fd_sc_hd__decap_8
XFILLER_135_439 VGND VGND VPWR VPWR sky130_fd_sc_hd__decap_3
Xhold700 u_interface.u_gelu_fp32.u_fp32_to_q16.s3_frac\[14\] VGND VGND VPWR VPWR net1565
+ sky130_fd_sc_hd__dlygate4sd3_1
Xhold711 u_interface.fifo_data\[7\]\[1\] VGND VGND VPWR VPWR net1576 sky130_fd_sc_hd__dlygate4sd3_1
Xhold744 u_interface.u_gelu_fp32.u_fp32_to_q16.s1_mant\[16\] VGND VGND VPWR VPWR net1609
+ sky130_fd_sc_hd__dlygate4sd3_1
Xhold733 u_interface.u_gelu_fp32.u_fp32_to_q16.s1_mant\[20\] VGND VGND VPWR VPWR net1598
+ sky130_fd_sc_hd__dlygate4sd3_1
Xhold755 _01019_ VGND VGND VPWR VPWR net1620 sky130_fd_sc_hd__dlygate4sd3_1
XTAP_TAPCELL_ROW_112_2129 VGND VPWR sky130_fd_sc_hd__tapvpwrvgnd_1
XTAP_TAPCELL_ROW_96_1873 VGND VPWR sky130_fd_sc_hd__tapvpwrvgnd_1
Xhold722 u_interface.fifo_data\[3\]\[6\] VGND VGND VPWR VPWR net1587 sky130_fd_sc_hd__dlygate4sd3_1
XFILLER_115_185 VPWR VGND VPWR VGND sky130_ef_sc_hd__decap_12
Xhold788 _00755_ VGND VGND VPWR VPWR net1653 sky130_fd_sc_hd__dlygate4sd3_1
Xhold766 u_interface.u_gelu_fp32.u_q16_to_fp32.s2_mag\[29\] VGND VGND VPWR VPWR net1631
+ sky130_fd_sc_hd__dlygate4sd3_1
Xhold777 u_interface.u_gelu_fp32.s2_data\[24\] VGND VGND VPWR VPWR net1642 sky130_fd_sc_hd__dlygate4sd3_1
X_09974_ _03667_ _03668_ _03725_ _03726_ VGND VGND VPWR VPWR _03727_ sky130_fd_sc_hd__a2bb2o_1
Xhold799 _00891_ VGND VGND VPWR VPWR net1664 sky130_fd_sc_hd__dlygate4sd3_1
XFILLER_39_27 VPWR VGND VPWR VGND sky130_ef_sc_hd__decap_12
XFILLER_130_155 VPWR VGND VPWR VGND sky130_ef_sc_hd__decap_12
X_08925_ _02682_ _02683_ _02679_ VGND VGND VPWR VPWR _02684_ sky130_fd_sc_hd__a21o_1
XFILLER_130_188 VGND VGND VPWR VPWR sky130_fd_sc_hd__fill_1
X_08856_ _02611_ _02612_ _02613_ VGND VGND VPWR VPWR _02615_ sky130_fd_sc_hd__a21o_1
XFILLER_111_391 VGND VGND VPWR VPWR sky130_fd_sc_hd__fill_1
XFILLER_57_423 VPWR VGND VPWR VGND sky130_ef_sc_hd__decap_12
XFILLER_29_125 VGND VGND VPWR VPWR sky130_fd_sc_hd__decap_4
XTAP_TAPCELL_ROW_127_2372 VGND VPWR sky130_fd_sc_hd__tapvpwrvgnd_1
XTAP_TAPCELL_ROW_127_2361 VGND VPWR sky130_fd_sc_hd__tapvpwrvgnd_1
XFILLER_84_242 VGND VGND VPWR VPWR sky130_fd_sc_hd__decap_8
X_07807_ net1385 net375 net230 VGND VGND VPWR VPWR _00568_ sky130_fd_sc_hd__mux2_1
XFILLER_55_15 VGND VGND VPWR VPWR sky130_fd_sc_hd__decap_8
XFILLER_29_169 VGND VGND VPWR VPWR sky130_fd_sc_hd__decap_6
X_08787_ _02534_ _02543_ _02544_ VGND VGND VPWR VPWR _02546_ sky130_fd_sc_hd__and3_1
X_07738_ u_interface.u_gelu_fp32.u_q16_to_fp32.s3_norm_mag\[18\] u_interface.u_gelu_fp32.u_q16_to_fp32.s3_norm_mag\[17\]
+ _01781_ VGND VGND VPWR VPWR _01782_ sky130_fd_sc_hd__and3_1
XTAP_TAPCELL_ROW_140_2583 VGND VPWR sky130_fd_sc_hd__tapvpwrvgnd_1
XTAP_TAPCELL_ROW_140_2572 VGND VPWR sky130_fd_sc_hd__tapvpwrvgnd_1
X_07669_ u_interface.u_gelu_fp32.u_q16_to_fp32.s2_mag\[15\] u_interface.u_gelu_fp32.u_q16_to_fp32.s2_mag\[14\]
+ u_interface.u_gelu_fp32.u_q16_to_fp32.s2_mag\[13\] u_interface.u_gelu_fp32.u_q16_to_fp32.s2_mag\[12\]
+ net337 net335 VGND VGND VPWR VPWR _01750_ sky130_fd_sc_hd__mux4_1
X_09408_ _03134_ _03165_ VGND VGND VPWR VPWR _03166_ sky130_fd_sc_hd__or2_1
XFILLER_111_98 VPWR VGND VPWR VGND sky130_ef_sc_hd__decap_12
XFILLER_111_87 VGND VGND VPWR VPWR sky130_fd_sc_hd__fill_1
X_10680_ _04425_ _04426_ _04306_ _04308_ VGND VGND VPWR VPWR _04427_ sky130_fd_sc_hd__a211oi_1
XFILLER_52_194 VGND VGND VPWR VPWR sky130_fd_sc_hd__fill_2
XFILLER_13_559 VGND VGND VPWR VPWR sky130_fd_sc_hd__fill_1
X_09339_ _03094_ _03097_ _03093_ VGND VGND VPWR VPWR _03098_ sky130_fd_sc_hd__a21oi_1
XFILLER_71_69 VGND VGND VPWR VPWR sky130_fd_sc_hd__fill_1
XFILLER_139_756 VGND VGND VPWR VPWR sky130_fd_sc_hd__decap_6
XPHY_EDGE_ROW_109_Right_109 VGND VGND VPWR VPWR sky130_fd_sc_hd__decap_3
XFILLER_139_778 VGND VGND VPWR VPWR sky130_fd_sc_hd__decap_6
XFILLER_126_406 VGND VGND VPWR VPWR sky130_fd_sc_hd__fill_1
X_12350_ _05815_ _06018_ _06017_ VGND VGND VPWR VPWR _06078_ sky130_fd_sc_hd__a21oi_2
XFILLER_153_225 VGND VGND VPWR VPWR sky130_fd_sc_hd__decap_4
XFILLER_119_480 VPWR VGND VPWR VGND sky130_ef_sc_hd__decap_12
X_11301_ _05030_ _05040_ VGND VGND VPWR VPWR _05042_ sky130_fd_sc_hd__xnor2_1
X_12281_ _06008_ _06009_ VGND VGND VPWR VPWR _06010_ sky130_fd_sc_hd__nor2_1
XFILLER_153_258 VPWR VGND VPWR VGND sky130_ef_sc_hd__decap_12
X_14020_ clknet_leaf_71_clk _00946_ VGND VGND VPWR VPWR u_interface.core_data_out\[6\]
+ sky130_fd_sc_hd__dfxtp_1
X_11232_ _04967_ _04972_ VGND VGND VPWR VPWR _04974_ sky130_fd_sc_hd__xor2_1
XFILLER_122_601 VPWR VGND VPWR VGND sky130_ef_sc_hd__decap_12
XFILLER_107_697 VGND VGND VPWR VPWR sky130_fd_sc_hd__decap_3
X_11163_ _04904_ _04905_ VGND VGND VPWR VPWR _04906_ sky130_fd_sc_hd__nand2_1
X_10114_ _03810_ _03818_ _03819_ VGND VGND VPWR VPWR _03865_ sky130_fd_sc_hd__a21o_1
XFILLER_121_177 VGND VGND VPWR VPWR sky130_fd_sc_hd__fill_2
X_11094_ net658 net668 net430 net425 VGND VGND VPWR VPWR _04837_ sky130_fd_sc_hd__and4_1
X_10045_ _03795_ _03796_ VGND VGND VPWR VPWR _03797_ sky130_fd_sc_hd__nand2_1
Xhold60 u_interface.meta_tlast_pipe\[4\] VGND VGND VPWR VPWR net925 sky130_fd_sc_hd__dlygate4sd3_1
Xhold71 u_interface.u_gelu_fp32.s1_data\[14\] VGND VGND VPWR VPWR net936 sky130_fd_sc_hd__dlygate4sd3_1
Xhold82 u_interface.u_gelu_fp32.s2_data\[6\] VGND VGND VPWR VPWR net947 sky130_fd_sc_hd__dlygate4sd3_1
XFILLER_29_93 VGND VGND VPWR VPWR sky130_fd_sc_hd__decap_6
XFILLER_152_83 VGND VGND VPWR VPWR sky130_fd_sc_hd__fill_1
X_13804_ clknet_leaf_23_clk _00814_ VGND VGND VPWR VPWR u_interface.u_gelu_fp32.u_synth_top.s3_mult\[22\]
+ sky130_fd_sc_hd__dfxtp_1
XFILLER_91_746 VGND VGND VPWR VPWR sky130_fd_sc_hd__decap_3
Xhold93 u_interface.fifo_data\[9\]\[21\] VGND VGND VPWR VPWR net958 sky130_fd_sc_hd__dlygate4sd3_1
XFILLER_17_821 VPWR VGND VPWR VGND sky130_ef_sc_hd__decap_12
XFILLER_35_106 VGND VGND VPWR VPWR sky130_fd_sc_hd__decap_6
XFILLER_16_342 VPWR VGND VPWR VGND sky130_ef_sc_hd__decap_12
XFILLER_17_865 VPWR VGND VPWR VGND sky130_ef_sc_hd__decap_12
X_11996_ net202 _05663_ _05664_ VGND VGND VPWR VPWR _05729_ sky130_fd_sc_hd__o21a_1
X_13735_ clknet_leaf_56_clk _00745_ VGND VGND VPWR VPWR u_interface.u_gelu_fp32.u_q16_to_fp32.s1_mag\[1\]
+ sky130_fd_sc_hd__dfxtp_1
XFILLER_90_289 VGND VGND VPWR VPWR sky130_fd_sc_hd__decap_3
X_10947_ _04561_ _04563_ _04690_ VGND VGND VPWR VPWR _04691_ sky130_fd_sc_hd__a21oi_1
XFILLER_45_81 VPWR VGND VPWR VGND sky130_ef_sc_hd__decap_12
XPHY_EDGE_ROW_11_Left_167 VGND VGND VPWR VPWR sky130_fd_sc_hd__decap_3
XFILLER_31_301 VPWR VGND VPWR VGND sky130_ef_sc_hd__decap_12
XFILLER_32_813 VPWR VGND VPWR VGND sky130_ef_sc_hd__decap_12
X_13666_ clknet_leaf_14_clk _00676_ VGND VGND VPWR VPWR u_interface.u_gelu_fp32.u_fp32_to_q16.s2_shift\[3\]
+ sky130_fd_sc_hd__dfxtp_1
XTAP_TAPCELL_ROW_63_1349 VGND VPWR sky130_fd_sc_hd__tapvpwrvgnd_1
XTAP_TAPCELL_ROW_63_1338 VGND VPWR sky130_fd_sc_hd__tapvpwrvgnd_1
XFILLER_16_397 VGND VGND VPWR VPWR sky130_fd_sc_hd__decap_8
XFILLER_31_334 VGND VGND VPWR VPWR sky130_fd_sc_hd__fill_2
X_12617_ _06316_ _06319_ _06306_ VGND VGND VPWR VPWR _06320_ sky130_fd_sc_hd__a21oi_1
X_10878_ _04619_ _04622_ VGND VGND VPWR VPWR _04623_ sky130_fd_sc_hd__xnor2_1
XTAP_TAPCELL_ROW_14_554 VGND VPWR sky130_fd_sc_hd__tapvpwrvgnd_1
XTAP_TAPCELL_ROW_14_565 VGND VPWR sky130_fd_sc_hd__tapvpwrvgnd_1
XFILLER_129_211 VGND VGND VPWR VPWR sky130_fd_sc_hd__fill_1
X_13597_ clknet_leaf_63_clk _00607_ VGND VGND VPWR VPWR u_interface.fifo_data\[3\]\[12\]
+ sky130_fd_sc_hd__dfxtp_1
XFILLER_12_581 VGND VGND VPWR VPWR sky130_fd_sc_hd__decap_6
XFILLER_61_80 VGND VGND VPWR VPWR sky130_fd_sc_hd__decap_4
X_12548_ _06269_ _06270_ VGND VGND VPWR VPWR _06272_ sky130_fd_sc_hd__and2_1
Xgelu_top_837 VGND VGND VPWR VPWR gelu_top_837/HI s_axil_rdata[5] sky130_fd_sc_hd__conb_1
Xgelu_top_859 VGND VGND VPWR VPWR gelu_top_859/HI s_axil_rdata[27] sky130_fd_sc_hd__conb_1
XFILLER_145_759 VGND VGND VPWR VPWR sky130_fd_sc_hd__fill_1
XFILLER_117_428 VGND VGND VPWR VPWR sky130_fd_sc_hd__decap_4
XANTENNA_2 _01513_ VGND VGND VPWR VPWR sky130_fd_sc_hd__diode_2
Xgelu_top_848 VGND VGND VPWR VPWR gelu_top_848/HI s_axil_rdata[16] sky130_fd_sc_hd__conb_1
X_12479_ _06203_ _06204_ VGND VGND VPWR VPWR _06205_ sky130_fd_sc_hd__and2_1
XTAP_TAPCELL_ROW_78_1581 VGND VPWR sky130_fd_sc_hd__tapvpwrvgnd_1
XFILLER_6_53 VPWR VGND VPWR VGND sky130_ef_sc_hd__decap_12
XPHY_EDGE_ROW_20_Left_176 VGND VGND VPWR VPWR sky130_fd_sc_hd__decap_3
XFILLER_153_770 VGND VGND VPWR VPWR sky130_fd_sc_hd__decap_4
XFILLER_125_483 VPWR VGND VPWR VGND sky130_ef_sc_hd__decap_12
XFILLER_6_97 VPWR VGND VPWR VGND sky130_ef_sc_hd__decap_12
Xfanout509 u_interface.u_gelu_fp32.u_synth_top.s2_dx\[3\] VGND VGND VPWR VPWR net509
+ sky130_fd_sc_hd__clkbuf_4
XFILLER_99_868 VGND VGND VPWR VPWR sky130_fd_sc_hd__fill_1
X_14149_ clknet_leaf_83_clk _01075_ VGND VGND VPWR VPWR u_interface.fifo_data\[1\]\[9\]
+ sky130_fd_sc_hd__dfxtp_1
XFILLER_101_818 VGND VGND VPWR VPWR sky130_fd_sc_hd__decap_6
XFILLER_100_317 VGND VGND VPWR VPWR sky130_fd_sc_hd__decap_6
XTAP_TAPCELL_ROW_91_1792 VGND VPWR sky130_fd_sc_hd__tapvpwrvgnd_1
X_06971_ _01497_ _01498_ VGND VGND VPWR VPWR _00030_ sky130_fd_sc_hd__nor2_1
X_08710_ _02468_ _02454_ VGND VGND VPWR VPWR _02469_ sky130_fd_sc_hd__and2b_1
X_09690_ _03434_ _03444_ VGND VGND VPWR VPWR _03445_ sky130_fd_sc_hd__xnor2_1
XFILLER_100_328 VPWR VGND VPWR VGND sky130_ef_sc_hd__decap_12
XFILLER_94_562 VGND VGND VPWR VPWR sky130_fd_sc_hd__fill_2
XFILLER_66_242 VGND VGND VPWR VPWR sky130_fd_sc_hd__decap_8
X_08641_ net157 _02410_ VGND VGND VPWR VPWR _02411_ sky130_fd_sc_hd__nand2_1
XFILLER_39_445 VGND VGND VPWR VPWR sky130_fd_sc_hd__decap_3
XTAP_TAPCELL_ROW_109_2080 VGND VPWR sky130_fd_sc_hd__tapvpwrvgnd_1
XFILLER_81_201 VGND VGND VPWR VPWR sky130_fd_sc_hd__fill_1
XFILLER_27_629 VPWR VGND VPWR VGND sky130_ef_sc_hd__decap_12
X_08572_ net154 _02362_ net824 VGND VGND VPWR VPWR _00776_ sky130_fd_sc_hd__a21oi_1
XFILLER_54_459 VPWR VGND VPWR VGND sky130_ef_sc_hd__decap_12
X_07523_ _01616_ _01618_ net552 VGND VGND VPWR VPWR _01652_ sky130_fd_sc_hd__mux2_1
XFILLER_81_267 VPWR VGND VPWR VGND sky130_ef_sc_hd__decap_12
XFILLER_34_161 VGND VGND VPWR VPWR sky130_fd_sc_hd__decap_6
XFILLER_35_673 VGND VGND VPWR VPWR sky130_fd_sc_hd__fill_1
X_07454_ u_interface.u_gelu_fp32.u_fp32_to_q16.s2_norm_mag\[11\] u_interface.u_gelu_fp32.u_fp32_to_q16.s2_norm_mag\[12\]
+ net559 VGND VGND VPWR VPWR _01589_ sky130_fd_sc_hd__mux2_1
XTAP_TAPCELL_ROW_122_2291 VGND VPWR sky130_fd_sc_hd__tapvpwrvgnd_1
XTAP_TAPCELL_ROW_122_2280 VGND VPWR sky130_fd_sc_hd__tapvpwrvgnd_1
XTAP_TAPCELL_ROW_33_863 VGND VPWR sky130_fd_sc_hd__tapvpwrvgnd_1
X_07385_ net1158 net349 net240 VGND VGND VPWR VPWR _00415_ sky130_fd_sc_hd__mux2_1
XTAP_TAPCELL_ROW_98_1902 VGND VPWR sky130_fd_sc_hd__tapvpwrvgnd_1
XFILLER_10_529 VGND VGND VPWR VPWR sky130_fd_sc_hd__decap_3
XFILLER_148_586 VGND VGND VPWR VPWR sky130_fd_sc_hd__fill_2
X_09124_ net647 net654 net516 net520 VGND VGND VPWR VPWR _02883_ sky130_fd_sc_hd__and4_1
XFILLER_136_715 VGND VGND VPWR VPWR sky130_fd_sc_hd__fill_2
X_09055_ _02763_ _02764_ _02813_ VGND VGND VPWR VPWR _02814_ sky130_fd_sc_hd__nand3_1
Xhold530 u_interface.fifo_data\[4\]\[26\] VGND VGND VPWR VPWR net1395 sky130_fd_sc_hd__dlygate4sd3_1
X_08006_ net309 _01679_ _01868_ VGND VGND VPWR VPWR _01869_ sky130_fd_sc_hd__o21a_1
XFILLER_151_729 VGND VGND VPWR VPWR sky130_fd_sc_hd__decap_6
XFILLER_116_483 VPWR VGND VPWR VGND sky130_ef_sc_hd__decap_12
Xhold552 u_interface.fifo_data\[4\]\[27\] VGND VGND VPWR VPWR net1417 sky130_fd_sc_hd__dlygate4sd3_1
Xhold541 u_interface.fifo_data\[10\]\[30\] VGND VGND VPWR VPWR net1406 sky130_fd_sc_hd__dlygate4sd3_1
Xhold563 u_interface.fifo_data\[0\]\[12\] VGND VGND VPWR VPWR net1428 sky130_fd_sc_hd__dlygate4sd3_1
XFILLER_1_205 VPWR VGND VPWR VGND sky130_ef_sc_hd__decap_12
Xhold585 u_interface.fifo_data\[11\]\[28\] VGND VGND VPWR VPWR net1450 sky130_fd_sc_hd__dlygate4sd3_1
Xhold596 u_interface.fifo_data\[7\]\[28\] VGND VGND VPWR VPWR net1461 sky130_fd_sc_hd__dlygate4sd3_1
Xhold574 u_interface.fifo_data\[3\]\[21\] VGND VGND VPWR VPWR net1439 sky130_fd_sc_hd__dlygate4sd3_1
XFILLER_1_249 VPWR VGND VPWR VGND sky130_ef_sc_hd__decap_12
XFILLER_131_475 VGND VGND VPWR VPWR sky130_fd_sc_hd__decap_8
XTAP_TAPCELL_ROW_129_2401 VGND VPWR sky130_fd_sc_hd__tapvpwrvgnd_1
X_09957_ _03708_ _03709_ _03705_ VGND VGND VPWR VPWR _03710_ sky130_fd_sc_hd__a21o_1
X_08908_ _02665_ _02666_ VGND VGND VPWR VPWR _02667_ sky130_fd_sc_hd__and2b_1
XFILLER_103_177 VGND VGND VPWR VPWR sky130_fd_sc_hd__fill_1
XTAP_TAPCELL_ROW_142_2612 VGND VPWR sky130_fd_sc_hd__tapvpwrvgnd_1
XTAP_TAPCELL_ROW_142_2601 VGND VPWR sky130_fd_sc_hd__tapvpwrvgnd_1
X_09888_ _03637_ _03638_ _03639_ VGND VGND VPWR VPWR _03641_ sky130_fd_sc_hd__nand3_1
XFILLER_66_58 VGND VGND VPWR VPWR sky130_fd_sc_hd__decap_3
XFILLER_58_776 VGND VGND VPWR VPWR sky130_fd_sc_hd__decap_4
X_08839_ _02578_ _02579_ _02596_ VGND VGND VPWR VPWR _02598_ sky130_fd_sc_hd__or3_1
X_11850_ _05578_ _05583_ VGND VGND VPWR VPWR _05585_ sky130_fd_sc_hd__and2_1
XFILLER_72_256 VPWR VGND VPWR VGND sky130_ef_sc_hd__decap_12
X_10801_ _04545_ _04546_ _04339_ _04341_ VGND VGND VPWR VPWR _04547_ sky130_fd_sc_hd__o211ai_2
XFILLER_14_813 VPWR VGND VPWR VGND sky130_ef_sc_hd__decap_12
X_11781_ _05513_ _05514_ _05515_ VGND VGND VPWR VPWR _05517_ sky130_fd_sc_hd__a21bo_1
X_10732_ _04469_ _04475_ _04476_ VGND VGND VPWR VPWR _04478_ sky130_fd_sc_hd__nand3_1
X_13520_ clknet_leaf_76_clk _00530_ VGND VGND VPWR VPWR u_interface.core_data_out\[31\]
+ sky130_fd_sc_hd__dfxtp_1
XTAP_TAPCELL_ROW_45_1057 VGND VPWR sky130_fd_sc_hd__tapvpwrvgnd_1
XFILLER_15_51 VGND VGND VPWR VPWR sky130_fd_sc_hd__decap_4
XFILLER_40_153 VPWR VGND VPWR VGND sky130_ef_sc_hd__decap_12
X_13451_ clknet_leaf_9_clk _00461_ VGND VGND VPWR VPWR u_interface.u_gelu_fp32.u_fp32_to_q16.s3_mag\[22\]
+ sky130_fd_sc_hd__dfxtp_1
X_10663_ _04407_ _04408_ _04290_ VGND VGND VPWR VPWR _04410_ sky130_fd_sc_hd__or3b_2
XTAP_TAPCELL_ROW_11_513 VGND VPWR sky130_fd_sc_hd__tapvpwrvgnd_1
X_13382_ clknet_leaf_66_clk _00392_ VGND VGND VPWR VPWR u_interface.fifo_data\[7\]\[27\]
+ sky130_fd_sc_hd__dfxtp_1
X_10594_ _04319_ _04338_ _04339_ VGND VGND VPWR VPWR _04341_ sky130_fd_sc_hd__nand3_2
X_12402_ net182 _06128_ VGND VGND VPWR VPWR _06129_ sky130_fd_sc_hd__xnor2_1
XFILLER_40_197 VPWR VGND VPWR VGND sky130_ef_sc_hd__decap_12
X_12333_ _05930_ _05995_ _05996_ VGND VGND VPWR VPWR _06062_ sky130_fd_sc_hd__o21ba_1
XTAP_TAPCELL_ROW_153_2785 VGND VPWR sky130_fd_sc_hd__tapvpwrvgnd_1
XFILLER_154_589 VGND VGND VPWR VPWR sky130_fd_sc_hd__decap_4
X_14003_ clknet_leaf_60_clk _00929_ VGND VGND VPWR VPWR u_interface.u_gelu_fp32.u_q16_to_fp32.s3_norm_mag\[30\]
+ sky130_fd_sc_hd__dfxtp_1
X_12264_ _05992_ _05993_ VGND VGND VPWR VPWR _05994_ sky130_fd_sc_hd__nand2_1
X_11215_ net677 net434 _04838_ _04837_ VGND VGND VPWR VPWR _04957_ sky130_fd_sc_hd__a31o_1
X_12195_ net191 _05925_ VGND VGND VPWR VPWR _05926_ sky130_fd_sc_hd__or2_1
XFILLER_122_475 VGND VGND VPWR VPWR sky130_fd_sc_hd__fill_1
X_11146_ _04830_ _04888_ VGND VGND VPWR VPWR _04889_ sky130_fd_sc_hd__xnor2_1
XFILLER_95_337 VGND VGND VPWR VPWR sky130_fd_sc_hd__fill_2
X_11077_ _04818_ _04819_ VGND VGND VPWR VPWR _04820_ sky130_fd_sc_hd__nand2_1
XFILLER_1_783 VGND VGND VPWR VPWR sky130_fd_sc_hd__fill_1
X_10028_ _03758_ _03777_ _03778_ VGND VGND VPWR VPWR _03780_ sky130_fd_sc_hd__or3_1
XFILLER_0_293 VPWR VGND VPWR VGND sky130_ef_sc_hd__decap_12
XFILLER_91_521 VGND VGND VPWR VPWR sky130_fd_sc_hd__decap_8
XFILLER_48_264 VGND VGND VPWR VPWR sky130_fd_sc_hd__decap_4
XFILLER_91_543 VGND VGND VPWR VPWR sky130_fd_sc_hd__fill_2
XFILLER_64_779 VGND VGND VPWR VPWR sky130_fd_sc_hd__decap_8
XFILLER_63_245 VGND VGND VPWR VPWR sky130_fd_sc_hd__decap_4
XTAP_TAPCELL_ROW_19_635 VGND VPWR sky130_fd_sc_hd__tapvpwrvgnd_1
XTAP_TAPCELL_ROW_19_646 VGND VPWR sky130_fd_sc_hd__tapvpwrvgnd_1
XFILLER_63_289 VGND VGND VPWR VPWR sky130_fd_sc_hd__decap_4
XFILLER_63_278 VGND VGND VPWR VPWR sky130_fd_sc_hd__fill_2
XFILLER_17_673 VPWR VGND VPWR VGND sky130_ef_sc_hd__decap_12
X_13718_ clknet_leaf_7_clk _00728_ VGND VGND VPWR VPWR u_interface.u_gelu_fp32.s1_data\[18\]
+ sky130_fd_sc_hd__dfxtp_1
X_11979_ _05710_ _05711_ VGND VGND VPWR VPWR _05713_ sky130_fd_sc_hd__xor2_1
XFILLER_20_805 VGND VGND VPWR VPWR sky130_fd_sc_hd__decap_6
XFILLER_32_643 VGND VGND VPWR VPWR sky130_fd_sc_hd__fill_1
X_13649_ clknet_leaf_28_clk _00659_ VGND VGND VPWR VPWR u_interface.u_gelu_fp32.u_synth_top.v_pipe\[0\]
+ sky130_fd_sc_hd__dfxtp_1
XFILLER_82_3 VPWR VGND VPWR VGND sky130_ef_sc_hd__decap_12
XFILLER_20_849 VPWR VGND VPWR VGND sky130_ef_sc_hd__decap_12
XTAP_TAPCELL_ROW_30_811 VGND VPWR sky130_fd_sc_hd__tapvpwrvgnd_1
XTAP_TAPCELL_ROW_30_822 VGND VPWR sky130_fd_sc_hd__tapvpwrvgnd_1
X_07170_ net1147 net365 net263 VGND VGND VPWR VPWR _00210_ sky130_fd_sc_hd__mux2_1
XFILLER_145_534 VPWR VGND VPWR VGND sky130_ef_sc_hd__decap_12
XFILLER_145_523 VGND VGND VPWR VPWR sky130_fd_sc_hd__decap_6
XFILLER_145_567 VGND VGND VPWR VPWR sky130_fd_sc_hd__decap_8
XTAP_TAPCELL_ROW_93_1821 VGND VPWR sky130_fd_sc_hd__tapvpwrvgnd_1
XFILLER_101_615 VGND VGND VPWR VPWR sky130_fd_sc_hd__fill_1
X_09811_ _03501_ _03503_ _03562_ _03563_ VGND VGND VPWR VPWR _03565_ sky130_fd_sc_hd__a211oi_1
Xfanout317 _01108_ VGND VGND VPWR VPWR net317 sky130_fd_sc_hd__clkbuf_4
Xfanout306 _01115_ VGND VGND VPWR VPWR net306 sky130_fd_sc_hd__buf_2
Xfanout339 u_interface.u_gelu_fp32.u_q16_to_fp32.s2_clz\[0\] VGND VGND VPWR VPWR net339
+ sky130_fd_sc_hd__dlymetal6s2s_1
Xfanout328 u_interface.u_gelu_fp32.u_q16_to_fp32.s2_clz\[2\] VGND VGND VPWR VPWR net328
+ sky130_fd_sc_hd__buf_2
XFILLER_59_529 VGND VGND VPWR VPWR sky130_fd_sc_hd__decap_3
XFILLER_140_283 VGND VGND VPWR VPWR sky130_fd_sc_hd__fill_2
X_09742_ _03389_ _03391_ _03494_ _03495_ VGND VGND VPWR VPWR _03497_ sky130_fd_sc_hd__a211oi_1
XFILLER_98_197 VGND VGND VPWR VPWR sky130_fd_sc_hd__decap_4
XFILLER_95_871 VGND VGND VPWR VPWR sky130_fd_sc_hd__fill_2
X_06954_ u_interface.u_gelu_fp32.u_synth_top.s1_x\[27\] net275 _01481_ VGND VGND VPWR
+ VPWR _01484_ sky130_fd_sc_hd__o21a_1
XFILLER_67_551 VGND VGND VPWR VPWR sky130_fd_sc_hd__decap_8
XFILLER_28_905 VPWR VGND VPWR VGND sky130_ef_sc_hd__decap_12
XTAP_TAPCELL_ROW_124_2320 VGND VPWR sky130_fd_sc_hd__tapvpwrvgnd_1
X_09673_ _03422_ _03427_ VGND VGND VPWR VPWR _03428_ sky130_fd_sc_hd__nand2b_1
X_06885_ u_interface.u_gelu_fp32.u_synth_top.s1_hits\[12\] u_interface.u_gelu_fp32.u_synth_top.s1_hits\[8\]
+ VGND VGND VPWR VPWR _01428_ sky130_fd_sc_hd__or2_2
XFILLER_94_381 VGND VGND VPWR VPWR sky130_fd_sc_hd__fill_1
X_08624_ _02173_ _02174_ _02241_ VGND VGND VPWR VPWR _02398_ sky130_fd_sc_hd__nand3_1
XFILLER_27_437 VGND VGND VPWR VPWR sky130_fd_sc_hd__decap_4
XTAP_TAPCELL_ROW_38_944 VGND VPWR sky130_fd_sc_hd__tapvpwrvgnd_1
XFILLER_82_587 VGND VGND VPWR VPWR sky130_fd_sc_hd__fill_1
XFILLER_14_109 VPWR VGND VPWR VGND sky130_ef_sc_hd__decap_12
X_08555_ _02341_ _02343_ _02344_ _02345_ VGND VGND VPWR VPWR _02346_ sky130_fd_sc_hd__or4_1
X_07506_ _01575_ _01580_ net553 VGND VGND VPWR VPWR _01637_ sky130_fd_sc_hd__mux2_1
XFILLER_70_749 VGND VGND VPWR VPWR sky130_fd_sc_hd__decap_6
XFILLER_52_27 VGND VGND VPWR VPWR sky130_fd_sc_hd__fill_1
XFILLER_23_665 VGND VGND VPWR VPWR sky130_fd_sc_hd__decap_6
X_08486_ net522 u_interface.u_gelu_fp32.u_synth_top.s3_mult\[44\] VGND VGND VPWR VPWR
+ _02277_ sky130_fd_sc_hd__nand2_1
X_07437_ _01570_ _01571_ net555 VGND VGND VPWR VPWR _01572_ sky130_fd_sc_hd__mux2_1
XTAP_TAPCELL_ROW_102_1972 VGND VPWR sky130_fd_sc_hd__tapvpwrvgnd_1
XTAP_TAPCELL_ROW_102_1961 VGND VPWR sky130_fd_sc_hd__tapvpwrvgnd_1
XFILLER_22_153 VGND VGND VPWR VPWR sky130_fd_sc_hd__decap_3
XFILLER_155_309 VGND VGND VPWR VPWR sky130_fd_sc_hd__fill_2
X_07368_ net1276 net382 net240 VGND VGND VPWR VPWR _00398_ sky130_fd_sc_hd__mux2_1
XFILLER_7_809 VPWR VGND VPWR VGND sky130_ef_sc_hd__decap_12
XFILLER_22_197 VGND VGND VPWR VPWR sky130_fd_sc_hd__decap_8
X_09107_ _02863_ _02864_ _02865_ VGND VGND VPWR VPWR _02866_ sky130_fd_sc_hd__and3_1
X_07299_ net1036 net568 net248 VGND VGND VPWR VPWR _00329_ sky130_fd_sc_hd__mux2_1
XTAP_TAPCELL_ROW_135_2493 VGND VPWR sky130_fd_sc_hd__tapvpwrvgnd_1
X_09038_ _02796_ _02784_ VGND VGND VPWR VPWR _02797_ sky130_fd_sc_hd__and2b_1
Xhold360 u_interface.fifo_data\[13\]\[14\] VGND VGND VPWR VPWR net1225 sky130_fd_sc_hd__dlygate4sd3_1
Xhold371 u_interface.fifo_data\[1\]\[30\] VGND VGND VPWR VPWR net1236 sky130_fd_sc_hd__dlygate4sd3_1
XFILLER_2_525 VGND VGND VPWR VPWR sky130_fd_sc_hd__decap_6
Xhold382 u_interface.fifo_data\[5\]\[4\] VGND VGND VPWR VPWR net1247 sky130_fd_sc_hd__dlygate4sd3_1
Xhold393 u_interface.fifo_data\[15\]\[9\] VGND VGND VPWR VPWR net1258 sky130_fd_sc_hd__dlygate4sd3_1
X_11000_ net628 net634 net418 net413 VGND VGND VPWR VPWR _04744_ sky130_fd_sc_hd__and4_1
XFILLER_2_569 VPWR VGND VPWR VGND sky130_ef_sc_hd__decap_12
XFILLER_104_475 VGND VGND VPWR VPWR sky130_fd_sc_hd__fill_1
XFILLER_77_57 VPWR VGND VPWR VGND sky130_ef_sc_hd__decap_12
X_12951_ u_interface.fifo_count\[1\] _06467_ VGND VGND VPWR VPWR _06472_ sky130_fd_sc_hd__nand2_1
XFILLER_58_584 VGND VGND VPWR VPWR sky130_fd_sc_hd__decap_4
X_12882_ net787 net919 VGND VGND VPWR VPWR _01024_ sky130_fd_sc_hd__and2_1
X_11902_ net194 _05635_ VGND VGND VPWR VPWR _05637_ sky130_fd_sc_hd__nand2_1
X_11833_ _05495_ _05498_ net179 VGND VGND VPWR VPWR _05568_ sky130_fd_sc_hd__o21a_1
XFILLER_60_215 VPWR VGND VPWR VGND sky130_ef_sc_hd__decap_12
XFILLER_26_83 VGND VGND VPWR VPWR sky130_fd_sc_hd__fill_1
XFILLER_14_643 VGND VGND VPWR VPWR sky130_fd_sc_hd__fill_1
X_11764_ net214 _05422_ _05421_ VGND VGND VPWR VPWR _05500_ sky130_fd_sc_hd__a21o_1
XTAP_TAPCELL_ROW_155_2825 VGND VPWR sky130_fd_sc_hd__tapvpwrvgnd_1
XTAP_TAPCELL_ROW_155_2814 VGND VPWR sky130_fd_sc_hd__tapvpwrvgnd_1
X_13503_ clknet_leaf_4_clk _00513_ VGND VGND VPWR VPWR u_interface.u_gelu_fp32.u_synth_top.s2_m\[8\]
+ sky130_fd_sc_hd__dfxtp_2
X_10715_ _04344_ _04346_ VGND VGND VPWR VPWR _04461_ sky130_fd_sc_hd__nand2_1
XFILLER_9_113 VPWR VGND VPWR VGND sky130_ef_sc_hd__decap_12
X_11695_ net702 net420 _05430_ _05431_ VGND VGND VPWR VPWR _05432_ sky130_fd_sc_hd__a22o_1
XTAP_TAPCELL_ROW_155_2836 VGND VPWR sky130_fd_sc_hd__tapvpwrvgnd_1
XFILLER_146_309 VGND VGND VPWR VPWR sky130_fd_sc_hd__fill_2
X_13434_ clknet_leaf_18_clk _00444_ VGND VGND VPWR VPWR u_interface.u_gelu_fp32.u_fp32_to_q16.s3_mag\[5\]
+ sky130_fd_sc_hd__dfxtp_1
X_10646_ net594 net408 VGND VGND VPWR VPWR _04393_ sky130_fd_sc_hd__nand2_1
XFILLER_41_495 VGND VGND VPWR VPWR sky130_fd_sc_hd__fill_1
XFILLER_155_832 VGND VGND VPWR VPWR sky130_fd_sc_hd__decap_4
XFILLER_139_361 VGND VGND VPWR VPWR sky130_fd_sc_hd__decap_6
XFILLER_127_501 VGND VGND VPWR VPWR sky130_fd_sc_hd__decap_3
X_13365_ clknet_leaf_38_clk _00375_ VGND VGND VPWR VPWR u_interface.fifo_data\[7\]\[10\]
+ sky130_fd_sc_hd__dfxtp_1
X_10577_ net277 _03869_ _04323_ VGND VGND VPWR VPWR _04324_ sky130_fd_sc_hd__a21o_1
XFILLER_10_893 VPWR VGND VPWR VGND sky130_ef_sc_hd__decap_12
XTAP_TAPCELL_ROW_58_1259 VGND VPWR sky130_fd_sc_hd__tapvpwrvgnd_1
X_13296_ clknet_leaf_70_clk _00306_ VGND VGND VPWR VPWR u_interface.fifo_data\[8\]\[5\]
+ sky130_fd_sc_hd__dfxtp_1
X_12316_ _06042_ _06043_ VGND VGND VPWR VPWR _06045_ sky130_fd_sc_hd__xnor2_1
XFILLER_142_537 VGND VGND VPWR VPWR sky130_fd_sc_hd__fill_1
XFILLER_123_740 VGND VGND VPWR VPWR sky130_fd_sc_hd__fill_1
XTAP_TAPCELL_ROW_75_1540 VGND VPWR sky130_fd_sc_hd__tapvpwrvgnd_1
X_12247_ _05882_ _05909_ _05908_ VGND VGND VPWR VPWR _05977_ sky130_fd_sc_hd__a21bo_1
XFILLER_122_250 VGND VGND VPWR VPWR sky130_fd_sc_hd__fill_2
XFILLER_110_401 VGND VGND VPWR VPWR sky130_fd_sc_hd__decap_4
X_12178_ _05906_ _05907_ VGND VGND VPWR VPWR _05909_ sky130_fd_sc_hd__xnor2_1
XFILLER_68_359 VGND VGND VPWR VPWR sky130_fd_sc_hd__fill_1
X_11129_ net595 net392 _04870_ VGND VGND VPWR VPWR _04872_ sky130_fd_sc_hd__and3_1
XFILLER_92_830 VGND VGND VPWR VPWR sky130_fd_sc_hd__decap_3
X_06670_ u_interface.fifo_data\[12\]\[5\] u_interface.fifo_data\[13\]\[5\] u_interface.fifo_data\[14\]\[5\]
+ u_interface.fifo_data\[15\]\[5\] net756 net739 VGND VGND VPWR VPWR _01240_ sky130_fd_sc_hd__mux4_1
XFILLER_64_554 VGND VGND VPWR VPWR sky130_fd_sc_hd__decap_3
XTAP_TAPCELL_ROW_35_903 VGND VPWR sky130_fd_sc_hd__tapvpwrvgnd_1
XFILLER_36_289 VPWR VGND VPWR VGND sky130_ef_sc_hd__decap_12
X_08340_ net531 _02137_ net1672 VGND VGND VPWR VPWR _02138_ sky130_fd_sc_hd__a21oi_1
X_08271_ u_interface.u_gelu_fp32.s2_data\[7\] _02083_ VGND VGND VPWR VPWR _02086_
+ sky130_fd_sc_hd__or2_1
XFILLER_20_613 VPWR VGND VPWR VGND sky130_ef_sc_hd__decap_12
X_07222_ net563 net1495 net257 VGND VGND VPWR VPWR _00262_ sky130_fd_sc_hd__mux2_1
XFILLER_20_657 VPWR VGND VPWR VGND sky130_ef_sc_hd__decap_12
XFILLER_146_810 VGND VGND VPWR VPWR sky130_fd_sc_hd__fill_2
X_07153_ net1155 net573 net218 VGND VGND VPWR VPWR _00193_ sky130_fd_sc_hd__mux2_1
XFILLER_145_375 VPWR VGND VPWR VGND sky130_ef_sc_hd__decap_12
XFILLER_118_589 VPWR VGND VPWR VGND sky130_ef_sc_hd__decap_12
X_07084_ net1314 net379 net225 VGND VGND VPWR VPWR _00124_ sky130_fd_sc_hd__mux2_1
XFILLER_154_18 VGND VGND VPWR VPWR sky130_fd_sc_hd__decap_8
XFILLER_154_29 VPWR VGND VPWR VGND sky130_ef_sc_hd__decap_12
XFILLER_141_592 VGND VGND VPWR VPWR sky130_fd_sc_hd__fill_1
XFILLER_87_646 VGND VGND VPWR VPWR sky130_fd_sc_hd__fill_1
XFILLER_86_101 VGND VGND VPWR VPWR sky130_fd_sc_hd__decap_6
Xfanout169 _01896_ VGND VGND VPWR VPWR net169 sky130_fd_sc_hd__clkbuf_2
X_07986_ net542 _01690_ net279 _01659_ net812 VGND VGND VPWR VPWR _01855_ sky130_fd_sc_hd__a221o_1
Xfanout158 net159 VGND VGND VPWR VPWR net158 sky130_fd_sc_hd__buf_2
XFILLER_47_27 VPWR VGND VPWR VGND sky130_ef_sc_hd__decap_12
X_09725_ _03470_ _03478_ VGND VGND VPWR VPWR _03480_ sky130_fd_sc_hd__xnor2_1
X_06937_ _01468_ _01469_ _01470_ VGND VGND VPWR VPWR _01471_ sky130_fd_sc_hd__and3_1
XFILLER_28_713 VPWR VGND VPWR VGND sky130_ef_sc_hd__decap_12
X_09656_ _03310_ _03313_ _03409_ _03410_ VGND VGND VPWR VPWR _03412_ sky130_fd_sc_hd__a211oi_2
XFILLER_28_757 VPWR VGND VPWR VGND sky130_ef_sc_hd__decap_12
X_06868_ _01409_ _01410_ _01413_ net318 VGND VGND VPWR VPWR net130 sky130_fd_sc_hd__a22o_1
X_08607_ net154 _02386_ net801 VGND VGND VPWR VPWR _00787_ sky130_fd_sc_hd__a21oi_1
XFILLER_63_15 VPWR VGND VPWR VGND sky130_ef_sc_hd__decap_12
XFILLER_43_705 VGND VGND VPWR VPWR sky130_fd_sc_hd__decap_4
XTAP_TAPCELL_ROW_2_366 VGND VPWR sky130_fd_sc_hd__tapvpwrvgnd_1
XFILLER_27_267 VGND VGND VPWR VPWR sky130_fd_sc_hd__fill_1
X_09587_ _03340_ _03342_ VGND VGND VPWR VPWR _03343_ sky130_fd_sc_hd__nor2_1
XFILLER_55_587 VGND VGND VPWR VPWR sky130_fd_sc_hd__fill_1
X_06799_ u_interface.fifo_data\[12\]\[21\] u_interface.fifo_data\[13\]\[21\] u_interface.fifo_data\[14\]\[21\]
+ u_interface.fifo_data\[15\]\[21\] net755 net738 VGND VGND VPWR VPWR _01353_ sky130_fd_sc_hd__mux4_1
XFILLER_151_6 VPWR VGND VPWR VGND sky130_ef_sc_hd__decap_12
XFILLER_70_568 VGND VGND VPWR VPWR sky130_fd_sc_hd__fill_2
X_08538_ _02157_ _02315_ VGND VGND VPWR VPWR _02329_ sky130_fd_sc_hd__xor2_1
X_08469_ net526 u_interface.u_gelu_fp32.u_synth_top.s3_mult\[38\] VGND VGND VPWR VPWR
+ _02260_ sky130_fd_sc_hd__or2_1
XFILLER_23_462 VGND VGND VPWR VPWR sky130_fd_sc_hd__fill_1
XTAP_TAPCELL_ROW_42_1005 VGND VPWR sky130_fd_sc_hd__tapvpwrvgnd_1
XTAP_TAPCELL_ROW_137_2533 VGND VPWR sky130_fd_sc_hd__tapvpwrvgnd_1
XTAP_TAPCELL_ROW_137_2522 VGND VPWR sky130_fd_sc_hd__tapvpwrvgnd_1
XFILLER_128_309 VPWR VGND VPWR VGND sky130_ef_sc_hd__decap_12
X_10500_ _04239_ _04245_ _04246_ VGND VGND VPWR VPWR _04248_ sky130_fd_sc_hd__nand3_1
XFILLER_149_681 VGND VGND VPWR VPWR sky130_fd_sc_hd__decap_4
XFILLER_149_670 VGND VGND VPWR VPWR sky130_fd_sc_hd__fill_2
X_11480_ _05217_ _05218_ VGND VGND VPWR VPWR _05219_ sky130_fd_sc_hd__nor2_1
XFILLER_7_617 VPWR VGND VPWR VGND sky130_ef_sc_hd__decap_12
XFILLER_155_139 VGND VGND VPWR VPWR sky130_fd_sc_hd__fill_1
XFILLER_137_865 VGND VGND VPWR VPWR sky130_fd_sc_hd__decap_6
X_10431_ _04062_ _04064_ _04177_ _04178_ VGND VGND VPWR VPWR _04180_ sky130_fd_sc_hd__o211a_1
XFILLER_12_41 VPWR VGND VPWR VGND sky130_ef_sc_hd__decap_12
XTAP_TAPCELL_ROW_21_674 VGND VPWR sky130_fd_sc_hd__tapvpwrvgnd_1
XTAP_TAPCELL_ROW_150_2733 VGND VPWR sky130_fd_sc_hd__tapvpwrvgnd_1
X_13150_ clknet_leaf_35_clk _00160_ VGND VGND VPWR VPWR u_interface.fifo_tlast\[7\]
+ sky130_fd_sc_hd__dfxtp_1
XFILLER_124_515 VGND VGND VPWR VPWR sky130_fd_sc_hd__fill_1
X_10362_ _03999_ _04110_ VGND VGND VPWR VPWR _04111_ sky130_fd_sc_hd__xnor2_1
XFILLER_12_85 VPWR VGND VPWR VGND sky130_ef_sc_hd__decap_12
XFILLER_152_857 VGND VGND VPWR VPWR sky130_fd_sc_hd__fill_1
XFILLER_152_846 VGND VGND VPWR VPWR sky130_fd_sc_hd__fill_2
XFILLER_136_397 VGND VGND VPWR VPWR sky130_fd_sc_hd__fill_1
XFILLER_128_85 VGND VGND VPWR VPWR sky130_fd_sc_hd__decap_3
X_10293_ net645 net449 VGND VGND VPWR VPWR _04043_ sky130_fd_sc_hd__nand2_1
X_12101_ _05828_ _05832_ VGND VGND VPWR VPWR _05833_ sky130_fd_sc_hd__xnor2_1
X_13081_ clknet_leaf_74_clk _00091_ VGND VGND VPWR VPWR u_interface.fifo_data\[15\]\[2\]
+ sky130_fd_sc_hd__dfxtp_1
XFILLER_88_67 VGND VGND VPWR VPWR sky130_fd_sc_hd__fill_2
XFILLER_3_889 VGND VGND VPWR VPWR sky130_fd_sc_hd__decap_6
XFILLER_2_333 VPWR VGND VPWR VGND sky130_ef_sc_hd__decap_12
X_12032_ _05755_ _05764_ VGND VGND VPWR VPWR _05765_ sky130_fd_sc_hd__xnor2_1
Xhold190 u_interface.fifo_data\[5\]\[19\] VGND VGND VPWR VPWR net1055 sky130_fd_sc_hd__dlygate4sd3_1
XFILLER_104_250 VGND VGND VPWR VPWR sky130_fd_sc_hd__fill_2
XFILLER_2_377 VPWR VGND VPWR VGND sky130_ef_sc_hd__decap_12
XTAP_TAPCELL_ROW_53_1189 VGND VPWR sky130_fd_sc_hd__tapvpwrvgnd_1
XTAP_TAPCELL_ROW_53_1178 VGND VPWR sky130_fd_sc_hd__tapvpwrvgnd_1
Xfanout670 net671 VGND VGND VPWR VPWR net670 sky130_fd_sc_hd__buf_2
Xfanout681 net682 VGND VGND VPWR VPWR net681 sky130_fd_sc_hd__clkbuf_2
XFILLER_92_115 VGND VGND VPWR VPWR sky130_fd_sc_hd__decap_4
XFILLER_77_167 VGND VGND VPWR VPWR sky130_fd_sc_hd__fill_1
X_13983_ clknet_leaf_83_clk net1636 VGND VGND VPWR VPWR u_interface.u_gelu_fp32.u_q16_to_fp32.s2_mag\[28\]
+ sky130_fd_sc_hd__dfxtp_1
Xfanout692 net693 VGND VGND VPWR VPWR net692 sky130_fd_sc_hd__buf_2
X_12934_ u_interface.in_flight_count\[3\] _06438_ _06455_ VGND VGND VPWR VPWR _06458_
+ sky130_fd_sc_hd__a21o_1
XFILLER_58_392 VGND VGND VPWR VPWR sky130_fd_sc_hd__fill_2
XPHY_EDGE_ROW_16_Right_16 VGND VGND VPWR VPWR sky130_fd_sc_hd__decap_3
X_12865_ net1489 u_interface.u_gelu_fp32.u_fp32_to_q16.s2_norm_mag\[20\] net817 VGND
+ VGND VPWR VPWR _01009_ sky130_fd_sc_hd__mux2_1
XFILLER_73_384 VGND VGND VPWR VPWR sky130_fd_sc_hd__fill_1
XFILLER_18_289 VPWR VGND VPWR VGND sky130_ef_sc_hd__decap_12
XTAP_TAPCELL_ROW_29_796 VGND VPWR sky130_fd_sc_hd__tapvpwrvgnd_1
XFILLER_33_204 VPWR VGND VPWR VGND sky130_ef_sc_hd__decap_12
XFILLER_34_749 VGND VGND VPWR VPWR sky130_fd_sc_hd__decap_6
X_12796_ net1738 _01787_ _06414_ VGND VGND VPWR VPWR _00958_ sky130_fd_sc_hd__a21oi_1
XFILLER_61_579 VGND VGND VPWR VPWR sky130_fd_sc_hd__decap_3
XFILLER_33_237 VGND VGND VPWR VPWR sky130_fd_sc_hd__decap_4
X_11816_ _05492_ _05551_ VGND VGND VPWR VPWR _05552_ sky130_fd_sc_hd__xnor2_1
X_11747_ _05312_ _05483_ VGND VGND VPWR VPWR _05484_ sky130_fd_sc_hd__nand2_1
XFILLER_14_484 VGND VGND VPWR VPWR sky130_fd_sc_hd__decap_6
XFILLER_41_270 VGND VGND VPWR VPWR sky130_fd_sc_hd__decap_8
X_11678_ _05332_ _05333_ _05331_ VGND VGND VPWR VPWR _05415_ sky130_fd_sc_hd__o21bai_1
XTAP_TAPCELL_ROW_40_972 VGND VPWR sky130_fd_sc_hd__tapvpwrvgnd_1
XFILLER_139_180 VGND VGND VPWR VPWR sky130_fd_sc_hd__decap_6
X_13417_ clknet_leaf_68_clk _00427_ VGND VGND VPWR VPWR u_interface.fifo_data\[6\]\[30\]
+ sky130_fd_sc_hd__dfxtp_1
X_10629_ net660 net445 net440 net652 VGND VGND VPWR VPWR _04376_ sky130_fd_sc_hd__a22o_1
XPHY_EDGE_ROW_25_Right_25 VGND VGND VPWR VPWR sky130_fd_sc_hd__decap_3
XTAP_TAPCELL_ROW_40_983 VGND VPWR sky130_fd_sc_hd__tapvpwrvgnd_1
XFILLER_155_673 VGND VGND VPWR VPWR sky130_fd_sc_hd__fill_2
XFILLER_143_802 VPWR VGND VPWR VGND sky130_ef_sc_hd__decap_12
XFILLER_127_353 VPWR VGND VPWR VGND sky130_ef_sc_hd__decap_12
X_13348_ clknet_leaf_47_clk _00358_ VGND VGND VPWR VPWR u_interface.fifo_data\[10\]\[25\]
+ sky130_fd_sc_hd__dfxtp_1
XFILLER_154_194 VGND VGND VPWR VPWR sky130_fd_sc_hd__fill_2
X_13279_ clknet_leaf_76_clk _00289_ VGND VGND VPWR VPWR u_interface.fifo_data\[0\]\[21\]
+ sky130_fd_sc_hd__dfxtp_1
XFILLER_45_3 VPWR VGND VPWR VGND sky130_ef_sc_hd__decap_12
XFILLER_5_193 VPWR VGND VPWR VGND sky130_ef_sc_hd__decap_12
XFILLER_142_389 VGND VGND VPWR VPWR sky130_fd_sc_hd__decap_8
XFILLER_111_710 VPWR VGND VPWR VGND sky130_ef_sc_hd__decap_12
XFILLER_96_421 VGND VGND VPWR VPWR sky130_fd_sc_hd__decap_4
X_07840_ net373 net1587 net282 VGND VGND VPWR VPWR _00601_ sky130_fd_sc_hd__mux2_1
X_07771_ net1249 net382 net236 VGND VGND VPWR VPWR _00532_ sky130_fd_sc_hd__mux2_1
XFILLER_56_307 VGND VGND VPWR VPWR sky130_fd_sc_hd__fill_1
X_09510_ _03265_ _03266_ _03227_ VGND VGND VPWR VPWR _03267_ sky130_fd_sc_hd__a21o_1
X_06722_ u_interface.fifo_data\[4\]\[11\] u_interface.fifo_data\[5\]\[11\] u_interface.fifo_data\[6\]\[11\]
+ u_interface.fifo_data\[7\]\[11\] net763 net746 VGND VGND VPWR VPWR _01286_ sky130_fd_sc_hd__mux4_1
XTAP_TAPCELL_ROW_88_1742 VGND VPWR sky130_fd_sc_hd__tapvpwrvgnd_1
XFILLER_65_841 VGND VGND VPWR VPWR sky130_fd_sc_hd__fill_1
XPHY_EDGE_ROW_3_Left_159 VGND VGND VPWR VPWR sky130_fd_sc_hd__decap_3
XPHY_EDGE_ROW_34_Right_34 VGND VGND VPWR VPWR sky130_fd_sc_hd__decap_3
XFILLER_92_660 VGND VGND VPWR VPWR sky130_fd_sc_hd__decap_3
X_09441_ _03187_ _03196_ _03197_ VGND VGND VPWR VPWR _03199_ sky130_fd_sc_hd__and3_1
X_06653_ u_interface.fifo_data\[8\]\[3\] u_interface.fifo_data\[9\]\[3\] u_interface.fifo_data\[10\]\[3\]
+ u_interface.fifo_data\[11\]\[3\] net757 net740 VGND VGND VPWR VPWR _01225_ sky130_fd_sc_hd__mux4_1
XFILLER_24_215 VPWR VGND VPWR VGND sky130_ef_sc_hd__decap_12
XFILLER_25_727 VGND VGND VPWR VPWR sky130_fd_sc_hd__fill_1
X_09372_ _03126_ _03130_ VGND VGND VPWR VPWR _03131_ sky130_fd_sc_hd__nand2_1
X_06584_ u_interface.u_gelu_fp32.s1_data\[21\] u_interface.u_gelu_fp32.s1_data\[20\]
+ u_interface.u_gelu_fp32.s1_data\[19\] u_interface.u_gelu_fp32.s1_data\[18\] VGND
+ VGND VPWR VPWR _01172_ sky130_fd_sc_hd__and4_1
XFILLER_52_568 VGND VGND VPWR VPWR sky130_fd_sc_hd__decap_3
X_08323_ u_interface.u_gelu_fp32.s2_data\[20\] _02122_ VGND VGND VPWR VPWR _02125_
+ sky130_fd_sc_hd__or2_1
XFILLER_119_821 VGND VGND VPWR VPWR sky130_fd_sc_hd__decap_3
XTAP_TAPCELL_ROW_119_2241 VGND VPWR sky130_fd_sc_hd__tapvpwrvgnd_1
X_08254_ u_interface.u_gelu_fp32.s2_data\[1\] u_interface.u_gelu_fp32.s2_data\[0\]
+ u_interface.u_gelu_fp32.s2_data\[2\] net533 VGND VGND VPWR VPWR _02074_ sky130_fd_sc_hd__o31a_1
XPHY_EDGE_ROW_43_Right_43 VGND VGND VPWR VPWR sky130_fd_sc_hd__decap_3
X_07205_ net358 net1356 net259 VGND VGND VPWR VPWR _00245_ sky130_fd_sc_hd__mux2_1
XFILLER_118_331 VPWR VGND VPWR VGND sky130_ef_sc_hd__decap_12
X_08185_ _02009_ _02010_ _02014_ VGND VGND VPWR VPWR _02020_ sky130_fd_sc_hd__nor3b_1
XTAP_TAPCELL_ROW_132_2441 VGND VPWR sky130_fd_sc_hd__tapvpwrvgnd_1
XFILLER_116_9 VGND VGND VPWR VPWR sky130_fd_sc_hd__fill_1
X_07136_ net1097 net368 net217 VGND VGND VPWR VPWR _00176_ sky130_fd_sc_hd__mux2_1
XFILLER_134_846 VGND VGND VPWR VPWR sky130_fd_sc_hd__fill_2
XTAP_TAPCELL_ROW_132_2452 VGND VPWR sky130_fd_sc_hd__tapvpwrvgnd_1
X_07067_ net1235 net348 net208 VGND VGND VPWR VPWR _00107_ sky130_fd_sc_hd__mux2_1
XFILLER_102_710 VGND VGND VPWR VPWR sky130_fd_sc_hd__fill_1
XFILLER_99_281 VGND VGND VPWR VPWR sky130_fd_sc_hd__decap_8
XFILLER_58_15 VGND VGND VPWR VPWR sky130_fd_sc_hd__decap_6
XTAP_TAPCELL_ROW_7_447 VGND VPWR sky130_fd_sc_hd__tapvpwrvgnd_1
XFILLER_0_837 VGND VGND VPWR VPWR sky130_fd_sc_hd__decap_3
XFILLER_101_231 VGND VGND VPWR VPWR sky130_fd_sc_hd__decap_4
XFILLER_101_220 VGND VGND VPWR VPWR sky130_fd_sc_hd__decap_4
XFILLER_59_145 VGND VGND VPWR VPWR sky130_fd_sc_hd__decap_4
XFILLER_102_798 VGND VGND VPWR VPWR sky130_fd_sc_hd__decap_4
XPHY_EDGE_ROW_52_Right_52 VGND VGND VPWR VPWR sky130_fd_sc_hd__decap_3
X_07969_ net1081 _01846_ net774 VGND VGND VPWR VPWR _00689_ sky130_fd_sc_hd__mux2_1
XFILLER_114_76 VGND VGND VPWR VPWR sky130_fd_sc_hd__fill_1
X_09708_ _03459_ _03460_ _03355_ _03358_ VGND VGND VPWR VPWR _03463_ sky130_fd_sc_hd__o211ai_1
XFILLER_87_498 VGND VGND VPWR VPWR sky130_fd_sc_hd__decap_6
XFILLER_59_189 VPWR VGND VPWR VGND sky130_ef_sc_hd__decap_12
XFILLER_56_841 VPWR VGND VPWR VGND sky130_ef_sc_hd__decap_12
XFILLER_28_510 VGND VGND VPWR VPWR sky130_fd_sc_hd__decap_4
XFILLER_74_159 VGND VGND VPWR VPWR sky130_fd_sc_hd__fill_2
XFILLER_71_800 VGND VGND VPWR VPWR sky130_fd_sc_hd__fill_1
X_10980_ _04722_ _04723_ VGND VGND VPWR VPWR _04724_ sky130_fd_sc_hd__and2b_1
XFILLER_28_576 VPWR VGND VPWR VGND sky130_ef_sc_hd__decap_12
X_09639_ _03252_ _03254_ _03392_ _03393_ VGND VGND VPWR VPWR _03395_ sky130_fd_sc_hd__a211oi_2
XFILLER_83_693 VGND VGND VPWR VPWR sky130_fd_sc_hd__decap_3
XFILLER_71_833 VGND VGND VPWR VPWR sky130_fd_sc_hd__decap_6
XFILLER_70_321 VPWR VGND VPWR VGND sky130_ef_sc_hd__decap_12
XFILLER_16_749 VGND VGND VPWR VPWR sky130_fd_sc_hd__decap_6
XFILLER_130_53 VGND VGND VPWR VPWR sky130_fd_sc_hd__decap_6
X_12650_ net1650 u_interface.u_gelu_fp32.u_q16_to_fp32.s2_mag\[5\] net806 VGND VGND
+ VPWR VPWR _00886_ sky130_fd_sc_hd__mux2_1
XFILLER_15_259 VPWR VGND VPWR VGND sky130_ef_sc_hd__decap_12
XTAP_TAPCELL_ROW_26_744 VGND VPWR sky130_fd_sc_hd__tapvpwrvgnd_1
XTAP_TAPCELL_ROW_26_755 VGND VPWR sky130_fd_sc_hd__tapvpwrvgnd_1
X_11601_ _05337_ _05338_ net214 VGND VGND VPWR VPWR _05339_ sky130_fd_sc_hd__o21bai_1
X_12581_ net14 _06279_ _06284_ u_interface.pipeline_enable VGND VGND VPWR VPWR _06285_
+ sky130_fd_sc_hd__or4b_1
XFILLER_70_398 VGND VGND VPWR VPWR sky130_fd_sc_hd__decap_8
XPHY_EDGE_ROW_61_Right_61 VGND VGND VPWR VPWR sky130_fd_sc_hd__decap_3
XFILLER_51_590 VGND VGND VPWR VPWR sky130_fd_sc_hd__fill_1
XFILLER_11_432 VPWR VGND VPWR VGND sky130_ef_sc_hd__decap_12
XFILLER_24_793 VPWR VGND VPWR VGND sky130_ef_sc_hd__decap_12
XFILLER_23_51 VGND VGND VPWR VPWR sky130_fd_sc_hd__decap_4
X_11532_ net633 net393 VGND VGND VPWR VPWR _05271_ sky130_fd_sc_hd__nand2_1
XFILLER_139_73 VGND VGND VPWR VPWR sky130_fd_sc_hd__decap_3
X_11463_ _05127_ _05202_ VGND VGND VPWR VPWR _05203_ sky130_fd_sc_hd__xnor2_1
XFILLER_125_813 VGND VGND VPWR VPWR sky130_fd_sc_hd__decap_4
X_10414_ _04159_ _04160_ _04161_ VGND VGND VPWR VPWR _04163_ sky130_fd_sc_hd__nand3_1
X_13202_ clknet_leaf_68_clk _00212_ VGND VGND VPWR VPWR u_interface.fifo_data\[12\]\[12\]
+ sky130_fd_sc_hd__dfxtp_1
XFILLER_152_643 VGND VGND VPWR VPWR sky130_fd_sc_hd__fill_1
X_13133_ clknet_leaf_35_clk _00143_ VGND VGND VPWR VPWR u_interface.fifo_data\[2\]\[22\]
+ sky130_fd_sc_hd__dfxtp_1
XFILLER_99_88 VGND VGND VPWR VPWR sky130_fd_sc_hd__decap_8
X_11394_ _04934_ _05131_ VGND VGND VPWR VPWR _05134_ sky130_fd_sc_hd__xnor2_1
X_10345_ _04092_ _04093_ _04088_ VGND VGND VPWR VPWR _04094_ sky130_fd_sc_hd__a21o_1
XTAP_TAPCELL_ROW_55_1218 VGND VPWR sky130_fd_sc_hd__tapvpwrvgnd_1
XFILLER_3_653 VPWR VGND VPWR VGND sky130_ef_sc_hd__decap_12
XFILLER_155_83 VGND VGND VPWR VPWR sky130_fd_sc_hd__fill_1
X_13064_ clknet_leaf_53_clk _00074_ VGND VGND VPWR VPWR u_interface.fifo_data\[14\]\[17\]
+ sky130_fd_sc_hd__dfxtp_1
XFILLER_112_529 VGND VGND VPWR VPWR sky130_fd_sc_hd__decap_3
X_10276_ _03904_ _03910_ _03911_ VGND VGND VPWR VPWR _04026_ sky130_fd_sc_hd__a21bo_1
XFILLER_78_421 VPWR VGND VPWR VGND sky130_ef_sc_hd__decap_12
XPHY_EDGE_ROW_70_Right_70 VGND VGND VPWR VPWR sky130_fd_sc_hd__decap_3
XFILLER_3_697 VPWR VGND VPWR VGND sky130_ef_sc_hd__decap_12
XFILLER_2_141 VPWR VGND VPWR VGND sky130_ef_sc_hd__decap_12
X_12015_ _05740_ _05747_ VGND VGND VPWR VPWR _05748_ sky130_fd_sc_hd__or2_1
XFILLER_78_465 VGND VGND VPWR VPWR sky130_fd_sc_hd__decap_8
XFILLER_66_616 VGND VGND VPWR VPWR sky130_fd_sc_hd__fill_2
XFILLER_78_498 VPWR VGND VPWR VGND sky130_ef_sc_hd__decap_12
XFILLER_47_841 VGND VGND VPWR VPWR sky130_fd_sc_hd__decap_6
XFILLER_93_457 VGND VGND VPWR VPWR sky130_fd_sc_hd__decap_3
X_13966_ clknet_leaf_59_clk net1613 VGND VGND VPWR VPWR u_interface.u_gelu_fp32.u_q16_to_fp32.s2_mag\[11\]
+ sky130_fd_sc_hd__dfxtp_1
X_12917_ u_interface.in_flight_count\[1\] _06438_ VGND VGND VPWR VPWR _06444_ sky130_fd_sc_hd__nand2_1
X_13897_ clknet_leaf_19_clk net889 VGND VGND VPWR VPWR u_interface.u_gelu_fp32.u_synth_top.s1_x\[1\]
+ sky130_fd_sc_hd__dfxtp_1
XFILLER_74_682 VGND VGND VPWR VPWR sky130_fd_sc_hd__decap_4
X_12848_ net47 net36 _06424_ _06429_ VGND VGND VPWR VPWR _06430_ sky130_fd_sc_hd__or4_1
XFILLER_73_192 VGND VGND VPWR VPWR sky130_fd_sc_hd__fill_1
XFILLER_61_321 VPWR VGND VPWR VGND sky130_ef_sc_hd__decap_12
XFILLER_46_395 VGND VGND VPWR VPWR sky130_fd_sc_hd__decap_6
XTAP_TAPCELL_ROW_83_1661 VGND VPWR sky130_fd_sc_hd__tapvpwrvgnd_1
XFILLER_61_365 VGND VGND VPWR VPWR sky130_fd_sc_hd__fill_1
XFILLER_21_207 VPWR VGND VPWR VGND sky130_ef_sc_hd__decap_12
X_12779_ u_interface.u_gelu_fp32.u_q16_to_fp32.s3_norm_mag\[17\] u_interface.u_gelu_fp32.u_q16_to_fp32.s3_norm_mag\[16\]
+ _01780_ u_interface.u_gelu_fp32.u_q16_to_fp32.s3_norm_mag\[18\] VGND VGND VPWR VPWR
+ _06406_ sky130_fd_sc_hd__a31o_1
XFILLER_14_270 VGND VGND VPWR VPWR sky130_fd_sc_hd__decap_6
XFILLER_119_117 VGND VGND VPWR VPWR sky130_fd_sc_hd__fill_1
Xhold904 u_interface.u_gelu_fp32.u_fp32_to_q16.s3_mag\[30\] VGND VGND VPWR VPWR net1769
+ sky130_fd_sc_hd__dlygate4sd3_1
XFILLER_128_695 VGND VGND VPWR VPWR sky130_fd_sc_hd__decap_4
Xhold915 u_interface.u_gelu_fp32.u_fp32_to_q16.s3_mag\[24\] VGND VGND VPWR VPWR net1780
+ sky130_fd_sc_hd__dlygate4sd3_1
XTAP_TAPCELL_ROW_114_2160 VGND VPWR sky130_fd_sc_hd__tapvpwrvgnd_1
X_09990_ _03522_ _03527_ _03629_ VGND VGND VPWR VPWR _03743_ sky130_fd_sc_hd__and3_1
X_08941_ _02625_ _02696_ _02697_ VGND VGND VPWR VPWR _02700_ sky130_fd_sc_hd__nand3_1
XFILLER_142_197 VPWR VGND VPWR VGND sky130_ef_sc_hd__decap_12
X_08872_ net454 net585 VGND VGND VPWR VPWR _02631_ sky130_fd_sc_hd__nand2_1
XTAP_TAPCELL_ROW_4_406 VGND VPWR sky130_fd_sc_hd__tapvpwrvgnd_1
X_07823_ net1390 net343 net229 VGND VGND VPWR VPWR _00584_ sky130_fd_sc_hd__mux2_1
XFILLER_28_29 VPWR VGND VPWR VGND sky130_ef_sc_hd__decap_12
XFILLER_29_329 VGND VGND VPWR VPWR sky130_fd_sc_hd__decap_4
X_07754_ u_interface.u_gelu_fp32.u_q16_to_fp32.s3_exp\[2\] _01794_ VGND VGND VPWR
+ VPWR _01796_ sky130_fd_sc_hd__and2_1
XFILLER_84_457 VPWR VGND VPWR VGND sky130_ef_sc_hd__decap_12
X_07685_ _01128_ _00495_ _01758_ VGND VGND VPWR VPWR _00491_ sky130_fd_sc_hd__or3_1
XFILLER_65_671 VGND VGND VPWR VPWR sky130_fd_sc_hd__fill_1
X_06705_ u_interface.fifo_data\[0\]\[9\] u_interface.fifo_data\[1\]\[9\] u_interface.fifo_data\[2\]\[9\]
+ u_interface.fifo_data\[3\]\[9\] net756 net739 VGND VGND VPWR VPWR _01271_ sky130_fd_sc_hd__mux4_1
X_09424_ _03179_ _03180_ VGND VGND VPWR VPWR _03182_ sky130_fd_sc_hd__xnor2_1
X_06636_ _01205_ _01207_ _01210_ net316 VGND VGND VPWR VPWR net109 sky130_fd_sc_hd__a22o_1
XFILLER_52_387 VPWR VGND VPWR VGND sky130_ef_sc_hd__decap_12
XFILLER_52_365 VGND VGND VPWR VPWR sky130_fd_sc_hd__decap_8
XTAP_TAPCELL_ROW_23_703 VGND VPWR sky130_fd_sc_hd__tapvpwrvgnd_1
X_09355_ _02990_ _03010_ _03033_ _03035_ VGND VGND VPWR VPWR _03114_ sky130_fd_sc_hd__o211a_1
X_06567_ _01158_ _01159_ _01160_ _01157_ VGND VGND VPWR VPWR _01161_ sky130_fd_sc_hd__o2bb2a_1
XFILLER_100_23 VGND VGND VPWR VPWR sky130_fd_sc_hd__decap_4
XFILLER_21_741 VPWR VGND VPWR VGND sky130_ef_sc_hd__decap_12
X_09286_ _03014_ _03016_ _03015_ VGND VGND VPWR VPWR _03045_ sky130_fd_sc_hd__o21ai_1
X_08306_ _02111_ _02112_ VGND VGND VPWR VPWR _00760_ sky130_fd_sc_hd__nor2_1
X_08237_ _02059_ _02057_ VGND VGND VPWR VPWR _02064_ sky130_fd_sc_hd__nand2b_1
XFILLER_20_284 VGND VGND VPWR VPWR sky130_fd_sc_hd__fill_2
XFILLER_21_785 VPWR VGND VPWR VGND sky130_ef_sc_hd__decap_12
XFILLER_119_673 VGND VGND VPWR VPWR sky130_fd_sc_hd__decap_3
Xclkbuf_3_0__f_clk clknet_0_clk VGND VGND VPWR VPWR clknet_3_0__leaf_clk sky130_fd_sc_hd__clkbuf_16
X_08168_ net315 _02004_ _02003_ VGND VGND VPWR VPWR _02006_ sky130_fd_sc_hd__o21ai_1
X_07119_ net1067 net325 net248 VGND VGND VPWR VPWR _00159_ sky130_fd_sc_hd__mux2_1
XFILLER_134_643 VGND VGND VPWR VPWR sky130_fd_sc_hd__fill_1
X_08099_ _01878_ _01947_ VGND VGND VPWR VPWR _01948_ sky130_fd_sc_hd__or2_1
XFILLER_69_47 VGND VGND VPWR VPWR sky130_fd_sc_hd__decap_8
X_10130_ _03879_ _03880_ net189 VGND VGND VPWR VPWR _03881_ sky130_fd_sc_hd__a21o_1
XFILLER_69_69 VPWR VGND VPWR VGND sky130_ef_sc_hd__decap_12
XFILLER_0_601 VPWR VGND VPWR VGND sky130_ef_sc_hd__decap_12
XFILLER_121_359 VGND VGND VPWR VPWR sky130_fd_sc_hd__fill_2
XFILLER_121_337 VGND VGND VPWR VPWR sky130_fd_sc_hd__fill_1
X_10061_ net465 net662 net673 net469 VGND VGND VPWR VPWR _03813_ sky130_fd_sc_hd__a22o_1
XFILLER_0_645 VPWR VGND VPWR VGND sky130_ef_sc_hd__decap_12
XFILLER_125_53 VGND VGND VPWR VPWR sky130_fd_sc_hd__decap_3
XTAP_TAPCELL_ROW_50_1137 VGND VPWR sky130_fd_sc_hd__tapvpwrvgnd_1
XFILLER_48_605 VGND VGND VPWR VPWR sky130_fd_sc_hd__fill_2
XTAP_TAPCELL_ROW_145_2654 VGND VPWR sky130_fd_sc_hd__tapvpwrvgnd_1
XFILLER_75_424 VPWR VGND VPWR VGND sky130_ef_sc_hd__decap_12
XFILLER_29_841 VPWR VGND VPWR VGND sky130_ef_sc_hd__decap_12
X_13820_ clknet_leaf_81_clk _00830_ VGND VGND VPWR VPWR u_interface.u_gelu_fp32.u_synth_top.s3_mult\[38\]
+ sky130_fd_sc_hd__dfxtp_1
XFILLER_90_416 VGND VGND VPWR VPWR sky130_fd_sc_hd__decap_4
X_13751_ clknet_leaf_84_clk _00761_ VGND VGND VPWR VPWR u_interface.u_gelu_fp32.u_q16_to_fp32.s1_mag\[17\]
+ sky130_fd_sc_hd__dfxtp_1
X_10963_ _04598_ _04602_ _04704_ _04705_ VGND VGND VPWR VPWR _04707_ sky130_fd_sc_hd__o211a_1
X_12702_ u_interface.u_gelu_fp32.u_q16_to_fp32.s2_clz\[3\] _01717_ net288 VGND VGND
+ VPWR VPWR _06359_ sky130_fd_sc_hd__o21ai_1
Xclkbuf_leaf_82_clk clknet_3_4__leaf_clk VGND VGND VPWR VPWR clknet_leaf_82_clk sky130_fd_sc_hd__clkbuf_8
XFILLER_44_866 VGND VGND VPWR VPWR sky130_fd_sc_hd__fill_2
X_13682_ clknet_leaf_9_clk _00692_ VGND VGND VPWR VPWR u_interface.u_gelu_fp32.u_fp32_to_q16.s3_frac\[18\]
+ sky130_fd_sc_hd__dfxtp_1
X_10894_ _04516_ _04638_ VGND VGND VPWR VPWR _04639_ sky130_fd_sc_hd__xor2_1
XFILLER_31_505 VGND VGND VPWR VPWR sky130_fd_sc_hd__fill_2
X_12633_ _06332_ _06333_ VGND VGND VPWR VPWR _06334_ sky130_fd_sc_hd__or2_1
XFILLER_70_184 VGND VGND VPWR VPWR sky130_fd_sc_hd__decap_3
XTAP_TAPCELL_ROW_65_1380 VGND VPWR sky130_fd_sc_hd__tapvpwrvgnd_1
XTAP_TAPCELL_ROW_48_1099 VGND VPWR sky130_fd_sc_hd__tapvpwrvgnd_1
XFILLER_43_387 VGND VGND VPWR VPWR sky130_fd_sc_hd__decap_4
XFILLER_129_415 VGND VGND VPWR VPWR sky130_fd_sc_hd__decap_8
X_12564_ net784 net1744 VGND VGND VPWR VPWR _00862_ sky130_fd_sc_hd__and2_1
XFILLER_8_701 VPWR VGND VPWR VGND sky130_ef_sc_hd__decap_12
X_11515_ _05252_ _05253_ VGND VGND VPWR VPWR _05254_ sky130_fd_sc_hd__and2b_1
X_12495_ _06218_ _06219_ _06220_ VGND VGND VPWR VPWR _00841_ sky130_fd_sc_hd__o21a_1
XFILLER_50_82 VGND VGND VPWR VPWR sky130_fd_sc_hd__fill_2
XFILLER_7_277 VGND VGND VPWR VPWR sky130_fd_sc_hd__decap_3
X_11446_ _05176_ _05185_ VGND VGND VPWR VPWR _05186_ sky130_fd_sc_hd__xnor2_1
XFILLER_125_643 VGND VGND VPWR VPWR sky130_fd_sc_hd__fill_1
XFILLER_113_816 VGND VGND VPWR VPWR sky130_fd_sc_hd__decap_3
XFILLER_98_505 VGND VGND VPWR VPWR sky130_fd_sc_hd__fill_1
X_14165_ clknet_leaf_49_clk _01091_ VGND VGND VPWR VPWR u_interface.fifo_data\[1\]\[25\]
+ sky130_fd_sc_hd__dfxtp_1
X_11377_ _04906_ _05021_ VGND VGND VPWR VPWR _05118_ sky130_fd_sc_hd__or2_1
XFILLER_152_462 VPWR VGND VPWR VGND sky130_ef_sc_hd__decap_12
X_14096_ clknet_leaf_35_clk _01022_ VGND VGND VPWR VPWR u_interface.meta_tuser_pipe\[11\]
+ sky130_fd_sc_hd__dfxtp_1
XFILLER_125_687 VGND VGND VPWR VPWR sky130_fd_sc_hd__decap_3
XFILLER_113_849 VGND VGND VPWR VPWR sky130_fd_sc_hd__decap_3
X_10328_ _04077_ VGND VGND VPWR VPWR _04078_ sky130_fd_sc_hd__inv_2
X_13116_ clknet_leaf_70_clk _00126_ VGND VGND VPWR VPWR u_interface.fifo_data\[2\]\[5\]
+ sky130_fd_sc_hd__dfxtp_1
XFILLER_3_461 VPWR VGND VPWR VGND sky130_ef_sc_hd__decap_12
XFILLER_112_348 VGND VGND VPWR VPWR sky130_fd_sc_hd__decap_3
XFILLER_79_741 VGND VGND VPWR VPWR sky130_fd_sc_hd__fill_1
X_13047_ clknet_leaf_62_clk _00057_ VGND VGND VPWR VPWR u_interface.fifo_data\[14\]\[0\]
+ sky130_fd_sc_hd__dfxtp_1
XFILLER_78_251 VGND VGND VPWR VPWR sky130_fd_sc_hd__fill_1
X_10259_ _04005_ _04006_ _04007_ VGND VGND VPWR VPWR _04009_ sky130_fd_sc_hd__nand3_1
XFILLER_59_91 VPWR VGND VPWR VGND sky130_ef_sc_hd__decap_12
XFILLER_38_137 VGND VGND VPWR VPWR sky130_fd_sc_hd__decap_3
XFILLER_94_788 VGND VGND VPWR VPWR sky130_fd_sc_hd__fill_1
XFILLER_93_265 VGND VGND VPWR VPWR sky130_fd_sc_hd__fill_1
XTAP_TAPCELL_ROW_85_1701 VGND VPWR sky130_fd_sc_hd__tapvpwrvgnd_1
XFILLER_81_438 VGND VGND VPWR VPWR sky130_fd_sc_hd__fill_2
XFILLER_19_384 VGND VGND VPWR VPWR sky130_fd_sc_hd__decap_8
XFILLER_35_833 VGND VGND VPWR VPWR sky130_fd_sc_hd__decap_6
X_13949_ clknet_leaf_56_clk _00875_ VGND VGND VPWR VPWR u_interface.u_gelu_fp32.u_q16_to_fp32.s2_exp\[1\]
+ sky130_fd_sc_hd__dfxtp_1
Xclkbuf_leaf_73_clk clknet_3_5__leaf_clk VGND VGND VPWR VPWR clknet_leaf_73_clk sky130_fd_sc_hd__clkbuf_8
X_07470_ _01551_ _01554_ net556 VGND VGND VPWR VPWR _01604_ sky130_fd_sc_hd__mux2_1
XPHY_EDGE_ROW_93_Left_249 VGND VGND VPWR VPWR sky130_fd_sc_hd__decap_3
XFILLER_61_140 VPWR VGND VPWR VGND sky130_ef_sc_hd__decap_12
XFILLER_34_365 VPWR VGND VPWR VGND sky130_ef_sc_hd__decap_12
XFILLER_62_696 VGND VGND VPWR VPWR sky130_fd_sc_hd__decap_4
XFILLER_50_869 VGND VGND VPWR VPWR sky130_fd_sc_hd__decap_3
X_09140_ _02883_ _02897_ _02898_ VGND VGND VPWR VPWR _02899_ sky130_fd_sc_hd__nand3_1
XFILLER_147_223 VGND VGND VPWR VPWR sky130_fd_sc_hd__fill_1
X_09071_ _02730_ _02779_ _02778_ VGND VGND VPWR VPWR _02830_ sky130_fd_sc_hd__a21o_1
X_08022_ u_interface.u_gelu_fp32.u_fp32_to_q16.s3_mag\[10\] u_interface.u_gelu_fp32.u_fp32_to_q16.s3_mag\[9\]
+ _01878_ VGND VGND VPWR VPWR _01879_ sky130_fd_sc_hd__and3_1
Xhold701 u_interface.fifo_data\[11\]\[16\] VGND VGND VPWR VPWR net1566 sky130_fd_sc_hd__dlygate4sd3_1
Xhold712 u_interface.u_gelu_fp32.u_fp32_to_q16.s3_frac\[4\] VGND VGND VPWR VPWR net1577
+ sky130_fd_sc_hd__dlygate4sd3_1
Xhold745 _01013_ VGND VGND VPWR VPWR net1610 sky130_fd_sc_hd__dlygate4sd3_1
Xhold734 _01017_ VGND VGND VPWR VPWR net1599 sky130_fd_sc_hd__dlygate4sd3_1
XTAP_TAPCELL_ROW_96_1874 VGND VPWR sky130_fd_sc_hd__tapvpwrvgnd_1
XFILLER_89_505 VGND VGND VPWR VPWR sky130_fd_sc_hd__decap_3
Xhold723 u_interface.u_gelu_fp32.s2_data\[15\] VGND VGND VPWR VPWR net1588 sky130_fd_sc_hd__dlygate4sd3_1
X_09973_ _03613_ _03723_ _03724_ VGND VGND VPWR VPWR _03726_ sky130_fd_sc_hd__nand3_2
XFILLER_89_538 VPWR VGND VPWR VGND sky130_ef_sc_hd__decap_12
Xhold778 u_interface.u_gelu_fp32.s2_data\[8\] VGND VGND VPWR VPWR net1643 sky130_fd_sc_hd__dlygate4sd3_1
Xhold756 u_interface.u_gelu_fp32.u_q16_to_fp32.s1_mag\[7\] VGND VGND VPWR VPWR net1621
+ sky130_fd_sc_hd__dlygate4sd3_1
Xhold767 u_interface.u_gelu_fp32.s2_data\[27\] VGND VGND VPWR VPWR net1632 sky130_fd_sc_hd__dlygate4sd3_1
XFILLER_130_112 VGND VGND VPWR VPWR sky130_fd_sc_hd__fill_1
X_08924_ net498 net671 _02680_ _02681_ VGND VGND VPWR VPWR _02683_ sky130_fd_sc_hd__nand4_2
XFILLER_115_197 VPWR VGND VPWR VGND sky130_ef_sc_hd__decap_12
Xhold789 u_interface.u_gelu_fp32.s2_data\[13\] VGND VGND VPWR VPWR net1654 sky130_fd_sc_hd__dlygate4sd3_1
XFILLER_39_39 VPWR VGND VPWR VGND sky130_ef_sc_hd__decap_12
XFILLER_130_167 VGND VGND VPWR VPWR sky130_fd_sc_hd__decap_8
XFILLER_97_571 VPWR VGND VPWR VGND sky130_ef_sc_hd__decap_12
X_08855_ _02611_ _02612_ _02613_ VGND VGND VPWR VPWR _02614_ sky130_fd_sc_hd__a21oi_1
XFILLER_57_435 VGND VGND VPWR VPWR sky130_fd_sc_hd__decap_6
XTAP_TAPCELL_ROW_127_2373 VGND VPWR sky130_fd_sc_hd__tapvpwrvgnd_1
XTAP_TAPCELL_ROW_127_2362 VGND VPWR sky130_fd_sc_hd__tapvpwrvgnd_1
X_08786_ _02543_ _02544_ _02534_ VGND VGND VPWR VPWR _02545_ sky130_fd_sc_hd__a21oi_1
X_07806_ net1238 net377 net230 VGND VGND VPWR VPWR _00567_ sky130_fd_sc_hd__mux2_1
XFILLER_57_446 VGND VGND VPWR VPWR sky130_fd_sc_hd__fill_2
XPHY_EDGE_ROW_2_Right_2 VGND VGND VPWR VPWR sky130_fd_sc_hd__decap_3
X_07737_ u_interface.u_gelu_fp32.u_q16_to_fp32.s3_norm_mag\[16\] _01780_ VGND VGND
+ VPWR VPWR _01781_ sky130_fd_sc_hd__and2_1
XFILLER_26_811 VGND VGND VPWR VPWR sky130_fd_sc_hd__fill_1
Xclkbuf_leaf_64_clk clknet_3_5__leaf_clk VGND VGND VPWR VPWR clknet_leaf_64_clk sky130_fd_sc_hd__clkbuf_8
XTAP_TAPCELL_ROW_140_2573 VGND VPWR sky130_fd_sc_hd__tapvpwrvgnd_1
XFILLER_111_55 VGND VGND VPWR VPWR sky130_fd_sc_hd__fill_1
X_07668_ u_interface.u_gelu_fp32.u_q16_to_fp32.s2_clz\[3\] net299 VGND VGND VPWR VPWR
+ _01749_ sky130_fd_sc_hd__nand2_1
XFILLER_13_505 VPWR VGND VPWR VGND sky130_ef_sc_hd__decap_12
XFILLER_41_825 VPWR VGND VPWR VGND sky130_ef_sc_hd__decap_12
X_06619_ _01194_ _01195_ net736 VGND VGND VPWR VPWR _01196_ sky130_fd_sc_hd__mux2_1
X_09407_ _03163_ _03164_ VGND VGND VPWR VPWR _03165_ sky130_fd_sc_hd__nand2_1
X_07599_ u_interface.u_gelu_fp32.u_q16_to_fp32.s2_clz\[4\] net808 VGND VGND VPWR VPWR
+ _01695_ sky130_fd_sc_hd__nor2_1
XFILLER_71_15 VGND VGND VPWR VPWR sky130_fd_sc_hd__decap_8
X_09338_ _03077_ _03096_ VGND VGND VPWR VPWR _03097_ sky130_fd_sc_hd__nor2_1
X_09269_ _03025_ _03026_ _03011_ VGND VGND VPWR VPWR _03028_ sky130_fd_sc_hd__a21o_1
X_11300_ _05030_ _05040_ VGND VGND VPWR VPWR _05041_ sky130_fd_sc_hd__and2b_1
XFILLER_138_289 VPWR VGND VPWR VGND sky130_ef_sc_hd__decap_12
XFILLER_112_3 VGND VGND VPWR VPWR sky130_fd_sc_hd__decap_6
X_12280_ net198 _06007_ VGND VGND VPWR VPWR _06009_ sky130_fd_sc_hd__nor2_1
X_11231_ _04967_ _04972_ VGND VGND VPWR VPWR _04973_ sky130_fd_sc_hd__nand2_1
XFILLER_20_41 VPWR VGND VPWR VGND sky130_ef_sc_hd__decap_12
XFILLER_136_41 VGND VGND VPWR VPWR sky130_fd_sc_hd__decap_4
XFILLER_122_613 VGND VGND VPWR VPWR sky130_fd_sc_hd__decap_8
X_11162_ _04902_ _04903_ VGND VGND VPWR VPWR _04905_ sky130_fd_sc_hd__nand2_1
XFILLER_20_85 VPWR VGND VPWR VGND sky130_ef_sc_hd__decap_12
XFILLER_106_197 VGND VGND VPWR VPWR sky130_fd_sc_hd__fill_1
X_10113_ _03768_ _03770_ VGND VGND VPWR VPWR _03864_ sky130_fd_sc_hd__nand2_1
XFILLER_96_56 VGND VGND VPWR VPWR sky130_fd_sc_hd__fill_1
X_11093_ net677 net434 VGND VGND VPWR VPWR _04836_ sky130_fd_sc_hd__nand2_1
Xhold50 u_interface.u_gelu_fp32.u_synth_top.s2_b\[4\] VGND VGND VPWR VPWR net915 sky130_fd_sc_hd__dlygate4sd3_1
X_10044_ net596 net436 _03677_ _03676_ VGND VGND VPWR VPWR _03796_ sky130_fd_sc_hd__a31o_1
Xhold61 u_interface.meta_tlast_pipe\[5\] VGND VGND VPWR VPWR net926 sky130_fd_sc_hd__dlygate4sd3_1
Xhold83 u_interface.u_gelu_fp32.u_fp32_to_q16.s3_frac\[18\] VGND VGND VPWR VPWR net948
+ sky130_fd_sc_hd__dlygate4sd3_1
Xhold72 u_interface.u_gelu_fp32.u_q16_to_fp32.s1_mag\[0\] VGND VGND VPWR VPWR net937
+ sky130_fd_sc_hd__dlygate4sd3_1
XFILLER_102_392 VGND VGND VPWR VPWR sky130_fd_sc_hd__decap_8
XFILLER_76_755 VGND VGND VPWR VPWR sky130_fd_sc_hd__fill_1
Xhold94 u_interface.fifo_data\[4\]\[17\] VGND VGND VPWR VPWR net959 sky130_fd_sc_hd__dlygate4sd3_1
X_13803_ clknet_leaf_57_clk _00813_ VGND VGND VPWR VPWR u_interface.u_gelu_fp32.u_synth_top.s3_mult\[21\]
+ sky130_fd_sc_hd__dfxtp_1
XFILLER_29_671 VGND VGND VPWR VPWR sky130_fd_sc_hd__fill_1
Xclkbuf_leaf_55_clk clknet_3_6__leaf_clk VGND VGND VPWR VPWR clknet_leaf_55_clk sky130_fd_sc_hd__clkbuf_8
XFILLER_17_833 VGND VGND VPWR VPWR sky130_fd_sc_hd__decap_6
X_11995_ net183 _05727_ VGND VGND VPWR VPWR _05728_ sky130_fd_sc_hd__xnor2_1
X_13734_ clknet_leaf_54_clk _00744_ VGND VGND VPWR VPWR u_interface.u_gelu_fp32.u_q16_to_fp32.s1_mag\[0\]
+ sky130_fd_sc_hd__dfxtp_1
X_10946_ _04686_ _04689_ VGND VGND VPWR VPWR _04690_ sky130_fd_sc_hd__xnor2_1
XFILLER_16_354 VGND VGND VPWR VPWR sky130_fd_sc_hd__decap_8
XFILLER_16_365 VGND VGND VPWR VPWR sky130_fd_sc_hd__fill_1
XFILLER_16_376 VGND VGND VPWR VPWR sky130_fd_sc_hd__decap_6
XFILLER_17_877 VPWR VGND VPWR VGND sky130_ef_sc_hd__decap_12
XFILLER_32_825 VPWR VGND VPWR VGND sky130_ef_sc_hd__decap_12
X_13665_ clknet_leaf_14_clk _00675_ VGND VGND VPWR VPWR u_interface.u_gelu_fp32.u_fp32_to_q16.s2_shift\[2\]
+ sky130_fd_sc_hd__dfxtp_1
XTAP_TAPCELL_ROW_80_1620 VGND VPWR sky130_fd_sc_hd__tapvpwrvgnd_1
XTAP_TAPCELL_ROW_63_1339 VGND VPWR sky130_fd_sc_hd__tapvpwrvgnd_1
X_10877_ _04620_ _04621_ VGND VGND VPWR VPWR _04622_ sky130_fd_sc_hd__nor2_1
XFILLER_45_93 VGND VGND VPWR VPWR sky130_fd_sc_hd__decap_8
XFILLER_44_696 VGND VGND VPWR VPWR sky130_fd_sc_hd__decap_4
XFILLER_31_313 VGND VGND VPWR VPWR sky130_fd_sc_hd__fill_2
X_12616_ u_interface.u_gelu_fp32.u_q16_to_fp32.s1_mag\[11\] net212 net186 _06318_
+ u_interface.u_gelu_fp32.u_q16_to_fp32.s1_mag\[27\] VGND VGND VPWR VPWR _06319_ sky130_fd_sc_hd__a221o_1
XTAP_TAPCELL_ROW_14_555 VGND VPWR sky130_fd_sc_hd__tapvpwrvgnd_1
XFILLER_32_869 VPWR VGND VPWR VGND sky130_ef_sc_hd__decap_12
XFILLER_129_223 VGND VGND VPWR VPWR sky130_fd_sc_hd__fill_1
X_13596_ clknet_leaf_51_clk _00606_ VGND VGND VPWR VPWR u_interface.fifo_data\[3\]\[11\]
+ sky130_fd_sc_hd__dfxtp_1
XFILLER_8_531 VGND VGND VPWR VPWR sky130_fd_sc_hd__fill_1
XTAP_TAPCELL_ROW_14_566 VGND VPWR sky130_fd_sc_hd__tapvpwrvgnd_1
XFILLER_31_379 VGND VGND VPWR VPWR sky130_fd_sc_hd__decap_4
X_12547_ _06269_ _06270_ VGND VGND VPWR VPWR _06271_ sky130_fd_sc_hd__nor2_1
Xgelu_top_838 VGND VGND VPWR VPWR gelu_top_838/HI s_axil_rdata[6] sky130_fd_sc_hd__conb_1
XFILLER_144_226 VGND VGND VPWR VPWR sky130_fd_sc_hd__fill_1
XANTENNA_3 _01518_ VGND VGND VPWR VPWR sky130_fd_sc_hd__diode_2
Xgelu_top_849 VGND VGND VPWR VPWR gelu_top_849/HI s_axil_rdata[17] sky130_fd_sc_hd__conb_1
X_12478_ _06129_ _06155_ _06156_ VGND VGND VPWR VPWR _06204_ sky130_fd_sc_hd__o21a_1
XTAP_TAPCELL_ROW_78_1582 VGND VPWR sky130_fd_sc_hd__tapvpwrvgnd_1
XFILLER_6_65 VPWR VGND VPWR VGND sky130_ef_sc_hd__decap_12
X_11429_ _05163_ _05166_ _05167_ VGND VGND VPWR VPWR _05169_ sky130_fd_sc_hd__and3_1
XFILLER_153_793 VGND VGND VPWR VPWR sky130_fd_sc_hd__decap_6
XFILLER_125_473 VGND VGND VPWR VPWR sky130_fd_sc_hd__fill_1
XFILLER_113_613 VGND VGND VPWR VPWR sky130_fd_sc_hd__decap_3
X_14148_ clknet_leaf_72_clk _01074_ VGND VGND VPWR VPWR u_interface.fifo_data\[1\]\[8\]
+ sky130_fd_sc_hd__dfxtp_1
XFILLER_152_281 VPWR VGND VPWR VGND sky130_ef_sc_hd__decap_12
XFILLER_140_421 VPWR VGND VPWR VGND sky130_ef_sc_hd__decap_12
XFILLER_125_495 VGND VGND VPWR VPWR sky130_fd_sc_hd__decap_8
XFILLER_4_781 VPWR VGND VPWR VGND sky130_ef_sc_hd__decap_12
XFILLER_140_465 VGND VGND VPWR VPWR sky130_fd_sc_hd__decap_8
X_14079_ clknet_leaf_18_clk net1626 VGND VGND VPWR VPWR u_interface.u_gelu_fp32.u_fp32_to_q16.s2_norm_mag\[16\]
+ sky130_fd_sc_hd__dfxtp_1
XFILLER_98_379 VGND VGND VPWR VPWR sky130_fd_sc_hd__fill_1
XTAP_TAPCELL_ROW_91_1793 VGND VPWR sky130_fd_sc_hd__tapvpwrvgnd_1
X_06970_ _01490_ _01492_ _01496_ VGND VGND VPWR VPWR _01498_ sky130_fd_sc_hd__and3_1
XFILLER_67_733 VGND VGND VPWR VPWR sky130_fd_sc_hd__fill_2
XFILLER_66_210 VGND VGND VPWR VPWR sky130_fd_sc_hd__decap_8
XFILLER_94_552 VGND VGND VPWR VPWR sky130_fd_sc_hd__decap_3
XFILLER_94_541 VGND VGND VPWR VPWR sky130_fd_sc_hd__decap_3
X_08640_ _02170_ _02409_ VGND VGND VPWR VPWR _02410_ sky130_fd_sc_hd__xnor2_1
XTAP_TAPCELL_ROW_109_2081 VGND VPWR sky130_fd_sc_hd__tapvpwrvgnd_1
XFILLER_54_427 VGND VGND VPWR VPWR sky130_fd_sc_hd__fill_1
X_08571_ _02213_ net158 _02361_ VGND VGND VPWR VPWR _02362_ sky130_fd_sc_hd__nand3_1
Xclkbuf_leaf_46_clk clknet_3_7__leaf_clk VGND VGND VPWR VPWR clknet_leaf_46_clk sky130_fd_sc_hd__clkbuf_8
XFILLER_19_181 VGND VGND VPWR VPWR sky130_fd_sc_hd__decap_8
XFILLER_35_641 VPWR VGND VPWR VGND sky130_ef_sc_hd__decap_12
X_07522_ net815 net1525 net300 _01651_ VGND VGND VPWR VPWR _00436_ sky130_fd_sc_hd__a22o_1
XFILLER_81_279 VGND VGND VPWR VPWR sky130_fd_sc_hd__fill_1
X_07453_ u_interface.u_gelu_fp32.u_fp32_to_q16.s2_norm_mag\[9\] u_interface.u_gelu_fp32.u_fp32_to_q16.s2_norm_mag\[10\]
+ net560 VGND VGND VPWR VPWR _01588_ sky130_fd_sc_hd__mux2_1
XTAP_TAPCELL_ROW_122_2292 VGND VPWR sky130_fd_sc_hd__tapvpwrvgnd_1
XTAP_TAPCELL_ROW_122_2281 VGND VPWR sky130_fd_sc_hd__tapvpwrvgnd_1
XFILLER_62_493 VGND VGND VPWR VPWR sky130_fd_sc_hd__fill_1
XFILLER_22_313 VGND VGND VPWR VPWR sky130_fd_sc_hd__fill_1
XTAP_TAPCELL_ROW_33_864 VGND VPWR sky130_fd_sc_hd__tapvpwrvgnd_1
X_09123_ _02829_ _02880_ _02881_ VGND VGND VPWR VPWR _02882_ sky130_fd_sc_hd__and3b_1
X_07384_ net1066 net350 net239 VGND VGND VPWR VPWR _00414_ sky130_fd_sc_hd__mux2_1
XTAP_TAPCELL_ROW_98_1903 VGND VPWR sky130_fd_sc_hd__tapvpwrvgnd_1
XFILLER_109_908 VGND VGND VPWR VPWR sky130_fd_sc_hd__fill_1
XFILLER_108_407 VGND VGND VPWR VPWR sky130_fd_sc_hd__decap_3
XFILLER_30_390 VPWR VGND VPWR VGND sky130_ef_sc_hd__decap_12
X_09054_ _02810_ _02812_ VGND VGND VPWR VPWR _02813_ sky130_fd_sc_hd__nand2b_1
X_08005_ net548 net303 _01645_ net278 VGND VGND VPWR VPWR _01868_ sky130_fd_sc_hd__a31o_1
Xhold520 u_interface.fifo_data\[4\]\[5\] VGND VGND VPWR VPWR net1385 sky130_fd_sc_hd__dlygate4sd3_1
XFILLER_150_218 VGND VGND VPWR VPWR sky130_fd_sc_hd__decap_8
Xhold542 u_interface.fifo_data\[6\]\[26\] VGND VGND VPWR VPWR net1407 sky130_fd_sc_hd__dlygate4sd3_1
Xhold553 u_interface.fifo_data\[10\]\[29\] VGND VGND VPWR VPWR net1418 sky130_fd_sc_hd__dlygate4sd3_1
XFILLER_116_473 VGND VGND VPWR VPWR sky130_fd_sc_hd__decap_3
Xhold531 u_interface.fifo_data\[10\]\[8\] VGND VGND VPWR VPWR net1396 sky130_fd_sc_hd__dlygate4sd3_1
Xhold597 u_interface.u_gelu_fp32.u_fp32_to_q16.s1_mant\[1\] VGND VGND VPWR VPWR net1462
+ sky130_fd_sc_hd__dlygate4sd3_1
XFILLER_143_281 VGND VGND VPWR VPWR sky130_fd_sc_hd__decap_8
XFILLER_131_432 VGND VGND VPWR VPWR sky130_fd_sc_hd__decap_8
XFILLER_116_495 VPWR VGND VPWR VGND sky130_ef_sc_hd__decap_12
Xhold575 u_interface.fifo_data\[3\]\[24\] VGND VGND VPWR VPWR net1440 sky130_fd_sc_hd__dlygate4sd3_1
Xhold564 u_interface.fifo_data\[15\]\[27\] VGND VGND VPWR VPWR net1429 sky130_fd_sc_hd__dlygate4sd3_1
XFILLER_1_217 VGND VGND VPWR VPWR sky130_fd_sc_hd__decap_6
Xhold586 u_interface.fifo_data\[14\]\[3\] VGND VGND VPWR VPWR net1451 sky130_fd_sc_hd__dlygate4sd3_1
XFILLER_131_465 VGND VGND VPWR VPWR sky130_fd_sc_hd__fill_2
XTAP_TAPCELL_ROW_129_2402 VGND VPWR sky130_fd_sc_hd__tapvpwrvgnd_1
XFILLER_106_33 VGND VGND VPWR VPWR sky130_fd_sc_hd__fill_1
XFILLER_104_679 VGND VGND VPWR VPWR sky130_fd_sc_hd__decap_4
XFILLER_103_167 VGND VGND VPWR VPWR sky130_fd_sc_hd__fill_1
XFILLER_103_134 VGND VGND VPWR VPWR sky130_fd_sc_hd__fill_1
X_09956_ net463 net649 _03706_ _03707_ VGND VGND VPWR VPWR _03709_ sky130_fd_sc_hd__nand4_1
X_08907_ net504 net679 net509 net690 VGND VGND VPWR VPWR _02666_ sky130_fd_sc_hd__a22o_1
X_09887_ _03638_ _03639_ _03637_ VGND VGND VPWR VPWR _03640_ sky130_fd_sc_hd__a21o_1
XFILLER_66_15 VPWR VGND VPWR VGND sky130_ef_sc_hd__decap_12
XTAP_TAPCELL_ROW_142_2602 VGND VPWR sky130_fd_sc_hd__tapvpwrvgnd_1
X_08838_ _02578_ _02579_ _02596_ VGND VGND VPWR VPWR _02597_ sky130_fd_sc_hd__nor3_1
XPHY_EDGE_ROW_142_Right_142 VGND VGND VPWR VPWR sky130_fd_sc_hd__decap_3
XTAP_TAPCELL_ROW_142_2613 VGND VPWR sky130_fd_sc_hd__tapvpwrvgnd_1
XFILLER_57_265 VGND VGND VPWR VPWR sky130_fd_sc_hd__fill_1
Xclkbuf_leaf_37_clk clknet_3_7__leaf_clk VGND VGND VPWR VPWR clknet_leaf_37_clk sky130_fd_sc_hd__clkbuf_8
X_08769_ net614 net621 net476 net480 VGND VGND VPWR VPWR _02528_ sky130_fd_sc_hd__and4_1
XFILLER_45_449 VPWR VGND VPWR VGND sky130_ef_sc_hd__decap_12
XFILLER_122_98 VGND VGND VPWR VPWR sky130_fd_sc_hd__decap_3
XFILLER_122_76 VGND VGND VPWR VPWR sky130_fd_sc_hd__fill_2
XFILLER_72_268 VGND VGND VPWR VPWR sky130_fd_sc_hd__decap_8
X_10800_ _04419_ _04422_ _04543_ _04544_ VGND VGND VPWR VPWR _04546_ sky130_fd_sc_hd__a211oi_2
XFILLER_25_140 VPWR VGND VPWR VGND sky130_ef_sc_hd__decap_12
X_11780_ _05515_ _05514_ _05513_ VGND VGND VPWR VPWR _05516_ sky130_fd_sc_hd__nand3b_1
XFILLER_81_780 VGND VGND VPWR VPWR sky130_fd_sc_hd__decap_4
X_10731_ _04475_ _04476_ _04469_ VGND VGND VPWR VPWR _04477_ sky130_fd_sc_hd__a21o_1
XFILLER_53_482 VGND VGND VPWR VPWR sky130_fd_sc_hd__decap_8
XFILLER_14_825 VPWR VGND VPWR VGND sky130_ef_sc_hd__decap_12
X_13450_ clknet_leaf_9_clk _00460_ VGND VGND VPWR VPWR u_interface.u_gelu_fp32.u_fp32_to_q16.s3_mag\[21\]
+ sky130_fd_sc_hd__dfxtp_1
XTAP_TAPCELL_ROW_45_1058 VGND VPWR sky130_fd_sc_hd__tapvpwrvgnd_1
XFILLER_14_869 VPWR VGND VPWR VGND sky130_ef_sc_hd__decap_12
XFILLER_41_677 VGND VGND VPWR VPWR sky130_fd_sc_hd__fill_1
X_10662_ _04407_ _04408_ _04290_ VGND VGND VPWR VPWR _04409_ sky130_fd_sc_hd__o21bai_1
XTAP_TAPCELL_ROW_11_514 VGND VPWR sky130_fd_sc_hd__tapvpwrvgnd_1
XFILLER_9_317 VGND VGND VPWR VPWR sky130_fd_sc_hd__fill_2
X_12401_ _06126_ _06127_ VGND VGND VPWR VPWR _06128_ sky130_fd_sc_hd__nor2_1
XFILLER_40_165 VGND VGND VPWR VPWR sky130_fd_sc_hd__decap_4
XPHY_EDGE_ROW_149_Left_305 VGND VGND VPWR VPWR sky130_fd_sc_hd__decap_3
XFILLER_139_576 VGND VGND VPWR VPWR sky130_fd_sc_hd__decap_3
XFILLER_139_565 VGND VGND VPWR VPWR sky130_fd_sc_hd__decap_4
X_13381_ clknet_leaf_42_clk _00391_ VGND VGND VPWR VPWR u_interface.fifo_data\[7\]\[26\]
+ sky130_fd_sc_hd__dfxtp_1
X_10593_ _04338_ _04339_ _04319_ VGND VGND VPWR VPWR _04340_ sky130_fd_sc_hd__a21o_1
XFILLER_139_587 VGND VGND VPWR VPWR sky130_fd_sc_hd__fill_1
XFILLER_31_51 VGND VGND VPWR VPWR sky130_fd_sc_hd__decap_4
X_12332_ _05931_ _05995_ _05996_ VGND VGND VPWR VPWR _06061_ sky130_fd_sc_hd__or3_1
XTAP_TAPCELL_ROW_153_2786 VGND VPWR sky130_fd_sc_hd__tapvpwrvgnd_1
XFILLER_126_237 VGND VGND VPWR VPWR sky130_fd_sc_hd__fill_1
XFILLER_107_440 VGND VGND VPWR VPWR sky130_fd_sc_hd__decap_3
X_12263_ net192 _05991_ VGND VGND VPWR VPWR _05993_ sky130_fd_sc_hd__nand2_1
X_14002_ clknet_leaf_64_clk _00928_ VGND VGND VPWR VPWR u_interface.u_gelu_fp32.u_q16_to_fp32.s3_norm_mag\[29\]
+ sky130_fd_sc_hd__dfxtp_1
X_11214_ _04952_ _04953_ _04954_ VGND VGND VPWR VPWR _04956_ sky130_fd_sc_hd__nand3_1
XFILLER_122_421 VGND VGND VPWR VPWR sky130_fd_sc_hd__fill_1
X_12194_ _05922_ _05923_ VGND VGND VPWR VPWR _05925_ sky130_fd_sc_hd__xnor2_1
X_11145_ _04885_ _04886_ VGND VGND VPWR VPWR _04888_ sky130_fd_sc_hd__xor2_1
X_11076_ _04701_ _04815_ _04817_ VGND VGND VPWR VPWR _04819_ sky130_fd_sc_hd__nand3b_1
XFILLER_49_722 VGND VGND VPWR VPWR sky130_fd_sc_hd__decap_6
XFILLER_95_349 VGND VGND VPWR VPWR sky130_fd_sc_hd__decap_8
X_10027_ _03777_ _03778_ _03758_ VGND VGND VPWR VPWR _03779_ sky130_fd_sc_hd__o21ai_1
XFILLER_49_766 VPWR VGND VPWR VGND sky130_ef_sc_hd__decap_12
XFILLER_64_714 VGND VGND VPWR VPWR sky130_fd_sc_hd__fill_1
XFILLER_48_276 VGND VGND VPWR VPWR sky130_fd_sc_hd__decap_3
Xclkbuf_leaf_28_clk clknet_3_3__leaf_clk VGND VGND VPWR VPWR clknet_leaf_28_clk sky130_fd_sc_hd__clkbuf_8
XFILLER_63_235 VGND VGND VPWR VPWR sky130_fd_sc_hd__decap_4
XFILLER_56_81 VGND VGND VPWR VPWR sky130_fd_sc_hd__decap_3
XFILLER_17_641 VPWR VGND VPWR VGND sky130_ef_sc_hd__decap_12
XTAP_TAPCELL_ROW_19_636 VGND VPWR sky130_fd_sc_hd__tapvpwrvgnd_1
XTAP_TAPCELL_ROW_19_647 VGND VPWR sky130_fd_sc_hd__tapvpwrvgnd_1
X_11978_ _05710_ _05711_ VGND VGND VPWR VPWR _05712_ sky130_fd_sc_hd__and2_1
X_13717_ clknet_leaf_8_clk _00727_ VGND VGND VPWR VPWR u_interface.u_gelu_fp32.s1_data\[17\]
+ sky130_fd_sc_hd__dfxtp_1
X_10929_ net196 _04661_ _04662_ VGND VGND VPWR VPWR _04673_ sky130_fd_sc_hd__o21ai_1
XFILLER_44_493 VGND VGND VPWR VPWR sky130_fd_sc_hd__decap_3
XFILLER_17_685 VPWR VGND VPWR VGND sky130_ef_sc_hd__decap_12
XFILLER_31_110 VGND VGND VPWR VPWR sky130_fd_sc_hd__fill_2
XFILLER_16_195 VGND VGND VPWR VPWR sky130_fd_sc_hd__fill_1
XTAP_TAPCELL_ROW_30_812 VGND VPWR sky130_fd_sc_hd__tapvpwrvgnd_1
XTAP_TAPCELL_ROW_30_823 VGND VPWR sky130_fd_sc_hd__tapvpwrvgnd_1
XFILLER_32_699 VGND VGND VPWR VPWR sky130_fd_sc_hd__fill_1
X_13648_ clknet_leaf_75_clk _00658_ VGND VGND VPWR VPWR u_interface.fifo_data\[13\]\[31\]
+ sky130_fd_sc_hd__dfxtp_1
X_13579_ clknet_leaf_40_clk _00589_ VGND VGND VPWR VPWR u_interface.fifo_data\[4\]\[26\]
+ sky130_fd_sc_hd__dfxtp_1
XFILLER_75_3 VPWR VGND VPWR VGND sky130_ef_sc_hd__decap_12
XFILLER_31_198 VPWR VGND VPWR VGND sky130_ef_sc_hd__decap_12
XFILLER_9_895 VGND VGND VPWR VPWR sky130_fd_sc_hd__fill_1
XFILLER_8_361 VGND VGND VPWR VPWR sky130_fd_sc_hd__decap_3
XFILLER_145_546 VPWR VGND VPWR VGND sky130_ef_sc_hd__decap_12
XFILLER_117_237 VGND VGND VPWR VPWR sky130_fd_sc_hd__fill_1
XTAP_TAPCELL_ROW_93_1822 VGND VPWR sky130_fd_sc_hd__tapvpwrvgnd_1
XPHY_EDGE_ROW_99_Right_99 VGND VGND VPWR VPWR sky130_fd_sc_hd__decap_3
Xfanout318 _01108_ VGND VGND VPWR VPWR net318 sky130_fd_sc_hd__buf_4
XFILLER_140_251 VGND VGND VPWR VPWR sky130_fd_sc_hd__fill_1
X_09810_ _03562_ _03563_ _03501_ _03503_ VGND VGND VPWR VPWR _03564_ sky130_fd_sc_hd__o211a_1
Xfanout307 _01115_ VGND VGND VPWR VPWR net307 sky130_fd_sc_hd__clkbuf_2
Xfanout329 u_interface.u_gelu_fp32.u_q16_to_fp32.s2_clz\[2\] VGND VGND VPWR VPWR net329
+ sky130_fd_sc_hd__clkbuf_2
XFILLER_141_796 VGND VGND VPWR VPWR sky130_fd_sc_hd__fill_1
XFILLER_141_785 VGND VGND VPWR VPWR sky130_fd_sc_hd__fill_2
X_09741_ _03494_ _03495_ _03389_ _03391_ VGND VGND VPWR VPWR _03496_ sky130_fd_sc_hd__o211ai_1
X_06953_ _01482_ VGND VGND VPWR VPWR _01483_ sky130_fd_sc_hd__inv_2
XFILLER_140_295 VGND VGND VPWR VPWR sky130_fd_sc_hd__decap_4
XTAP_TAPCELL_ROW_124_2321 VGND VPWR sky130_fd_sc_hd__tapvpwrvgnd_1
X_09672_ _03423_ _03426_ VGND VGND VPWR VPWR _03427_ sky130_fd_sc_hd__xnor2_1
X_06884_ _01423_ _01424_ _01427_ net316 VGND VGND VPWR VPWR net133 sky130_fd_sc_hd__a22o_1
XFILLER_28_917 VGND VGND VPWR VPWR sky130_fd_sc_hd__decap_4
Xclkbuf_leaf_19_clk clknet_3_3__leaf_clk VGND VGND VPWR VPWR clknet_leaf_19_clk sky130_fd_sc_hd__clkbuf_8
XFILLER_82_522 VGND VGND VPWR VPWR sky130_fd_sc_hd__decap_8
X_08623_ net153 _02397_ net799 VGND VGND VPWR VPWR _00792_ sky130_fd_sc_hd__a21oi_1
XFILLER_27_449 VPWR VGND VPWR VGND sky130_ef_sc_hd__decap_12
XFILLER_36_29 VPWR VGND VPWR VGND sky130_ef_sc_hd__decap_12
XTAP_TAPCELL_ROW_38_945 VGND VPWR sky130_fd_sc_hd__tapvpwrvgnd_1
XFILLER_82_566 VGND VGND VPWR VPWR sky130_fd_sc_hd__decap_8
X_08554_ _02165_ _02289_ VGND VGND VPWR VPWR _02345_ sky130_fd_sc_hd__xnor2_1
XFILLER_42_419 VGND VGND VPWR VPWR sky130_fd_sc_hd__fill_1
X_07505_ net815 net1577 net300 _01636_ VGND VGND VPWR VPWR _00434_ sky130_fd_sc_hd__a22o_1
XFILLER_23_600 VPWR VGND VPWR VGND sky130_ef_sc_hd__decap_12
XFILLER_35_493 VGND VGND VPWR VPWR sky130_fd_sc_hd__decap_8
XFILLER_22_121 VPWR VGND VPWR VGND sky130_ef_sc_hd__decap_12
X_08485_ net522 u_interface.u_gelu_fp32.u_synth_top.s3_mult\[47\] VGND VGND VPWR VPWR
+ _02276_ sky130_fd_sc_hd__xnor2_1
X_07436_ u_interface.u_gelu_fp32.u_fp32_to_q16.s2_norm_mag\[19\] u_interface.u_gelu_fp32.u_fp32_to_q16.s2_norm_mag\[20\]
+ net558 VGND VGND VPWR VPWR _01571_ sky130_fd_sc_hd__mux2_1
XTAP_TAPCELL_ROW_102_1973 VGND VPWR sky130_fd_sc_hd__tapvpwrvgnd_1
XTAP_TAPCELL_ROW_102_1962 VGND VPWR sky130_fd_sc_hd__tapvpwrvgnd_1
XFILLER_50_485 VGND VGND VPWR VPWR sky130_fd_sc_hd__fill_2
XFILLER_50_474 VGND VGND VPWR VPWR sky130_fd_sc_hd__fill_2
XFILLER_11_839 VGND VGND VPWR VPWR sky130_fd_sc_hd__fill_1
X_07367_ net1089 net384 net237 VGND VGND VPWR VPWR _00397_ sky130_fd_sc_hd__mux2_1
XFILLER_10_338 VPWR VGND VPWR VGND sky130_ef_sc_hd__decap_12
XFILLER_148_362 VGND VGND VPWR VPWR sky130_fd_sc_hd__fill_2
X_09106_ _02808_ _02819_ _02859_ _02862_ VGND VGND VPWR VPWR _02865_ sky130_fd_sc_hd__o211ai_2
XFILLER_6_309 VGND VGND VPWR VPWR sky130_fd_sc_hd__decap_8
X_09037_ _02791_ _02795_ VGND VGND VPWR VPWR _02796_ sky130_fd_sc_hd__and2_1
XFILLER_108_226 VPWR VGND VPWR VGND sky130_ef_sc_hd__decap_12
X_07298_ net1154 net570 net246 VGND VGND VPWR VPWR _00328_ sky130_fd_sc_hd__mux2_1
XFILLER_151_505 VGND VGND VPWR VPWR sky130_fd_sc_hd__decap_8
XTAP_TAPCELL_ROW_135_2494 VGND VPWR sky130_fd_sc_hd__tapvpwrvgnd_1
Xhold361 u_interface.fifo_data\[4\]\[14\] VGND VGND VPWR VPWR net1226 sky130_fd_sc_hd__dlygate4sd3_1
XFILLER_104_421 VGND VGND VPWR VPWR sky130_fd_sc_hd__fill_1
Xhold350 u_interface.fifo_data\[14\]\[18\] VGND VGND VPWR VPWR net1215 sky130_fd_sc_hd__dlygate4sd3_1
XFILLER_89_110 VGND VGND VPWR VPWR sky130_fd_sc_hd__fill_2
Xhold383 u_interface.fifo_data\[0\]\[29\] VGND VGND VPWR VPWR net1248 sky130_fd_sc_hd__dlygate4sd3_1
Xhold394 u_interface.fifo_data\[1\]\[4\] VGND VGND VPWR VPWR net1259 sky130_fd_sc_hd__dlygate4sd3_1
Xhold372 u_interface.fifo_data\[1\]\[3\] VGND VGND VPWR VPWR net1237 sky130_fd_sc_hd__dlygate4sd3_1
Xfanout830 net2 VGND VGND VPWR VPWR net830 sky130_fd_sc_hd__clkbuf_4
XFILLER_104_487 VGND VGND VPWR VPWR sky130_fd_sc_hd__decap_4
XFILLER_77_69 VGND VGND VPWR VPWR sky130_fd_sc_hd__decap_6
XFILLER_133_31 VGND VGND VPWR VPWR sky130_fd_sc_hd__decap_6
X_09939_ _03688_ _03691_ VGND VGND VPWR VPWR _03692_ sky130_fd_sc_hd__xnor2_1
X_12950_ u_interface.fifo_count\[1\] _01100_ net1 VGND VGND VPWR VPWR _06471_ sky130_fd_sc_hd__and3_1
X_12881_ net787 net917 VGND VGND VPWR VPWR _01023_ sky130_fd_sc_hd__and2_1
XFILLER_93_57 VGND VGND VPWR VPWR sky130_fd_sc_hd__decap_6
XFILLER_85_393 VPWR VGND VPWR VGND sky130_ef_sc_hd__decap_12
X_11901_ net194 _05635_ VGND VGND VPWR VPWR _05636_ sky130_fd_sc_hd__or2_1
XFILLER_45_246 VGND VGND VPWR VPWR sky130_fd_sc_hd__decap_4
X_11832_ net179 _05495_ _05498_ VGND VGND VPWR VPWR _05567_ sky130_fd_sc_hd__nor3_1
XFILLER_60_227 VGND VGND VPWR VPWR sky130_fd_sc_hd__decap_3
XFILLER_60_205 VGND VGND VPWR VPWR sky130_fd_sc_hd__decap_3
X_11763_ _05497_ _05498_ VGND VGND VPWR VPWR _05499_ sky130_fd_sc_hd__nor2_1
XTAP_TAPCELL_ROW_155_2826 VGND VPWR sky130_fd_sc_hd__tapvpwrvgnd_1
XTAP_TAPCELL_ROW_155_2815 VGND VPWR sky130_fd_sc_hd__tapvpwrvgnd_1
X_13502_ clknet_leaf_4_clk _00512_ VGND VGND VPWR VPWR u_interface.u_gelu_fp32.u_synth_top.s2_m\[9\]
+ sky130_fd_sc_hd__dfxtp_2
X_10714_ _04335_ _04337_ _04456_ _04457_ VGND VGND VPWR VPWR _04460_ sky130_fd_sc_hd__a211o_1
XFILLER_9_125 VPWR VGND VPWR VGND sky130_ef_sc_hd__decap_12
XFILLER_14_699 VGND VGND VPWR VPWR sky130_fd_sc_hd__fill_1
X_11694_ net693 net415 net410 net685 VGND VGND VPWR VPWR _05431_ sky130_fd_sc_hd__a22o_1
XTAP_TAPCELL_ROW_155_2837 VGND VPWR sky130_fd_sc_hd__tapvpwrvgnd_1
X_13433_ clknet_leaf_18_clk _00443_ VGND VGND VPWR VPWR u_interface.u_gelu_fp32.u_fp32_to_q16.s3_mag\[4\]
+ sky130_fd_sc_hd__dfxtp_1
X_10645_ _04373_ _04389_ _04390_ VGND VGND VPWR VPWR _04392_ sky130_fd_sc_hd__nand3_4
XFILLER_155_811 VGND VGND VPWR VPWR sky130_fd_sc_hd__fill_1
X_13364_ clknet_leaf_83_clk _00374_ VGND VGND VPWR VPWR u_interface.fifo_data\[7\]\[9\]
+ sky130_fd_sc_hd__dfxtp_1
XFILLER_10_861 VGND VGND VPWR VPWR sky130_fd_sc_hd__decap_6
XFILLER_9_169 VPWR VGND VPWR VGND sky130_ef_sc_hd__decap_12
XFILLER_42_94 VGND VGND VPWR VPWR sky130_fd_sc_hd__fill_2
X_10576_ net482 net722 _04224_ _04109_ VGND VGND VPWR VPWR _04323_ sky130_fd_sc_hd__a31o_1
X_12315_ _06042_ _06043_ VGND VGND VPWR VPWR _06044_ sky130_fd_sc_hd__or2_1
XFILLER_142_527 VGND VGND VPWR VPWR sky130_fd_sc_hd__decap_4
X_13295_ clknet_leaf_67_clk _00305_ VGND VGND VPWR VPWR u_interface.fifo_data\[8\]\[4\]
+ sky130_fd_sc_hd__dfxtp_1
XTAP_TAPCELL_ROW_75_1530 VGND VPWR sky130_fd_sc_hd__tapvpwrvgnd_1
XFILLER_154_387 VGND VGND VPWR VPWR sky130_fd_sc_hd__decap_3
XFILLER_107_281 VPWR VGND VPWR VGND sky130_ef_sc_hd__decap_12
XTAP_TAPCELL_ROW_75_1541 VGND VPWR sky130_fd_sc_hd__tapvpwrvgnd_1
XFILLER_5_375 VGND VGND VPWR VPWR sky130_fd_sc_hd__decap_8
X_12246_ _05952_ _05975_ VGND VGND VPWR VPWR _05976_ sky130_fd_sc_hd__xnor2_1
X_12177_ _05907_ _05906_ VGND VGND VPWR VPWR _05908_ sky130_fd_sc_hd__nand2b_1
XFILLER_110_413 VGND VGND VPWR VPWR sky130_fd_sc_hd__decap_6
XFILLER_95_113 VGND VGND VPWR VPWR sky130_fd_sc_hd__decap_3
X_11128_ net595 net392 VGND VGND VPWR VPWR _04871_ sky130_fd_sc_hd__nand2_1
XFILLER_3_55 VGND VGND VPWR VPWR sky130_fd_sc_hd__fill_1
XFILLER_96_669 VGND VGND VPWR VPWR sky130_fd_sc_hd__decap_8
XFILLER_77_894 VGND VGND VPWR VPWR sky130_fd_sc_hd__fill_2
X_11059_ _04226_ _04697_ _04685_ VGND VGND VPWR VPWR _04802_ sky130_fd_sc_hd__a21o_1
XFILLER_49_585 VGND VGND VPWR VPWR sky130_fd_sc_hd__decap_8
XFILLER_91_352 VGND VGND VPWR VPWR sky130_fd_sc_hd__fill_2
XFILLER_52_717 VGND VGND VPWR VPWR sky130_fd_sc_hd__decap_4
XFILLER_25_909 VPWR VGND VPWR VGND sky130_ef_sc_hd__decap_12
XFILLER_45_791 VGND VGND VPWR VPWR sky130_fd_sc_hd__decap_6
XFILLER_17_493 VGND VGND VPWR VPWR sky130_fd_sc_hd__fill_2
X_08270_ _02084_ _02085_ VGND VGND VPWR VPWR _00751_ sky130_fd_sc_hd__nor2_1
XFILLER_60_783 VGND VGND VPWR VPWR sky130_fd_sc_hd__decap_3
XFILLER_20_625 VPWR VGND VPWR VGND sky130_ef_sc_hd__decap_12
X_07221_ net565 net1548 net259 VGND VGND VPWR VPWR _00261_ sky130_fd_sc_hd__mux2_1
X_07152_ net1019 net576 net219 VGND VGND VPWR VPWR _00192_ sky130_fd_sc_hd__mux2_1
XFILLER_20_669 VPWR VGND VPWR VGND sky130_ef_sc_hd__decap_12
XFILLER_145_332 VGND VGND VPWR VPWR sky130_fd_sc_hd__decap_4
Xclkbuf_leaf_8_clk clknet_3_2__leaf_clk VGND VGND VPWR VPWR clknet_leaf_8_clk sky130_fd_sc_hd__clkbuf_8
X_07083_ net1213 net381 net225 VGND VGND VPWR VPWR _00123_ sky130_fd_sc_hd__mux2_1
XFILLER_145_387 VGND VGND VPWR VPWR sky130_fd_sc_hd__fill_1
XFILLER_133_549 VGND VGND VPWR VPWR sky130_fd_sc_hd__fill_1
XFILLER_87_614 VGND VGND VPWR VPWR sky130_fd_sc_hd__fill_2
X_07985_ net774 net979 _01854_ VGND VGND VPWR VPWR _00697_ sky130_fd_sc_hd__o21a_1
XFILLER_86_124 VPWR VGND VPWR VGND sky130_ef_sc_hd__decap_12
Xfanout159 _02359_ VGND VGND VPWR VPWR net159 sky130_fd_sc_hd__buf_2
X_09724_ _03478_ _03470_ VGND VGND VPWR VPWR _03479_ sky130_fd_sc_hd__nand2b_1
X_06936_ u_interface.u_gelu_fp32.u_synth_top.s1_x\[22\] u_interface.u_gelu_fp32.u_synth_top.s1_x\[23\]
+ net273 VGND VGND VPWR VPWR _01470_ sky130_fd_sc_hd__o21ai_1
XFILLER_28_725 VPWR VGND VPWR VGND sky130_ef_sc_hd__decap_12
X_06867_ _01411_ _01412_ net733 VGND VGND VPWR VPWR _01413_ sky130_fd_sc_hd__mux2_1
X_09655_ _03409_ _03410_ _03310_ _03313_ VGND VGND VPWR VPWR _03411_ sky130_fd_sc_hd__o211a_1
XFILLER_67_393 VGND VGND VPWR VPWR sky130_fd_sc_hd__fill_2
XFILLER_82_363 VGND VGND VPWR VPWR sky130_fd_sc_hd__fill_1
X_08606_ net158 _02385_ VGND VGND VPWR VPWR _02386_ sky130_fd_sc_hd__nand2_1
XFILLER_55_577 VGND VGND VPWR VPWR sky130_fd_sc_hd__fill_2
XTAP_TAPCELL_ROW_2_367 VGND VPWR sky130_fd_sc_hd__tapvpwrvgnd_1
XFILLER_28_769 VPWR VGND VPWR VGND sky130_ef_sc_hd__decap_12
X_09586_ _03337_ _03338_ _03339_ VGND VGND VPWR VPWR _03342_ sky130_fd_sc_hd__and3_1
XFILLER_63_27 VGND VGND VPWR VPWR sky130_fd_sc_hd__decap_8
X_06798_ net730 _01351_ VGND VGND VPWR VPWR _01352_ sky130_fd_sc_hd__or2_1
X_08537_ _02156_ _02327_ VGND VGND VPWR VPWR _02328_ sky130_fd_sc_hd__xnor2_1
XFILLER_144_6 VGND VGND VPWR VPWR sky130_fd_sc_hd__fill_1
XFILLER_51_783 VGND VGND VPWR VPWR sky130_fd_sc_hd__fill_1
X_08468_ net526 u_interface.u_gelu_fp32.u_synth_top.s3_mult\[38\] VGND VGND VPWR VPWR
+ _02259_ sky130_fd_sc_hd__nand2_1
XTAP_TAPCELL_ROW_42_1006 VGND VPWR sky130_fd_sc_hd__tapvpwrvgnd_1
X_07419_ _01554_ VGND VGND VPWR VPWR _01555_ sky130_fd_sc_hd__inv_2
XTAP_TAPCELL_ROW_137_2534 VGND VPWR sky130_fd_sc_hd__tapvpwrvgnd_1
XTAP_TAPCELL_ROW_137_2523 VGND VPWR sky130_fd_sc_hd__tapvpwrvgnd_1
XFILLER_51_794 VGND VGND VPWR VPWR sky130_fd_sc_hd__decap_4
X_08399_ u_interface.u_gelu_fp32.u_synth_top.s3_mult\[26\] u_interface.u_gelu_fp32.u_synth_top.s3_b\[10\]
+ VGND VGND VPWR VPWR _02190_ sky130_fd_sc_hd__or2_1
X_10430_ _04177_ _04178_ _04062_ _04064_ VGND VGND VPWR VPWR _04179_ sky130_fd_sc_hd__a211oi_2
XFILLER_7_629 VPWR VGND VPWR VGND sky130_ef_sc_hd__decap_12
XTAP_TAPCELL_ROW_21_664 VGND VPWR sky130_fd_sc_hd__tapvpwrvgnd_1
XFILLER_109_546 VPWR VGND VPWR VGND sky130_ef_sc_hd__decap_12
XFILLER_6_139 VGND VGND VPWR VPWR sky130_fd_sc_hd__fill_1
XFILLER_12_53 VPWR VGND VPWR VGND sky130_ef_sc_hd__decap_12
XTAP_TAPCELL_ROW_21_675 VGND VPWR sky130_fd_sc_hd__tapvpwrvgnd_1
XTAP_TAPCELL_ROW_150_2734 VGND VPWR sky130_fd_sc_hd__tapvpwrvgnd_1
XFILLER_136_365 VPWR VGND VPWR VGND sky130_ef_sc_hd__decap_12
X_10361_ net715 _04109_ _04108_ VGND VGND VPWR VPWR _04110_ sky130_fd_sc_hd__a21bo_1
XFILLER_12_97 VPWR VGND VPWR VGND sky130_ef_sc_hd__decap_12
X_13080_ clknet_leaf_53_clk _00090_ VGND VGND VPWR VPWR u_interface.fifo_data\[15\]\[1\]
+ sky130_fd_sc_hd__dfxtp_1
X_10292_ _04040_ _04041_ VGND VGND VPWR VPWR _04042_ sky130_fd_sc_hd__or2_1
X_12100_ _05829_ _05830_ VGND VGND VPWR VPWR _05832_ sky130_fd_sc_hd__xnor2_1
XFILLER_2_301 VGND VGND VPWR VPWR sky130_fd_sc_hd__decap_6
Xhold180 u_interface.fifo_data\[0\]\[8\] VGND VGND VPWR VPWR net1045 sky130_fd_sc_hd__dlygate4sd3_1
XFILLER_5_3 VPWR VGND VPWR VGND sky130_ef_sc_hd__decap_12
XFILLER_2_345 VPWR VGND VPWR VGND sky130_ef_sc_hd__decap_12
X_12031_ _05761_ _05762_ VGND VGND VPWR VPWR _05764_ sky130_fd_sc_hd__xor2_1
XFILLER_151_379 VPWR VGND VPWR VGND sky130_ef_sc_hd__decap_12
XFILLER_77_113 VPWR VGND VPWR VGND sky130_ef_sc_hd__decap_12
Xhold191 u_interface.fifo_data\[9\]\[0\] VGND VGND VPWR VPWR net1056 sky130_fd_sc_hd__dlygate4sd3_1
XFILLER_2_389 VPWR VGND VPWR VGND sky130_ef_sc_hd__decap_12
XFILLER_132_593 VGND VGND VPWR VPWR sky130_fd_sc_hd__decap_3
Xfanout660 net661 VGND VGND VPWR VPWR net660 sky130_fd_sc_hd__buf_2
XTAP_TAPCELL_ROW_70_1460 VGND VPWR sky130_fd_sc_hd__tapvpwrvgnd_1
XTAP_TAPCELL_ROW_53_1179 VGND VPWR sky130_fd_sc_hd__tapvpwrvgnd_1
XTAP_TAPCELL_ROW_148_2696 VGND VPWR sky130_fd_sc_hd__tapvpwrvgnd_1
XFILLER_144_85 VGND VGND VPWR VPWR sky130_fd_sc_hd__decap_8
Xfanout671 net672 VGND VGND VPWR VPWR net671 sky130_fd_sc_hd__buf_2
Xfanout682 net683 VGND VGND VPWR VPWR net682 sky130_fd_sc_hd__buf_2
X_13982_ clknet_leaf_83_clk net1721 VGND VGND VPWR VPWR u_interface.u_gelu_fp32.u_q16_to_fp32.s2_mag\[27\]
+ sky130_fd_sc_hd__dfxtp_1
Xfanout693 net700 VGND VGND VPWR VPWR net693 sky130_fd_sc_hd__clkbuf_2
X_12933_ u_interface.in_flight_count\[3\] _06441_ _06457_ net788 VGND VGND VPWR VPWR
+ _01056_ sky130_fd_sc_hd__o211a_1
XFILLER_92_149 VGND VGND VPWR VPWR sky130_fd_sc_hd__fill_1
XFILLER_86_680 VGND VGND VPWR VPWR sky130_fd_sc_hd__decap_4
XFILLER_74_864 VGND VGND VPWR VPWR sky130_fd_sc_hd__decap_4
X_12864_ net1455 u_interface.u_gelu_fp32.u_fp32_to_q16.s2_norm_mag\[19\] net819 VGND
+ VGND VPWR VPWR _01008_ sky130_fd_sc_hd__mux2_1
XTAP_TAPCELL_ROW_29_797 VGND VPWR sky130_fd_sc_hd__tapvpwrvgnd_1
XFILLER_33_216 VGND VGND VPWR VPWR sky130_fd_sc_hd__decap_8
X_12795_ u_interface.u_gelu_fp32.u_q16_to_fp32.s3_norm_mag\[26\] _01787_ net294 VGND
+ VGND VPWR VPWR _06414_ sky130_fd_sc_hd__o21ai_1
X_11815_ _05548_ _05549_ VGND VGND VPWR VPWR _05551_ sky130_fd_sc_hd__xnor2_1
X_11746_ _05307_ _05397_ VGND VGND VPWR VPWR _05483_ sky130_fd_sc_hd__and2_1
XFILLER_128_811 VGND VGND VPWR VPWR sky130_fd_sc_hd__fill_1
X_11677_ _05346_ _05354_ _05355_ VGND VGND VPWR VPWR _05414_ sky130_fd_sc_hd__a21o_1
XTAP_TAPCELL_ROW_40_973 VGND VPWR sky130_fd_sc_hd__tapvpwrvgnd_1
XFILLER_127_321 VGND VGND VPWR VPWR sky130_fd_sc_hd__fill_1
X_13416_ clknet_leaf_44_clk _00426_ VGND VGND VPWR VPWR u_interface.fifo_data\[6\]\[29\]
+ sky130_fd_sc_hd__dfxtp_1
X_10628_ net652 net660 net445 net440 VGND VGND VPWR VPWR _04375_ sky130_fd_sc_hd__and4_1
XFILLER_155_685 VGND VGND VPWR VPWR sky130_fd_sc_hd__decap_4
XFILLER_143_814 VPWR VGND VPWR VGND sky130_ef_sc_hd__decap_12
XFILLER_127_365 VPWR VGND VPWR VGND sky130_ef_sc_hd__decap_12
XFILLER_127_343 VGND VGND VPWR VPWR sky130_fd_sc_hd__fill_1
XFILLER_115_505 VGND VGND VPWR VPWR sky130_fd_sc_hd__fill_2
X_13347_ clknet_leaf_47_clk _00357_ VGND VGND VPWR VPWR u_interface.fifo_data\[10\]\[24\]
+ sky130_fd_sc_hd__dfxtp_1
X_10559_ _04305_ _04306_ _04103_ _04106_ VGND VGND VPWR VPWR _04307_ sky130_fd_sc_hd__o211a_1
X_13278_ clknet_leaf_69_clk _00288_ VGND VGND VPWR VPWR u_interface.fifo_data\[0\]\[20\]
+ sky130_fd_sc_hd__dfxtp_1
XFILLER_5_161 VGND VGND VPWR VPWR sky130_fd_sc_hd__decap_6
X_12229_ net693 net388 VGND VGND VPWR VPWR _05959_ sky130_fd_sc_hd__and2b_1
XFILLER_111_722 VGND VGND VPWR VPWR sky130_fd_sc_hd__decap_6
XFILLER_96_400 VGND VGND VPWR VPWR sky130_fd_sc_hd__decap_3
XFILLER_38_3 VPWR VGND VPWR VGND sky130_ef_sc_hd__decap_12
XFILLER_96_455 VGND VGND VPWR VPWR sky130_fd_sc_hd__decap_8
XFILLER_96_433 VGND VGND VPWR VPWR sky130_fd_sc_hd__decap_3
X_07770_ net1098 net384 net233 VGND VGND VPWR VPWR _00531_ sky130_fd_sc_hd__mux2_1
XFILLER_110_287 VPWR VGND VPWR VGND sky130_ef_sc_hd__decap_12
X_06721_ u_interface.fifo_data\[0\]\[11\] u_interface.fifo_data\[1\]\[11\] u_interface.fifo_data\[2\]\[11\]
+ u_interface.fifo_data\[3\]\[11\] net763 net746 VGND VGND VPWR VPWR _01285_ sky130_fd_sc_hd__mux4_1
XTAP_TAPCELL_ROW_88_1743 VGND VPWR sky130_fd_sc_hd__tapvpwrvgnd_1
XFILLER_49_393 VPWR VGND VPWR VGND sky130_ef_sc_hd__decap_12
X_09440_ _03196_ _03197_ _03187_ VGND VGND VPWR VPWR _03198_ sky130_fd_sc_hd__a21oi_1
XFILLER_64_330 VGND VGND VPWR VPWR sky130_fd_sc_hd__fill_1
XFILLER_92_683 VGND VGND VPWR VPWR sky130_fd_sc_hd__decap_6
XFILLER_80_845 VGND VGND VPWR VPWR sky130_fd_sc_hd__fill_1
XFILLER_64_363 VGND VGND VPWR VPWR sky130_fd_sc_hd__fill_1
XFILLER_52_525 VGND VGND VPWR VPWR sky130_fd_sc_hd__decap_6
XFILLER_52_514 VGND VGND VPWR VPWR sky130_fd_sc_hd__fill_2
X_06652_ _01219_ _01221_ _01224_ net316 VGND VGND VPWR VPWR net131 sky130_fd_sc_hd__a22o_1
XFILLER_24_205 VGND VGND VPWR VPWR sky130_fd_sc_hd__fill_1
XFILLER_24_227 VGND VGND VPWR VPWR sky130_fd_sc_hd__decap_4
X_09371_ _03000_ _03127_ _03128_ _03129_ VGND VGND VPWR VPWR _03130_ sky130_fd_sc_hd__or4b_2
X_06583_ u_interface.u_gelu_fp32.s1_data\[24\] _01169_ _01170_ VGND VGND VPWR VPWR
+ _01171_ sky130_fd_sc_hd__and3_1
XFILLER_80_867 VGND VGND VPWR VPWR sky130_fd_sc_hd__fill_1
X_08322_ _02123_ _02124_ VGND VGND VPWR VPWR _00764_ sky130_fd_sc_hd__nor2_1
XFILLER_33_783 VGND VGND VPWR VPWR sky130_fd_sc_hd__fill_1
X_08253_ net1618 _02072_ _02073_ VGND VGND VPWR VPWR _00746_ sky130_fd_sc_hd__a21oi_1
XTAP_TAPCELL_ROW_119_2242 VGND VPWR sky130_fd_sc_hd__tapvpwrvgnd_1
X_07204_ net361 net1493 net258 VGND VGND VPWR VPWR _00244_ sky130_fd_sc_hd__mux2_1
XFILLER_146_630 VGND VGND VPWR VPWR sky130_fd_sc_hd__decap_4
X_08184_ _01888_ _02018_ VGND VGND VPWR VPWR _02019_ sky130_fd_sc_hd__nand2b_1
X_07135_ net1336 net371 net219 VGND VGND VPWR VPWR _00175_ sky130_fd_sc_hd__mux2_1
XFILLER_118_365 VPWR VGND VPWR VGND sky130_ef_sc_hd__decap_12
XFILLER_118_343 VGND VGND VPWR VPWR sky130_fd_sc_hd__decap_4
XFILLER_146_696 VGND VGND VPWR VPWR sky130_fd_sc_hd__fill_1
XTAP_TAPCELL_ROW_132_2453 VGND VPWR sky130_fd_sc_hd__tapvpwrvgnd_1
XFILLER_133_302 VPWR VGND VPWR VGND sky130_ef_sc_hd__decap_12
XTAP_TAPCELL_ROW_132_2442 VGND VPWR sky130_fd_sc_hd__tapvpwrvgnd_1
X_07066_ net1167 net351 net210 VGND VGND VPWR VPWR _00106_ sky130_fd_sc_hd__mux2_1
XFILLER_0_805 VGND VGND VPWR VPWR sky130_fd_sc_hd__decap_3
XTAP_TAPCELL_ROW_7_448 VGND VPWR sky130_fd_sc_hd__tapvpwrvgnd_1
XFILLER_59_113 VGND VGND VPWR VPWR sky130_fd_sc_hd__fill_1
XFILLER_48_809 VGND VGND VPWR VPWR sky130_fd_sc_hd__decap_3
X_07968_ net549 _01655_ net279 _01682_ net543 VGND VGND VPWR VPWR _01846_ sky130_fd_sc_hd__a32o_1
XFILLER_114_33 VGND VGND VPWR VPWR sky130_fd_sc_hd__fill_1
XFILLER_74_105 VGND VGND VPWR VPWR sky130_fd_sc_hd__fill_1
XFILLER_59_157 VGND VGND VPWR VPWR sky130_fd_sc_hd__decap_8
XFILLER_47_319 VGND VGND VPWR VPWR sky130_fd_sc_hd__decap_4
XFILLER_47_308 VGND VGND VPWR VPWR sky130_fd_sc_hd__decap_4
XPHY_EDGE_ROW_113_Left_269 VGND VGND VPWR VPWR sky130_fd_sc_hd__decap_3
X_09707_ _03355_ _03358_ _03459_ _03460_ VGND VGND VPWR VPWR _03462_ sky130_fd_sc_hd__a211o_1
X_06919_ _01455_ _01456_ VGND VGND VPWR VPWR _00037_ sky130_fd_sc_hd__nor2_1
XFILLER_74_15 VPWR VGND VPWR VGND sky130_ef_sc_hd__decap_12
XFILLER_28_533 VGND VGND VPWR VPWR sky130_fd_sc_hd__decap_8
X_07899_ net788 net910 VGND VGND VPWR VPWR _00660_ sky130_fd_sc_hd__and2_1
XFILLER_56_853 VPWR VGND VPWR VGND sky130_ef_sc_hd__decap_12
XFILLER_55_341 VGND VGND VPWR VPWR sky130_fd_sc_hd__decap_6
X_09638_ _03392_ _03393_ _03252_ _03254_ VGND VGND VPWR VPWR _03394_ sky130_fd_sc_hd__o211a_1
XFILLER_43_514 VPWR VGND VPWR VGND sky130_ef_sc_hd__decap_12
X_09569_ net585 net589 net447 net442 VGND VGND VPWR VPWR _03325_ sky130_fd_sc_hd__and4_1
XFILLER_82_193 VGND VGND VPWR VPWR sky130_fd_sc_hd__decap_3
XFILLER_70_333 VGND VGND VPWR VPWR sky130_fd_sc_hd__decap_8
XFILLER_15_238 VPWR VGND VPWR VGND sky130_ef_sc_hd__decap_12
XTAP_TAPCELL_ROW_26_745 VGND VPWR sky130_fd_sc_hd__tapvpwrvgnd_1
XTAP_TAPCELL_ROW_26_756 VGND VPWR sky130_fd_sc_hd__tapvpwrvgnd_1
XFILLER_31_709 VPWR VGND VPWR VGND sky130_ef_sc_hd__decap_12
X_12580_ net3 net28 net25 net30 VGND VGND VPWR VPWR _06284_ sky130_fd_sc_hd__or4_1
X_11600_ _05334_ _05335_ _05336_ VGND VGND VPWR VPWR _05338_ sky130_fd_sc_hd__a21oi_1
XFILLER_142_3 VGND VGND VPWR VPWR sky130_fd_sc_hd__fill_1
XFILLER_8_905 VPWR VGND VPWR VGND sky130_ef_sc_hd__decap_12
X_11531_ _05266_ _05269_ VGND VGND VPWR VPWR _05270_ sky130_fd_sc_hd__xnor2_2
XFILLER_11_444 VGND VGND VPWR VPWR sky130_fd_sc_hd__decap_4
XPHY_EDGE_ROW_122_Left_278 VGND VGND VPWR VPWR sky130_fd_sc_hd__decap_3
X_11462_ _05199_ _05200_ VGND VGND VPWR VPWR _05202_ sky130_fd_sc_hd__xnor2_1
X_13201_ clknet_leaf_44_clk _00211_ VGND VGND VPWR VPWR u_interface.fifo_data\[12\]\[11\]
+ sky130_fd_sc_hd__dfxtp_1
X_10413_ _04160_ _04161_ _04159_ VGND VGND VPWR VPWR _04162_ sky130_fd_sc_hd__a21o_1
X_11393_ _04934_ _05131_ VGND VGND VPWR VPWR _05133_ sky130_fd_sc_hd__nor2_1
XFILLER_125_825 VGND VGND VPWR VPWR sky130_fd_sc_hd__decap_6
X_10344_ _03979_ _04090_ _04091_ VGND VGND VPWR VPWR _04093_ sky130_fd_sc_hd__nand3_1
X_13132_ clknet_leaf_83_clk _00142_ VGND VGND VPWR VPWR u_interface.fifo_data\[2\]\[21\]
+ sky130_fd_sc_hd__dfxtp_1
XFILLER_155_51 VGND VGND VPWR VPWR sky130_fd_sc_hd__fill_1
XTAP_TAPCELL_ROW_55_1219 VGND VPWR sky130_fd_sc_hd__tapvpwrvgnd_1
XTAP_TAPCELL_ROW_55_1208 VGND VPWR sky130_fd_sc_hd__tapvpwrvgnd_1
XFILLER_155_62 VGND VGND VPWR VPWR sky130_fd_sc_hd__decap_4
X_13063_ clknet_leaf_32_clk _00073_ VGND VGND VPWR VPWR u_interface.fifo_data\[14\]\[16\]
+ sky130_fd_sc_hd__dfxtp_1
XFILLER_97_208 VGND VGND VPWR VPWR sky130_fd_sc_hd__fill_2
X_10275_ _04016_ _04022_ _04023_ VGND VGND VPWR VPWR _04025_ sky130_fd_sc_hd__nand3_1
XFILLER_3_665 VGND VGND VPWR VPWR sky130_fd_sc_hd__decap_6
XFILLER_2_153 VPWR VGND VPWR VGND sky130_ef_sc_hd__decap_12
XFILLER_120_530 VGND VGND VPWR VPWR sky130_fd_sc_hd__fill_2
XFILLER_78_433 VPWR VGND VPWR VGND sky130_ef_sc_hd__decap_12
XFILLER_2_197 VPWR VGND VPWR VGND sky130_ef_sc_hd__decap_12
X_12014_ _05741_ _05745_ VGND VGND VPWR VPWR _05747_ sky130_fd_sc_hd__xor2_1
XPHY_EDGE_ROW_131_Left_287 VGND VGND VPWR VPWR sky130_fd_sc_hd__decap_3
Xfanout490 u_interface.u_gelu_fp32.u_synth_top.s2_dx\[7\] VGND VGND VPWR VPWR net490
+ sky130_fd_sc_hd__clkbuf_2
XFILLER_19_522 VGND VGND VPWR VPWR sky130_fd_sc_hd__fill_1
X_13965_ clknet_leaf_59_clk net1664 VGND VGND VPWR VPWR u_interface.u_gelu_fp32.u_q16_to_fp32.s2_mag\[10\]
+ sky130_fd_sc_hd__dfxtp_1
XFILLER_58_190 VGND VGND VPWR VPWR sky130_fd_sc_hd__decap_6
X_12916_ u_interface.in_flight_count\[1\] _06438_ VGND VGND VPWR VPWR _06443_ sky130_fd_sc_hd__or2_1
X_13896_ clknet_leaf_19_clk net881 VGND VGND VPWR VPWR u_interface.u_gelu_fp32.u_synth_top.s1_x\[0\]
+ sky130_fd_sc_hd__dfxtp_1
XFILLER_73_160 VGND VGND VPWR VPWR sky130_fd_sc_hd__fill_1
XFILLER_46_363 VGND VGND VPWR VPWR sky130_fd_sc_hd__fill_1
X_12847_ _06425_ _06426_ _06427_ _06428_ VGND VGND VPWR VPWR _06429_ sky130_fd_sc_hd__or4_1
XFILLER_61_333 VGND VGND VPWR VPWR sky130_fd_sc_hd__decap_3
XTAP_TAPCELL_ROW_83_1662 VGND VPWR sky130_fd_sc_hd__tapvpwrvgnd_1
XFILLER_62_878 VGND VGND VPWR VPWR sky130_fd_sc_hd__fill_2
XFILLER_21_219 VGND VGND VPWR VPWR sky130_fd_sc_hd__decap_4
X_12778_ net1742 _01781_ _06405_ VGND VGND VPWR VPWR _00949_ sky130_fd_sc_hd__a21oi_1
XFILLER_15_783 VGND VGND VPWR VPWR sky130_fd_sc_hd__fill_1
XPHY_EDGE_ROW_140_Left_296 VGND VGND VPWR VPWR sky130_fd_sc_hd__decap_3
XFILLER_14_293 VPWR VGND VPWR VGND sky130_ef_sc_hd__decap_12
X_11729_ _05464_ _05465_ VGND VGND VPWR VPWR _05466_ sky130_fd_sc_hd__nand2_1
XFILLER_147_449 VPWR VGND VPWR VGND sky130_ef_sc_hd__decap_12
XFILLER_128_641 VGND VGND VPWR VPWR sky130_fd_sc_hd__decap_3
XFILLER_128_630 VGND VGND VPWR VPWR sky130_fd_sc_hd__fill_2
XFILLER_155_482 VGND VGND VPWR VPWR sky130_fd_sc_hd__decap_4
Xhold916 u_interface.u_gelu_fp32.u_fp32_to_q16.s3_frac\[9\] VGND VGND VPWR VPWR net1781
+ sky130_fd_sc_hd__dlygate4sd3_1
Xhold905 u_interface.u_gelu_fp32.u_fp32_to_q16.s3_mag\[15\] VGND VGND VPWR VPWR net1770
+ sky130_fd_sc_hd__dlygate4sd3_1
XFILLER_131_817 VGND VGND VPWR VPWR sky130_fd_sc_hd__decap_6
XFILLER_116_869 VGND VGND VPWR VPWR sky130_fd_sc_hd__decap_3
XFILLER_115_357 VGND VGND VPWR VPWR sky130_fd_sc_hd__decap_8
XTAP_TAPCELL_ROW_114_2161 VGND VPWR sky130_fd_sc_hd__tapvpwrvgnd_1
X_08940_ _02625_ _02696_ _02697_ VGND VGND VPWR VPWR _02699_ sky130_fd_sc_hd__and3_1
XFILLER_69_411 VGND VGND VPWR VPWR sky130_fd_sc_hd__fill_1
X_08871_ net462 net599 VGND VGND VPWR VPWR _02630_ sky130_fd_sc_hd__nand2_1
XFILLER_97_764 VGND VGND VPWR VPWR sky130_fd_sc_hd__decap_6
X_07822_ net1475 net344 net229 VGND VGND VPWR VPWR _00583_ sky130_fd_sc_hd__mux2_1
XFILLER_57_628 VGND VGND VPWR VPWR sky130_fd_sc_hd__decap_6
XFILLER_57_617 VGND VGND VPWR VPWR sky130_fd_sc_hd__fill_2
XTAP_TAPCELL_ROW_4_407 VGND VPWR sky130_fd_sc_hd__tapvpwrvgnd_1
X_07753_ _01794_ _01795_ VGND VGND VPWR VPWR _00523_ sky130_fd_sc_hd__nor2_1
XFILLER_84_469 VGND VGND VPWR VPWR sky130_fd_sc_hd__decap_6
X_07684_ u_interface.u_gelu_fp32.u_synth_top.s1_hits\[18\] _01186_ VGND VGND VPWR
+ VPWR _01758_ sky130_fd_sc_hd__or2_1
X_06704_ net320 _01269_ net725 VGND VGND VPWR VPWR _01270_ sky130_fd_sc_hd__o21a_1
XFILLER_25_503 VGND VGND VPWR VPWR sky130_fd_sc_hd__fill_1
XFILLER_38_897 VGND VGND VPWR VPWR sky130_fd_sc_hd__decap_4
X_09423_ _03180_ _03179_ VGND VGND VPWR VPWR _03181_ sky130_fd_sc_hd__and2b_1
XFILLER_64_193 VGND VGND VPWR VPWR sky130_fd_sc_hd__decap_3
X_06635_ _01208_ _01209_ net730 VGND VGND VPWR VPWR _01210_ sky130_fd_sc_hd__mux2_1
XFILLER_52_322 VPWR VGND VPWR VGND sky130_ef_sc_hd__decap_12
X_09354_ _02980_ _02981_ VGND VGND VPWR VPWR _03113_ sky130_fd_sc_hd__nand2_1
XFILLER_13_709 VPWR VGND VPWR VGND sky130_ef_sc_hd__decap_12
XTAP_TAPCELL_ROW_23_704 VGND VPWR sky130_fd_sc_hd__tapvpwrvgnd_1
X_06566_ u_interface.u_gelu_fp32.s1_data\[16\] _01139_ VGND VGND VPWR VPWR _01160_
+ sky130_fd_sc_hd__nand2_1
X_08305_ net531 net1582 _02110_ net799 VGND VGND VPWR VPWR _02112_ sky130_fd_sc_hd__a31o_1
XFILLER_52_399 VPWR VGND VPWR VGND sky130_ef_sc_hd__decap_12
X_09285_ _03019_ _03022_ _03021_ VGND VGND VPWR VPWR _03044_ sky130_fd_sc_hd__a21o_1
XFILLER_21_753 VPWR VGND VPWR VGND sky130_ef_sc_hd__decap_12
X_08236_ net166 _02062_ VGND VGND VPWR VPWR _02063_ sky130_fd_sc_hd__nand2_1
XFILLER_21_797 VPWR VGND VPWR VGND sky130_ef_sc_hd__decap_12
X_08167_ net315 _02003_ _02004_ VGND VGND VPWR VPWR _02005_ sky130_fd_sc_hd__or3_1
XFILLER_109_22 VPWR VGND VPWR VGND sky130_ef_sc_hd__decap_12
X_07118_ net963 net324 net251 VGND VGND VPWR VPWR _00158_ sky130_fd_sc_hd__mux2_1
XFILLER_134_666 VGND VGND VPWR VPWR sky130_fd_sc_hd__decap_4
XFILLER_133_121 VGND VGND VPWR VPWR sky130_fd_sc_hd__fill_2
X_08098_ u_interface.u_gelu_fp32.u_fp32_to_q16.s3_mag\[8\] _01877_ VGND VGND VPWR
+ VPWR _01947_ sky130_fd_sc_hd__nor2_1
XFILLER_109_99 VGND VGND VPWR VPWR sky130_fd_sc_hd__decap_8
XFILLER_69_15 VPWR VGND VPWR VGND sky130_ef_sc_hd__decap_12
XFILLER_133_165 VGND VGND VPWR VPWR sky130_fd_sc_hd__decap_3
X_07049_ net1102 net384 net208 VGND VGND VPWR VPWR _00089_ sky130_fd_sc_hd__mux2_1
XFILLER_0_613 VGND VGND VPWR VPWR sky130_fd_sc_hd__decap_3
X_10060_ net465 net469 net662 net673 VGND VGND VPWR VPWR _03812_ sky130_fd_sc_hd__nand4_1
XFILLER_0_657 VPWR VGND VPWR VGND sky130_ef_sc_hd__decap_12
XTAP_TAPCELL_ROW_145_2655 VGND VPWR sky130_fd_sc_hd__tapvpwrvgnd_1
XFILLER_102_574 VPWR VGND VPWR VGND sky130_ef_sc_hd__decap_12
XFILLER_75_436 VGND VGND VPWR VPWR sky130_fd_sc_hd__decap_4
XTAP_TAPCELL_ROW_50_1138 VGND VPWR sky130_fd_sc_hd__tapvpwrvgnd_1
XFILLER_18_41 VPWR VGND VPWR VGND sky130_ef_sc_hd__decap_12
XFILLER_29_853 VPWR VGND VPWR VGND sky130_ef_sc_hd__decap_12
X_13750_ clknet_leaf_84_clk _00760_ VGND VGND VPWR VPWR u_interface.u_gelu_fp32.u_q16_to_fp32.s1_mag\[16\]
+ sky130_fd_sc_hd__dfxtp_1
X_10962_ _04704_ _04705_ _04598_ _04602_ VGND VGND VPWR VPWR _04706_ sky130_fd_sc_hd__a211oi_1
XFILLER_44_834 VPWR VGND VPWR VGND sky130_ef_sc_hd__decap_12
XFILLER_18_85 VPWR VGND VPWR VGND sky130_ef_sc_hd__decap_12
XFILLER_29_897 VPWR VGND VPWR VGND sky130_ef_sc_hd__decap_12
X_12701_ net808 net1748 _01714_ net288 _06358_ VGND VGND VPWR VPWR _00919_ sky130_fd_sc_hd__a221o_1
XFILLER_16_558 VPWR VGND VPWR VGND sky130_ef_sc_hd__decap_12
XFILLER_43_333 VGND VGND VPWR VPWR sky130_fd_sc_hd__decap_3
X_13681_ clknet_leaf_10_clk _00691_ VGND VGND VPWR VPWR u_interface.u_gelu_fp32.u_fp32_to_q16.s3_frac\[17\]
+ sky130_fd_sc_hd__dfxtp_1
XFILLER_70_141 VPWR VGND VPWR VGND sky130_ef_sc_hd__decap_12
X_10893_ _04632_ _04636_ VGND VGND VPWR VPWR _04638_ sky130_fd_sc_hd__xnor2_1
X_12632_ _06317_ _06330_ VGND VGND VPWR VPWR _06333_ sky130_fd_sc_hd__and2_1
XTAP_TAPCELL_ROW_65_1381 VGND VPWR sky130_fd_sc_hd__tapvpwrvgnd_1
XTAP_TAPCELL_ROW_65_1370 VGND VPWR sky130_fd_sc_hd__tapvpwrvgnd_1
X_12563_ net784 net1757 VGND VGND VPWR VPWR _00861_ sky130_fd_sc_hd__and2_1
XFILLER_8_713 VPWR VGND VPWR VGND sky130_ef_sc_hd__decap_12
XFILLER_7_223 VGND VGND VPWR VPWR sky130_fd_sc_hd__fill_1
X_12494_ _06218_ _06219_ net795 VGND VGND VPWR VPWR _06220_ sky130_fd_sc_hd__a21oi_1
X_11514_ _05236_ _05251_ VGND VGND VPWR VPWR _05253_ sky130_fd_sc_hd__nand2_1
XFILLER_144_419 VGND VGND VPWR VPWR sky130_fd_sc_hd__fill_1
XFILLER_50_50 VPWR VGND VPWR VGND sky130_ef_sc_hd__decap_12
XFILLER_8_757 VPWR VGND VPWR VGND sky130_ef_sc_hd__decap_12
X_11445_ _05182_ _05183_ VGND VGND VPWR VPWR _05185_ sky130_fd_sc_hd__xor2_1
XFILLER_153_920 VGND VGND VPWR VPWR sky130_fd_sc_hd__fill_1
XFILLER_125_633 VGND VGND VPWR VPWR sky130_fd_sc_hd__fill_1
XFILLER_50_94 VGND VGND VPWR VPWR sky130_fd_sc_hd__fill_2
XFILLER_125_666 VGND VGND VPWR VPWR sky130_fd_sc_hd__decap_6
X_14164_ clknet_leaf_47_clk _01090_ VGND VGND VPWR VPWR u_interface.fifo_data\[1\]\[24\]
+ sky130_fd_sc_hd__dfxtp_1
X_11376_ _04904_ _05019_ _05020_ VGND VGND VPWR VPWR _05117_ sky130_fd_sc_hd__a21o_1
X_14095_ clknet_leaf_29_clk net1681 VGND VGND VPWR VPWR net148 sky130_fd_sc_hd__dfxtp_1
XFILLER_152_474 VGND VGND VPWR VPWR sky130_fd_sc_hd__fill_2
XFILLER_124_154 VGND VGND VPWR VPWR sky130_fd_sc_hd__decap_3
XFILLER_113_839 VGND VGND VPWR VPWR sky130_fd_sc_hd__fill_1
XFILLER_112_316 VGND VGND VPWR VPWR sky130_fd_sc_hd__decap_4
X_13115_ clknet_leaf_48_clk _00125_ VGND VGND VPWR VPWR u_interface.fifo_data\[2\]\[4\]
+ sky130_fd_sc_hd__dfxtp_1
X_10327_ _04075_ _04076_ _03974_ VGND VGND VPWR VPWR _04077_ sky130_fd_sc_hd__a21o_1
X_13046_ clknet_leaf_36_clk _00056_ VGND VGND VPWR VPWR u_interface.fifo_tlast\[9\]
+ sky130_fd_sc_hd__dfxtp_1
XFILLER_124_187 VGND VGND VPWR VPWR sky130_fd_sc_hd__decap_8
XFILLER_106_891 VGND VGND VPWR VPWR sky130_fd_sc_hd__fill_2
X_10258_ _04006_ _04007_ _04005_ VGND VGND VPWR VPWR _04008_ sky130_fd_sc_hd__a21o_1
XFILLER_3_473 VPWR VGND VPWR VGND sky130_ef_sc_hd__decap_12
XFILLER_121_861 VPWR VGND VPWR VGND sky130_ef_sc_hd__decap_12
XFILLER_39_617 VPWR VGND VPWR VGND sky130_ef_sc_hd__decap_12
X_10189_ _03930_ _03938_ VGND VGND VPWR VPWR _03940_ sky130_fd_sc_hd__xnor2_1
XFILLER_82_918 VGND VGND VPWR VPWR sky130_fd_sc_hd__decap_3
XFILLER_66_458 VGND VGND VPWR VPWR sky130_fd_sc_hd__fill_1
X_13948_ clknet_leaf_56_clk _00874_ VGND VGND VPWR VPWR u_interface.u_gelu_fp32.u_q16_to_fp32.s2_exp\[0\]
+ sky130_fd_sc_hd__dfxtp_1
XTAP_TAPCELL_ROW_85_1702 VGND VPWR sky130_fd_sc_hd__tapvpwrvgnd_1
XFILLER_34_300 VGND VGND VPWR VPWR sky130_fd_sc_hd__decap_8
X_13879_ clknet_leaf_3_clk _00032_ VGND VGND VPWR VPWR u_interface.u_gelu_fp32.u_synth_top.s2_dx\[15\]
+ sky130_fd_sc_hd__dfxtp_1
XFILLER_61_152 VGND VGND VPWR VPWR sky130_fd_sc_hd__decap_3
XFILLER_22_506 VPWR VGND VPWR VGND sky130_ef_sc_hd__decap_12
XFILLER_34_377 VPWR VGND VPWR VGND sky130_ef_sc_hd__decap_12
XFILLER_61_185 VGND VGND VPWR VPWR sky130_fd_sc_hd__decap_6
XFILLER_148_747 VGND VGND VPWR VPWR sky130_fd_sc_hd__fill_2
X_09070_ _02775_ _02777_ VGND VGND VPWR VPWR _02829_ sky130_fd_sc_hd__xor2_2
XFILLER_135_419 VGND VGND VPWR VPWR sky130_fd_sc_hd__decap_4
X_08021_ u_interface.u_gelu_fp32.u_fp32_to_q16.s3_mag\[8\] _01877_ VGND VGND VPWR
+ VPWR _01878_ sky130_fd_sc_hd__and2_1
XFILLER_147_279 VGND VGND VPWR VPWR sky130_fd_sc_hd__fill_1
Xhold702 u_interface.fifo_data\[11\]\[14\] VGND VGND VPWR VPWR net1567 sky130_fd_sc_hd__dlygate4sd3_1
Xhold713 u_interface.fifo_data\[7\]\[26\] VGND VGND VPWR VPWR net1578 sky130_fd_sc_hd__dlygate4sd3_1
Xhold735 u_interface.u_gelu_fp32.u_fp32_to_q16.s3_frac\[7\] VGND VGND VPWR VPWR net1600
+ sky130_fd_sc_hd__dlygate4sd3_1
Xhold724 u_interface.fifo_data\[3\]\[14\] VGND VGND VPWR VPWR net1589 sky130_fd_sc_hd__dlygate4sd3_1
XFILLER_116_633 VGND VGND VPWR VPWR sky130_fd_sc_hd__decap_3
Xhold746 u_interface.u_gelu_fp32.u_q16_to_fp32.s3_exp\[4\] VGND VGND VPWR VPWR net1611
+ sky130_fd_sc_hd__dlygate4sd3_1
XTAP_TAPCELL_ROW_96_1875 VGND VPWR sky130_fd_sc_hd__tapvpwrvgnd_1
XTAP_TAPCELL_ROW_96_1864 VGND VPWR sky130_fd_sc_hd__tapvpwrvgnd_1
XPHY_EDGE_ROW_123_Right_123 VGND VGND VPWR VPWR sky130_fd_sc_hd__decap_3
Xhold779 u_interface.u_gelu_fp32.u_fp32_to_q16.s3_mag\[10\] VGND VGND VPWR VPWR net1644
+ sky130_fd_sc_hd__dlygate4sd3_1
XFILLER_116_699 VGND VGND VPWR VPWR sky130_fd_sc_hd__fill_1
XFILLER_115_165 VGND VGND VPWR VPWR sky130_fd_sc_hd__decap_3
X_09972_ _03723_ _03724_ _03613_ VGND VGND VPWR VPWR _03725_ sky130_fd_sc_hd__a21o_1
Xhold757 _00888_ VGND VGND VPWR VPWR net1622 sky130_fd_sc_hd__dlygate4sd3_1
Xhold768 u_interface.u_gelu_fp32.s2_data\[17\] VGND VGND VPWR VPWR net1633 sky130_fd_sc_hd__dlygate4sd3_1
X_08923_ net498 net671 _02680_ _02681_ VGND VGND VPWR VPWR _02682_ sky130_fd_sc_hd__a22o_1
XFILLER_69_241 VGND VGND VPWR VPWR sky130_fd_sc_hd__fill_1
X_08854_ _02520_ _02522_ _02521_ VGND VGND VPWR VPWR _02613_ sky130_fd_sc_hd__a21bo_1
XFILLER_97_583 VGND VGND VPWR VPWR sky130_fd_sc_hd__decap_8
XTAP_TAPCELL_ROW_127_2374 VGND VPWR sky130_fd_sc_hd__tapvpwrvgnd_1
XTAP_TAPCELL_ROW_127_2363 VGND VPWR sky130_fd_sc_hd__tapvpwrvgnd_1
X_08785_ _02535_ _02541_ _02542_ VGND VGND VPWR VPWR _02544_ sky130_fd_sc_hd__nand3_1
XFILLER_111_393 VGND VGND VPWR VPWR sky130_fd_sc_hd__decap_3
X_07805_ net1294 net378 net229 VGND VGND VPWR VPWR _00566_ sky130_fd_sc_hd__mux2_1
X_07736_ u_interface.u_gelu_fp32.u_q16_to_fp32.s3_norm_mag\[15\] u_interface.u_gelu_fp32.u_q16_to_fp32.s3_norm_mag\[14\]
+ _01779_ VGND VGND VPWR VPWR _01780_ sky130_fd_sc_hd__and3_1
XFILLER_25_300 VPWR VGND VPWR VGND sky130_ef_sc_hd__decap_12
XFILLER_38_661 VGND VGND VPWR VPWR sky130_fd_sc_hd__decap_4
XTAP_TAPCELL_ROW_140_2574 VGND VPWR sky130_fd_sc_hd__tapvpwrvgnd_1
X_07667_ u_interface.u_gelu_fp32.u_q16_to_fp32.s2_clz\[3\] net298 VGND VGND VPWR VPWR
+ _01748_ sky130_fd_sc_hd__and2_1
XFILLER_52_141 VGND VGND VPWR VPWR sky130_fd_sc_hd__decap_8
XFILLER_13_517 VPWR VGND VPWR VGND sky130_ef_sc_hd__decap_12
XFILLER_26_867 VGND VGND VPWR VPWR sky130_fd_sc_hd__fill_1
X_06618_ u_interface.fifo_tuser\[4\] u_interface.fifo_tuser\[5\] u_interface.fifo_tuser\[6\]
+ u_interface.fifo_tuser\[7\] net769 net752 VGND VGND VPWR VPWR _01195_ sky130_fd_sc_hd__mux4_1
X_07598_ net813 net1769 net303 _01694_ VGND VGND VPWR VPWR _00469_ sky130_fd_sc_hd__a22o_1
X_09406_ _02653_ _03162_ VGND VGND VPWR VPWR _03164_ sky130_fd_sc_hd__nand2_1
XFILLER_52_174 VPWR VGND VPWR VGND sky130_ef_sc_hd__decap_12
XFILLER_25_399 VPWR VGND VPWR VGND sky130_ef_sc_hd__decap_12
XFILLER_41_837 VGND VGND VPWR VPWR sky130_fd_sc_hd__decap_3
X_09337_ net583 net506 net512 net591 VGND VGND VPWR VPWR _03096_ sky130_fd_sc_hd__a22oi_1
X_06549_ u_interface.u_gelu_fp32.s1_data\[7\] u_interface.u_gelu_fp32.s1_data\[6\]
+ u_interface.u_gelu_fp32.s1_data\[5\] u_interface.u_gelu_fp32.s1_data\[4\] VGND VGND
+ VPWR VPWR _01145_ sky130_fd_sc_hd__or4_1
XFILLER_71_49 VGND VGND VPWR VPWR sky130_fd_sc_hd__fill_1
X_09268_ _03011_ _03025_ _03026_ VGND VGND VPWR VPWR _03027_ sky130_fd_sc_hd__nand3_1
XFILLER_139_747 VGND VGND VPWR VPWR sky130_fd_sc_hd__decap_3
X_08219_ net166 _02048_ VGND VGND VPWR VPWR _02049_ sky130_fd_sc_hd__nand2_1
X_09199_ _02955_ _02956_ _02957_ VGND VGND VPWR VPWR _02958_ sky130_fd_sc_hd__nand3_1
XFILLER_138_279 VGND VGND VPWR VPWR sky130_fd_sc_hd__decap_3
XFILLER_126_419 VGND VGND VPWR VPWR sky130_fd_sc_hd__fill_1
XFILLER_107_611 VGND VGND VPWR VPWR sky130_fd_sc_hd__decap_4
XFILLER_5_727 VGND VGND VPWR VPWR sky130_fd_sc_hd__fill_1
XFILLER_105_3 VGND VGND VPWR VPWR sky130_fd_sc_hd__fill_1
X_11230_ _04968_ _04971_ VGND VGND VPWR VPWR _04972_ sky130_fd_sc_hd__xnor2_1
X_11161_ _04902_ _04903_ VGND VGND VPWR VPWR _04904_ sky130_fd_sc_hd__or2_1
XFILLER_20_53 VPWR VGND VPWR VGND sky130_ef_sc_hd__decap_12
XFILLER_96_24 VGND VGND VPWR VPWR sky130_fd_sc_hd__decap_4
X_10112_ _03805_ _03837_ _03838_ VGND VGND VPWR VPWR _03863_ sky130_fd_sc_hd__a21bo_1
XFILLER_0_421 VPWR VGND VPWR VGND sky130_ef_sc_hd__decap_12
XFILLER_20_97 VPWR VGND VPWR VGND sky130_ef_sc_hd__decap_12
X_11092_ _04831_ _04834_ VGND VGND VPWR VPWR _04835_ sky130_fd_sc_hd__xnor2_2
Xhold40 u_interface.u_gelu_fp32.s1_data\[27\] VGND VGND VPWR VPWR net905 sky130_fd_sc_hd__dlygate4sd3_1
X_10043_ _03791_ _03794_ VGND VGND VPWR VPWR _03795_ sky130_fd_sc_hd__xnor2_1
XFILLER_75_211 VPWR VGND VPWR VGND sky130_ef_sc_hd__decap_12
XFILLER_29_51 VGND VGND VPWR VPWR sky130_fd_sc_hd__decap_4
XFILLER_152_41 VPWR VGND VPWR VGND sky130_ef_sc_hd__decap_12
Xhold62 u_interface.meta_tuser_pipe\[6\] VGND VGND VPWR VPWR net927 sky130_fd_sc_hd__dlygate4sd3_1
Xhold51 u_interface.meta_tlast_pipe\[6\] VGND VGND VPWR VPWR net916 sky130_fd_sc_hd__dlygate4sd3_1
Xhold73 _00881_ VGND VGND VPWR VPWR net938 sky130_fd_sc_hd__dlygate4sd3_1
XFILLER_75_233 VGND VGND VPWR VPWR sky130_fd_sc_hd__fill_2
Xhold84 u_interface.meta_tuser_pipe\[0\] VGND VGND VPWR VPWR net949 sky130_fd_sc_hd__dlygate4sd3_1
X_13802_ clknet_leaf_23_clk _00812_ VGND VGND VPWR VPWR u_interface.u_gelu_fp32.u_synth_top.s3_mult\[20\]
+ sky130_fd_sc_hd__dfxtp_1
XFILLER_90_214 VGND VGND VPWR VPWR sky130_fd_sc_hd__decap_6
XFILLER_75_266 VPWR VGND VPWR VGND sky130_ef_sc_hd__decap_12
Xhold95 u_interface.u_gelu_fp32.u_q16_to_fp32.s1_mag\[14\] VGND VGND VPWR VPWR net960
+ sky130_fd_sc_hd__dlygate4sd3_1
XTAP_TAPCELL_ROW_67_1410 VGND VPWR sky130_fd_sc_hd__tapvpwrvgnd_1
XFILLER_44_642 VGND VGND VPWR VPWR sky130_fd_sc_hd__fill_2
XFILLER_16_322 VGND VGND VPWR VPWR sky130_fd_sc_hd__fill_1
XFILLER_28_182 VGND VGND VPWR VPWR sky130_fd_sc_hd__fill_1
XFILLER_28_193 VGND VGND VPWR VPWR sky130_fd_sc_hd__decap_3
X_11994_ _05725_ _05726_ VGND VGND VPWR VPWR _05727_ sky130_fd_sc_hd__nor2_1
X_13733_ clknet_leaf_21_clk _00743_ VGND VGND VPWR VPWR net145 sky130_fd_sc_hd__dfxtp_1
X_10945_ _04687_ _04688_ VGND VGND VPWR VPWR _04689_ sky130_fd_sc_hd__nand2b_1
XFILLER_17_889 VGND VGND VPWR VPWR sky130_fd_sc_hd__decap_6
X_13664_ clknet_leaf_14_clk _00674_ VGND VGND VPWR VPWR u_interface.u_gelu_fp32.u_fp32_to_q16.s2_shift\[1\]
+ sky130_fd_sc_hd__dfxtp_1
XTAP_TAPCELL_ROW_80_1621 VGND VPWR sky130_fd_sc_hd__tapvpwrvgnd_1
XTAP_TAPCELL_ROW_80_1610 VGND VPWR sky130_fd_sc_hd__tapvpwrvgnd_1
X_10876_ net626 net418 net413 net617 VGND VGND VPWR VPWR _04621_ sky130_fd_sc_hd__a22oi_1
XFILLER_32_837 VPWR VGND VPWR VGND sky130_ef_sc_hd__decap_12
X_12615_ u_interface.u_gelu_fp32.u_q16_to_fp32.s1_mag\[3\] net212 u_interface.u_gelu_fp32.u_q16_to_fp32.s1_mag\[19\]
+ VGND VGND VPWR VPWR _06318_ sky130_fd_sc_hd__a21o_1
XTAP_TAPCELL_ROW_14_556 VGND VPWR sky130_fd_sc_hd__tapvpwrvgnd_1
X_13595_ clknet_leaf_40_clk _00605_ VGND VGND VPWR VPWR u_interface.fifo_data\[3\]\[10\]
+ sky130_fd_sc_hd__dfxtp_1
XFILLER_129_235 VGND VGND VPWR VPWR sky130_fd_sc_hd__fill_2
XTAP_TAPCELL_ROW_14_567 VGND VPWR sky130_fd_sc_hd__tapvpwrvgnd_1
XFILLER_129_246 VGND VGND VPWR VPWR sky130_fd_sc_hd__decap_6
X_12546_ _06222_ _06239_ _06238_ VGND VGND VPWR VPWR _06270_ sky130_fd_sc_hd__a21oi_1
XFILLER_126_920 VGND VGND VPWR VPWR sky130_fd_sc_hd__fill_1
XFILLER_117_419 VGND VGND VPWR VPWR sky130_fd_sc_hd__fill_2
XFILLER_8_587 VGND VGND VPWR VPWR sky130_fd_sc_hd__fill_1
X_12477_ _06184_ _06202_ VGND VGND VPWR VPWR _06203_ sky130_fd_sc_hd__xnor2_1
Xgelu_top_839 VGND VGND VPWR VPWR gelu_top_839/HI s_axil_rdata[7] sky130_fd_sc_hd__conb_1
XANTENNA_4 _01541_ VGND VGND VPWR VPWR sky130_fd_sc_hd__diode_2
X_11428_ _05166_ _05167_ _05163_ VGND VGND VPWR VPWR _05168_ sky130_fd_sc_hd__a21oi_1
XFILLER_153_783 VGND VGND VPWR VPWR sky130_fd_sc_hd__fill_1
XFILLER_125_463 VGND VGND VPWR VPWR sky130_fd_sc_hd__decap_3
X_14147_ clknet_leaf_45_clk _01073_ VGND VGND VPWR VPWR u_interface.fifo_data\[1\]\[7\]
+ sky130_fd_sc_hd__dfxtp_1
XFILLER_99_837 VGND VGND VPWR VPWR sky130_fd_sc_hd__decap_3
XFILLER_99_815 VGND VGND VPWR VPWR sky130_fd_sc_hd__fill_2
XTAP_TAPCELL_ROW_78_1583 VGND VPWR sky130_fd_sc_hd__tapvpwrvgnd_1
X_11359_ _05098_ _05099_ VGND VGND VPWR VPWR _05100_ sky130_fd_sc_hd__nor2_1
XFILLER_6_77 VGND VGND VPWR VPWR sky130_fd_sc_hd__decap_6
XFILLER_152_293 VPWR VGND VPWR VGND sky130_ef_sc_hd__decap_12
XFILLER_140_433 VPWR VGND VPWR VGND sky130_ef_sc_hd__decap_12
XFILLER_113_625 VGND VGND VPWR VPWR sky130_fd_sc_hd__fill_2
XFILLER_4_793 VPWR VGND VPWR VGND sky130_ef_sc_hd__decap_12
XFILLER_3_281 VPWR VGND VPWR VGND sky130_ef_sc_hd__decap_12
X_14078_ clknet_leaf_17_clk net1595 VGND VGND VPWR VPWR u_interface.u_gelu_fp32.u_fp32_to_q16.s2_norm_mag\[15\]
+ sky130_fd_sc_hd__dfxtp_1
XFILLER_113_669 VGND VGND VPWR VPWR sky130_fd_sc_hd__decap_3
XFILLER_79_561 VGND VGND VPWR VPWR sky130_fd_sc_hd__fill_2
X_13029_ _01532_ _01533_ VGND VGND VPWR VPWR _01047_ sky130_fd_sc_hd__nor2_1
XFILLER_112_179 VGND VGND VPWR VPWR sky130_fd_sc_hd__fill_2
XTAP_TAPCELL_ROW_91_1794 VGND VPWR sky130_fd_sc_hd__tapvpwrvgnd_1
XFILLER_20_3 VPWR VGND VPWR VGND sky130_ef_sc_hd__decap_12
XFILLER_120_190 VGND VGND VPWR VPWR sky130_fd_sc_hd__decap_6
XFILLER_94_531 VGND VGND VPWR VPWR sky130_fd_sc_hd__fill_1
XFILLER_27_609 VGND VGND VPWR VPWR sky130_fd_sc_hd__decap_6
XTAP_TAPCELL_ROW_109_2082 VGND VPWR sky130_fd_sc_hd__tapvpwrvgnd_1
X_08570_ u_interface.u_gelu_fp32.u_synth_top.s3_mult\[16\] u_interface.u_gelu_fp32.u_synth_top.s3_b\[0\]
+ VGND VGND VPWR VPWR _02361_ sky130_fd_sc_hd__or2_1
XFILLER_94_586 VGND VGND VPWR VPWR sky130_fd_sc_hd__fill_2
XFILLER_54_417 VGND VGND VPWR VPWR sky130_fd_sc_hd__decap_3
X_07521_ _01647_ _01650_ u_interface.u_gelu_fp32.u_fp32_to_q16.s2_shift\[4\] VGND
+ VGND VPWR VPWR _01651_ sky130_fd_sc_hd__mux2_1
XFILLER_35_653 VPWR VGND VPWR VGND sky130_ef_sc_hd__decap_12
X_07452_ _01586_ VGND VGND VPWR VPWR _01587_ sky130_fd_sc_hd__inv_2
XTAP_TAPCELL_ROW_122_2293 VGND VPWR sky130_fd_sc_hd__tapvpwrvgnd_1
XTAP_TAPCELL_ROW_122_2282 VGND VPWR sky130_fd_sc_hd__tapvpwrvgnd_1
X_07383_ net1268 net352 net239 VGND VGND VPWR VPWR _00413_ sky130_fd_sc_hd__mux2_1
XFILLER_50_645 VGND VGND VPWR VPWR sky130_fd_sc_hd__fill_1
X_09122_ _02826_ _02827_ VGND VGND VPWR VPWR _02881_ sky130_fd_sc_hd__xor2_2
XTAP_TAPCELL_ROW_98_1904 VGND VPWR sky130_fd_sc_hd__tapvpwrvgnd_1
XFILLER_22_369 VGND VGND VPWR VPWR sky130_fd_sc_hd__fill_1
XTAP_TAPCELL_ROW_33_865 VGND VPWR sky130_fd_sc_hd__tapvpwrvgnd_1
X_09053_ _02593_ _02595_ _02810_ _02811_ VGND VGND VPWR VPWR _02812_ sky130_fd_sc_hd__a211o_1
X_08004_ net813 net1560 net301 _01693_ _01867_ VGND VGND VPWR VPWR _00703_ sky130_fd_sc_hd__a221o_1
Xhold510 u_interface.fifo_data\[12\]\[3\] VGND VGND VPWR VPWR net1375 sky130_fd_sc_hd__dlygate4sd3_1
Xhold521 u_interface.fifo_data\[14\]\[28\] VGND VGND VPWR VPWR net1386 sky130_fd_sc_hd__dlygate4sd3_1
Xhold543 u_interface.fifo_data\[3\]\[19\] VGND VGND VPWR VPWR net1408 sky130_fd_sc_hd__dlygate4sd3_1
Xhold554 u_interface.fifo_data\[1\]\[0\] VGND VGND VPWR VPWR net1419 sky130_fd_sc_hd__dlygate4sd3_1
Xhold532 u_interface.fifo_data\[4\]\[6\] VGND VGND VPWR VPWR net1397 sky130_fd_sc_hd__dlygate4sd3_1
Xhold576 u_interface.fifo_data\[7\]\[11\] VGND VGND VPWR VPWR net1441 sky130_fd_sc_hd__dlygate4sd3_1
Xhold587 u_interface.fifo_data\[11\]\[4\] VGND VGND VPWR VPWR net1452 sky130_fd_sc_hd__dlygate4sd3_1
Xhold565 u_interface.fifo_data\[7\]\[6\] VGND VGND VPWR VPWR net1430 sky130_fd_sc_hd__dlygate4sd3_1
Xhold598 _00998_ VGND VGND VPWR VPWR net1463 sky130_fd_sc_hd__dlygate4sd3_1
XTAP_TAPCELL_ROW_129_2403 VGND VPWR sky130_fd_sc_hd__tapvpwrvgnd_1
X_09955_ net463 net649 _03706_ _03707_ VGND VGND VPWR VPWR _03708_ sky130_fd_sc_hd__a22o_1
X_08906_ net504 net679 net509 net689 VGND VGND VPWR VPWR _02665_ sky130_fd_sc_hd__and4_1
X_09886_ net486 net491 net705 net713 VGND VGND VPWR VPWR _03639_ sky130_fd_sc_hd__nand4_1
XFILLER_66_27 VGND VGND VPWR VPWR sky130_fd_sc_hd__fill_1
XTAP_TAPCELL_ROW_142_2603 VGND VPWR sky130_fd_sc_hd__tapvpwrvgnd_1
X_08837_ _02580_ _02594_ VGND VGND VPWR VPWR _02596_ sky130_fd_sc_hd__xnor2_1
XFILLER_100_864 VGND VGND VPWR VPWR sky130_fd_sc_hd__decap_4
XFILLER_46_918 VGND VGND VPWR VPWR sky130_fd_sc_hd__decap_3
XTAP_TAPCELL_ROW_142_2614 VGND VPWR sky130_fd_sc_hd__tapvpwrvgnd_1
XFILLER_73_715 VGND VGND VPWR VPWR sky130_fd_sc_hd__fill_1
X_08768_ net629 net484 VGND VGND VPWR VPWR _02527_ sky130_fd_sc_hd__nand2_1
X_08699_ net655 net502 net508 net663 VGND VGND VPWR VPWR _02458_ sky130_fd_sc_hd__a22o_1
X_07719_ _01183_ _01768_ _01770_ VGND VGND VPWR VPWR _00514_ sky130_fd_sc_hd__or3_1
XFILLER_82_15 VPWR VGND VPWR VGND sky130_ef_sc_hd__decap_12
X_10730_ _04470_ _04473_ _04474_ VGND VGND VPWR VPWR _04476_ sky130_fd_sc_hd__nand3_1
XFILLER_53_461 VGND VGND VPWR VPWR sky130_fd_sc_hd__decap_4
XFILLER_14_837 VPWR VGND VPWR VGND sky130_ef_sc_hd__decap_12
XFILLER_25_152 VPWR VGND VPWR VGND sky130_ef_sc_hd__decap_12
XFILLER_80_291 VGND VGND VPWR VPWR sky130_fd_sc_hd__fill_2
X_10661_ _04405_ _04406_ _04397_ VGND VGND VPWR VPWR _04408_ sky130_fd_sc_hd__a21oi_1
XTAP_TAPCELL_ROW_45_1059 VGND VPWR sky130_fd_sc_hd__tapvpwrvgnd_1
XTAP_TAPCELL_ROW_45_1048 VGND VPWR sky130_fd_sc_hd__tapvpwrvgnd_1
XFILLER_139_533 VGND VGND VPWR VPWR sky130_fd_sc_hd__decap_4
XTAP_TAPCELL_ROW_11_504 VGND VPWR sky130_fd_sc_hd__tapvpwrvgnd_1
X_12400_ _06073_ _06076_ net177 VGND VGND VPWR VPWR _06127_ sky130_fd_sc_hd__o21a_1
XFILLER_22_881 VPWR VGND VPWR VGND sky130_ef_sc_hd__decap_12
X_13380_ clknet_leaf_49_clk _00390_ VGND VGND VPWR VPWR u_interface.fifo_data\[7\]\[25\]
+ sky130_fd_sc_hd__dfxtp_1
X_10592_ _04320_ _04336_ _04337_ VGND VGND VPWR VPWR _04339_ sky130_fd_sc_hd__nand3_2
XTAP_TAPCELL_ROW_11_515 VGND VPWR sky130_fd_sc_hd__tapvpwrvgnd_1
XFILLER_21_380 VGND VGND VPWR VPWR sky130_fd_sc_hd__fill_1
X_12331_ _06058_ _06059_ VGND VGND VPWR VPWR _06060_ sky130_fd_sc_hd__or2_1
XTAP_TAPCELL_ROW_153_2787 VGND VPWR sky130_fd_sc_hd__tapvpwrvgnd_1
XTAP_TAPCELL_ROW_153_2776 VGND VPWR sky130_fd_sc_hd__tapvpwrvgnd_1
XFILLER_142_709 VGND VGND VPWR VPWR sky130_fd_sc_hd__fill_2
X_12262_ net192 _05991_ VGND VGND VPWR VPWR _05992_ sky130_fd_sc_hd__or2_1
XFILLER_135_783 VGND VGND VPWR VPWR sky130_fd_sc_hd__fill_1
XFILLER_107_463 VPWR VGND VPWR VGND sky130_ef_sc_hd__decap_12
X_14001_ clknet_leaf_64_clk _00927_ VGND VGND VPWR VPWR u_interface.u_gelu_fp32.u_q16_to_fp32.s3_norm_mag\[28\]
+ sky130_fd_sc_hd__dfxtp_1
X_11213_ _04953_ _04954_ _04952_ VGND VGND VPWR VPWR _04955_ sky130_fd_sc_hd__a21o_1
XFILLER_134_271 VGND VGND VPWR VPWR sky130_fd_sc_hd__decap_3
X_12193_ _05922_ _05923_ VGND VGND VPWR VPWR _05924_ sky130_fd_sc_hd__nand2b_1
X_11144_ _04885_ _04886_ VGND VGND VPWR VPWR _04887_ sky130_fd_sc_hd__nor2_1
XFILLER_1_741 VPWR VGND VPWR VGND sky130_ef_sc_hd__decap_12
XFILLER_122_477 VPWR VGND VPWR VGND sky130_ef_sc_hd__decap_12
X_11075_ _04815_ _04817_ _04701_ VGND VGND VPWR VPWR _04818_ sky130_fd_sc_hd__a21bo_1
XFILLER_1_785 VPWR VGND VPWR VGND sky130_ef_sc_hd__decap_12
XFILLER_102_190 VGND VGND VPWR VPWR sky130_fd_sc_hd__decap_6
X_10026_ _03648_ _03651_ _03774_ _03775_ VGND VGND VPWR VPWR _03778_ sky130_fd_sc_hd__a211oi_1
XFILLER_88_391 VPWR VGND VPWR VGND sky130_ef_sc_hd__decap_12
XFILLER_76_531 VGND VGND VPWR VPWR sky130_fd_sc_hd__fill_1
XFILLER_49_778 VGND VGND VPWR VPWR sky130_fd_sc_hd__decap_6
XFILLER_63_225 VGND VGND VPWR VPWR sky130_fd_sc_hd__decap_4
XTAP_TAPCELL_ROW_19_637 VGND VPWR sky130_fd_sc_hd__tapvpwrvgnd_1
XFILLER_16_141 VPWR VGND VPWR VGND sky130_ef_sc_hd__decap_12
XFILLER_17_653 VPWR VGND VPWR VGND sky130_ef_sc_hd__decap_12
X_11977_ _05570_ _05628_ _05627_ VGND VGND VPWR VPWR _05711_ sky130_fd_sc_hd__o21ai_1
X_13716_ clknet_leaf_10_clk _00726_ VGND VGND VPWR VPWR u_interface.u_gelu_fp32.s1_data\[16\]
+ sky130_fd_sc_hd__dfxtp_2
X_10928_ net773 _04671_ _04672_ VGND VGND VPWR VPWR _00822_ sky130_fd_sc_hd__and3_1
XFILLER_17_697 VPWR VGND VPWR VGND sky130_ef_sc_hd__decap_12
XFILLER_32_601 VPWR VGND VPWR VGND sky130_ef_sc_hd__decap_12
XFILLER_72_70 VPWR VGND VPWR VGND sky130_ef_sc_hd__decap_12
XFILLER_31_133 VGND VGND VPWR VPWR sky130_fd_sc_hd__fill_1
XFILLER_32_645 VPWR VGND VPWR VGND sky130_ef_sc_hd__decap_12
X_13647_ clknet_leaf_67_clk _00657_ VGND VGND VPWR VPWR u_interface.fifo_data\[13\]\[30\]
+ sky130_fd_sc_hd__dfxtp_1
X_10859_ net660 net434 VGND VGND VPWR VPWR _04604_ sky130_fd_sc_hd__nand2_1
XTAP_TAPCELL_ROW_30_813 VGND VPWR sky130_fd_sc_hd__tapvpwrvgnd_1
XFILLER_31_166 VGND VGND VPWR VPWR sky130_fd_sc_hd__fill_2
X_13578_ clknet_leaf_47_clk _00588_ VGND VGND VPWR VPWR u_interface.fifo_data\[4\]\[25\]
+ sky130_fd_sc_hd__dfxtp_1
XFILLER_9_841 VPWR VGND VPWR VGND sky130_ef_sc_hd__decap_12
X_12529_ _06251_ _06252_ VGND VGND VPWR VPWR _06253_ sky130_fd_sc_hd__nor2_1
XFILLER_145_558 VGND VGND VPWR VPWR sky130_fd_sc_hd__fill_2
XFILLER_68_3 VPWR VGND VPWR VGND sky130_ef_sc_hd__decap_12
XFILLER_126_761 VGND VGND VPWR VPWR sky130_fd_sc_hd__fill_1
XTAP_TAPCELL_ROW_93_1823 VGND VPWR sky130_fd_sc_hd__tapvpwrvgnd_1
XFILLER_99_645 VGND VGND VPWR VPWR sky130_fd_sc_hd__decap_4
XFILLER_98_111 VGND VGND VPWR VPWR sky130_fd_sc_hd__decap_6
Xfanout319 _01108_ VGND VGND VPWR VPWR net319 sky130_fd_sc_hd__clkbuf_4
Xfanout308 net312 VGND VGND VPWR VPWR net308 sky130_fd_sc_hd__buf_2
XFILLER_99_689 VGND VGND VPWR VPWR sky130_fd_sc_hd__decap_3
X_09740_ _03483_ _03492_ _03493_ VGND VGND VPWR VPWR _03495_ sky130_fd_sc_hd__and3_1
XFILLER_98_177 VPWR VGND VPWR VGND sky130_ef_sc_hd__decap_12
X_06952_ u_interface.u_gelu_fp32.u_synth_top.s1_x\[28\] net275 VGND VGND VPWR VPWR
+ _01482_ sky130_fd_sc_hd__xnor2_1
.ends
